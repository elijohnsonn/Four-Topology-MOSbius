* Extracted by KLayout with GF180MCU LVS runset on : 01/09/2026 13:17

.SUBCKT DUT VSS INP_TELESCOPIC INP_FOLDED OUT_TELESCOPIC OUT_FOLDED VDD INP_5T
+ INN_TELESCOPIC INN_FOLDED INN_5T OUT_5T PROG_ENA OUT_CS SCAN_IN CLK IBIAS
+ IN_CS SCAN_OUT
X$1 INP_TELESCOPIC VSS \$6 VDD io_secondary_5p0
X$4 VDD VSS \$16 \$37 \$33 \$35 \$36 OUT_FOLDED \$12 \$29
+ programmable_folded_cascode
X$5 \$40 \$43 VDD VSS \$16 \$39 \$38 OUT_TELESCOPIC \$6 \$24
+ programmable_telescopic_cascode
X$6 \$95 \$96 VSS \$19 \$27 \$94 \$93 OUT_5T VDD \$16 programmable_5tOTA
X$7 \$53 \$44 \$20 \$16 \$72 \$55 VDD VSS OUT_CS programmable_common_source
X$9 CLK \$94 \$72 SCAN_IN SCAN_OUT VDD VSS \$55 \$44 \$53 \$95 \$96 \$93 \$40
+ \$39 \$38 \$43 \$33 \$37 \$36 \$35 scan_chain
X$70 INP_FOLDED VSS \$12 VDD io_secondary_5p0
X$71 INN_FOLDED VSS \$29 VDD io_secondary_5p0
X$72 INN_TELESCOPIC VSS \$24 VDD io_secondary_5p0
X$73 INP_5T VSS \$19 VDD io_secondary_5p0
X$74 IBIAS VSS \$16 VDD io_secondary_5p0
X$75 INN_5T VSS \$27 VDD io_secondary_5p0
X$76 IN_CS VSS \$20 VDD io_secondary_5p0
C$1 VDD VSS 8.932e-11 cap_nmos_03v3_b A=20300P P=4150U
M$54 VSS \$16 \$16 VSS nfet_03v3 L=1U W=27.1U AS=16.531P AD=16.531P PS=55.42U
+ PD=55.42U
M$55 VDD PROG_ENA \$42 VDD pfet_03v3 L=0.28U W=0.84U AS=0.546P AD=0.546P
+ PS=2.98U PD=2.98U
M$56 VSS PROG_ENA \$42 VSS nfet_03v3 L=0.28U W=0.42U AS=0.2646P AD=0.2646P
+ PS=2.1U PD=2.1U
M$57 \$36 PROG_ENA VSS VDD pfet_03v3 L=0.28U W=0.42U AS=0.2822P AD=0.2822P
+ PS=2.18U PD=2.18U
M$58 \$39 PROG_ENA VSS VDD pfet_03v3 L=0.28U W=0.42U AS=0.2822P AD=0.2822P
+ PS=2.18U PD=2.18U
M$59 \$37 PROG_ENA VSS VDD pfet_03v3 L=0.28U W=0.42U AS=0.2822P AD=0.2822P
+ PS=2.18U PD=2.18U
M$60 \$38 PROG_ENA VSS VDD pfet_03v3 L=0.28U W=0.42U AS=0.2822P AD=0.2822P
+ PS=2.18U PD=2.18U
M$61 \$94 PROG_ENA VSS VDD pfet_03v3 L=0.28U W=0.42U AS=0.2822P AD=0.2822P
+ PS=2.18U PD=2.18U
M$62 \$96 PROG_ENA VSS VDD pfet_03v3 L=0.28U W=0.42U AS=0.2822P AD=0.2822P
+ PS=2.18U PD=2.18U
M$63 \$72 PROG_ENA VSS VDD pfet_03v3 L=0.28U W=0.42U AS=0.2822P AD=0.2822P
+ PS=2.18U PD=2.18U
M$64 \$55 PROG_ENA VSS VDD pfet_03v3 L=0.28U W=0.42U AS=0.2822P AD=0.2822P
+ PS=2.18U PD=2.18U
M$65 \$36 \$42 VSS VSS nfet_03v3 L=0.28U W=0.42U AS=0.2646P AD=0.2646P PS=2.1U
+ PD=2.1U
M$66 \$39 \$42 VSS VSS nfet_03v3 L=0.28U W=0.42U AS=0.2646P AD=0.2646P PS=2.1U
+ PD=2.1U
M$67 \$37 \$42 VSS VSS nfet_03v3 L=0.28U W=0.42U AS=0.2646P AD=0.2646P PS=2.1U
+ PD=2.1U
M$68 \$38 \$42 VSS VSS nfet_03v3 L=0.28U W=0.42U AS=0.2646P AD=0.2646P PS=2.1U
+ PD=2.1U
M$69 \$94 \$42 VSS VSS nfet_03v3 L=0.28U W=0.42U AS=0.2646P AD=0.2646P PS=2.1U
+ PD=2.1U
M$70 \$96 \$42 VSS VSS nfet_03v3 L=0.28U W=0.42U AS=0.2646P AD=0.2646P PS=2.1U
+ PD=2.1U
M$71 \$72 \$42 VSS VSS nfet_03v3 L=0.28U W=0.42U AS=0.2646P AD=0.2646P PS=2.1U
+ PD=2.1U
M$72 \$55 \$42 VSS VSS nfet_03v3 L=0.28U W=0.42U AS=0.2646P AD=0.2646P PS=2.1U
+ PD=2.1U
.ENDS DUT

.SUBCKT io_secondary_5p0 ASIG5V VSS to_gate VDD
D$1 VSS to_gate diode_nd2ps_06v0 A=400P P=160U
D$5 to_gate VDD diode_pd2nw_06v0 A=400P P=160U
R$9 to_gate ASIG5V VSS 87.5 ppolyf_u L=10U W=40U
.ENDS io_secondary_5p0

.SUBCKT programmable_folded_cascode VDD VSS VG_BIAS EN1 \!EN1 \!EN0 EN0 OUT INP
+ INN
M$1 \$3 \$4 \$4 VDD pfet_03v3 L=0.5U W=196U AS=127.4P AD=127.4P PS=405U PD=405U
M$11 VDD \$3 \$3 VDD pfet_03v3 L=1U W=115U AS=74.75P AD=74.75P PS=236.5U
+ PD=236.5U
M$12 VDD \$3 \$8 VDD pfet_03v3 L=1U W=115U AS=74.75P AD=74.75P PS=236.5U
+ PD=236.5U
M$21 VDD \$14 \$14 VDD pfet_03v3 L=1U W=115U AS=74.75P AD=74.75P PS=236.5U
+ PD=236.5U
M$26 VSS VG_BIAS \$14 VSS nfet_03v3 L=1U W=27.1U AS=16.531P AD=16.531P
+ PS=55.42U PD=55.42U
M$27 VSS VG_BIAS \$4 VSS nfet_03v3 L=1U W=27.1U AS=16.531P AD=16.531P PS=55.42U
+ PD=55.42U
M$28 VSS \$8 \$8 VSS nfet_03v3 L=1U W=27.1U AS=16.531P AD=16.531P PS=55.42U
+ PD=55.42U
M$29 VSS \!EN0 \$I203 VSS nfet_03v3 L=0.28U W=0.42U AS=0.2646P AD=0.2646P
+ PS=2.1U PD=2.1U
M$30 VSS \!EN1 \$I202 VSS nfet_03v3 L=0.28U W=0.42U AS=0.2646P AD=0.2646P
+ PS=2.1U PD=2.1U
M$31 VSS \$I203 \$27 VSS nfet_03v3 L=1U W=40U AS=24.4P AD=24.4P PS=82.44U
+ PD=82.44U
M$32 VSS \$8 \$27 VSS nfet_03v3 L=1U W=40U AS=24.4P AD=24.4P PS=82.44U PD=82.44U
M$35 \$27 \$I202 VSS VSS nfet_03v3 L=1U W=80U AS=34.8P AD=34.8P PS=123.48U
+ PD=123.48U
M$39 VSS \!EN0 \$I206 VSS nfet_03v3 L=0.28U W=0.42U AS=0.2646P AD=0.2646P
+ PS=2.1U PD=2.1U
M$40 VSS \!EN0 \$I209 VSS nfet_03v3 L=0.28U W=0.42U AS=0.2646P AD=0.2646P
+ PS=2.1U PD=2.1U
M$41 VSS \!EN1 \$I205 VSS nfet_03v3 L=0.28U W=0.42U AS=0.2646P AD=0.2646P
+ PS=2.1U PD=2.1U
M$42 VSS \!EN1 \$I208 VSS nfet_03v3 L=0.28U W=0.42U AS=0.2646P AD=0.2646P
+ PS=2.1U PD=2.1U
M$43 \$19 \$I205 VSS VSS nfet_03v3 L=1U W=41U AS=17.835P AD=17.835P PS=63.24U
+ PD=63.24U
M$45 \$23 \$I208 VSS VSS nfet_03v3 L=1U W=41U AS=17.835P AD=17.835P PS=63.24U
+ PD=63.24U
M$47 VSS \$I206 \$19 VSS nfet_03v3 L=1U W=20.5U AS=12.505P AD=12.505P PS=42.22U
+ PD=42.22U
M$48 VSS \$19 \$19 VSS nfet_03v3 L=1U W=20.5U AS=12.505P AD=12.505P PS=42.22U
+ PD=42.22U
M$49 VSS \$I209 \$23 VSS nfet_03v3 L=1U W=20.5U AS=12.505P AD=12.505P PS=42.22U
+ PD=42.22U
M$50 VSS \$19 \$23 VSS nfet_03v3 L=1U W=20.5U AS=12.505P AD=12.505P PS=42.22U
+ PD=42.22U
M$51 VSS \!EN0 \$I212 VSS nfet_03v3 L=0.28U W=0.42U AS=0.2646P AD=0.2646P
+ PS=2.1U PD=2.1U
M$52 VSS \!EN0 \$I215 VSS nfet_03v3 L=0.28U W=0.42U AS=0.2646P AD=0.2646P
+ PS=2.1U PD=2.1U
M$53 VSS \!EN1 \$I211 VSS nfet_03v3 L=0.28U W=0.42U AS=0.2646P AD=0.2646P
+ PS=2.1U PD=2.1U
M$54 VSS \!EN1 \$I214 VSS nfet_03v3 L=0.28U W=0.42U AS=0.2646P AD=0.2646P
+ PS=2.1U PD=2.1U
M$55 \$25 \$I211 \$19 VSS nfet_03v3 L=0.5U W=21U AS=9.135P AD=9.135P PS=33.24U
+ PD=33.24U
M$57 OUT \$I214 \$23 VSS nfet_03v3 L=0.5U W=21U AS=9.135P AD=9.135P PS=33.24U
+ PD=33.24U
M$59 \$19 \$I212 \$25 VSS nfet_03v3 L=0.5U W=10.5U AS=6.405P AD=6.405P
+ PS=22.22U PD=22.22U
M$60 \$19 \$25 \$25 VSS nfet_03v3 L=0.5U W=10.5U AS=6.405P AD=6.405P PS=22.22U
+ PD=22.22U
M$61 \$23 \$I215 OUT VSS nfet_03v3 L=0.5U W=10.5U AS=6.405P AD=6.405P PS=22.22U
+ PD=22.22U
M$62 \$23 \$25 OUT VSS nfet_03v3 L=0.5U W=10.5U AS=6.405P AD=6.405P PS=22.22U
+ PD=22.22U
M$63 VSS \!EN0 \$I218 VSS nfet_03v3 L=0.28U W=0.42U AS=0.2646P AD=0.2646P
+ PS=2.1U PD=2.1U
M$64 VSS \!EN0 \$I221 VSS nfet_03v3 L=0.28U W=0.42U AS=0.2646P AD=0.2646P
+ PS=2.1U PD=2.1U
M$65 VSS \!EN1 \$I217 VSS nfet_03v3 L=0.28U W=0.42U AS=0.2646P AD=0.2646P
+ PS=2.1U PD=2.1U
M$66 VSS \!EN1 \$I220 VSS nfet_03v3 L=0.28U W=0.42U AS=0.2646P AD=0.2646P
+ PS=2.1U PD=2.1U
M$67 \$32 \$I217 \$27 VSS nfet_03v3 L=0.5U W=120U AS=52.2P AD=52.2P PS=183.48U
+ PD=183.48U
M$71 \$33 \$I220 \$27 VSS nfet_03v3 L=0.5U W=120U AS=52.2P AD=52.2P PS=183.48U
+ PD=183.48U
M$75 \$27 \$I218 \$32 VSS nfet_03v3 L=0.5U W=60U AS=36.6P AD=36.6P PS=122.44U
+ PD=122.44U
M$76 \$27 INP \$32 VSS nfet_03v3 L=0.5U W=60U AS=36.6P AD=36.6P PS=122.44U
+ PD=122.44U
M$79 \$27 \$I221 \$33 VSS nfet_03v3 L=0.5U W=60U AS=36.6P AD=36.6P PS=122.44U
+ PD=122.44U
M$80 \$27 INN \$33 VSS nfet_03v3 L=0.5U W=60U AS=36.6P AD=36.6P PS=122.44U
+ PD=122.44U
M$83 VDD EN0 \$I224 VDD pfet_03v3 L=0.28U W=0.42U AS=0.2822P AD=0.2822P
+ PS=2.18U PD=2.18U
M$84 VDD EN0 \$I228 VDD pfet_03v3 L=0.28U W=0.42U AS=0.2822P AD=0.2822P
+ PS=2.18U PD=2.18U
M$85 VDD EN1 \$I223 VDD pfet_03v3 L=0.28U W=0.42U AS=0.2822P AD=0.2822P
+ PS=2.18U PD=2.18U
M$86 VDD EN1 \$I227 VDD pfet_03v3 L=0.28U W=0.42U AS=0.2822P AD=0.2822P
+ PS=2.18U PD=2.18U
M$87 \$25 \$I223 \$32 VDD pfet_03v3 L=0.5U W=296U AS=134.68P AD=134.68P
+ PS=453.1U PD=453.1U
M$97 OUT \$I227 \$33 VDD pfet_03v3 L=0.5U W=296U AS=134.68P AD=134.68P
+ PS=453.1U PD=453.1U
M$107 \$32 \$4 \$25 VDD pfet_03v3 L=0.5U W=148U AS=96.2P AD=96.2P PS=302.5U
+ PD=302.5U
M$108 \$32 \$I224 \$25 VDD pfet_03v3 L=0.5U W=148U AS=96.2P AD=96.2P PS=302.5U
+ PD=302.5U
M$117 \$33 \$4 OUT VDD pfet_03v3 L=0.5U W=148U AS=96.2P AD=96.2P PS=302.5U
+ PD=302.5U
M$118 \$33 \$I228 OUT VDD pfet_03v3 L=0.5U W=148U AS=96.2P AD=96.2P PS=302.5U
+ PD=302.5U
M$127 VDD EN0 \$I232 VDD pfet_03v3 L=0.28U W=0.42U AS=0.2822P AD=0.2822P
+ PS=2.18U PD=2.18U
M$128 VDD EN0 \$I236 VDD pfet_03v3 L=0.28U W=0.42U AS=0.2822P AD=0.2822P
+ PS=2.18U PD=2.18U
M$129 VDD EN1 \$I231 VDD pfet_03v3 L=0.28U W=0.42U AS=0.2822P AD=0.2822P
+ PS=2.18U PD=2.18U
M$130 VDD EN1 \$I235 VDD pfet_03v3 L=0.28U W=0.42U AS=0.2822P AD=0.2822P
+ PS=2.18U PD=2.18U
M$131 \$33 \$I231 VDD VDD pfet_03v3 L=1U W=696U AS=316.68P AD=316.68P
+ PS=1062.2U PD=1062.2U
M$151 \$32 \$I235 VDD VDD pfet_03v3 L=1U W=696U AS=316.68P AD=316.68P
+ PS=1062.2U PD=1062.2U
M$171 VDD \$14 \$33 VDD pfet_03v3 L=1U W=348U AS=226.2P AD=226.2P PS=709U
+ PD=709U
M$172 VDD \$I232 \$33 VDD pfet_03v3 L=1U W=348U AS=226.2P AD=226.2P PS=709U
+ PD=709U
M$191 VDD \$14 \$32 VDD pfet_03v3 L=1U W=348U AS=226.2P AD=226.2P PS=709U
+ PD=709U
M$192 VDD \$I236 \$32 VDD pfet_03v3 L=1U W=348U AS=226.2P AD=226.2P PS=709U
+ PD=709U
M$211 \$I202 \!EN1 \$8 VDD pfet_03v3 L=0.28U W=0.42U AS=0.2822P AD=0.2822P
+ PS=2.18U PD=2.18U
M$212 \$I203 \!EN0 \$8 VDD pfet_03v3 L=0.28U W=0.42U AS=0.2822P AD=0.2822P
+ PS=2.18U PD=2.18U
M$213 \$I202 EN1 \$8 VSS nfet_03v3 L=0.28U W=0.42U AS=0.2646P AD=0.2646P
+ PS=2.1U PD=2.1U
M$214 \$I203 EN0 \$8 VSS nfet_03v3 L=0.28U W=0.42U AS=0.2646P AD=0.2646P
+ PS=2.1U PD=2.1U
M$215 \$I205 \!EN1 \$19 VDD pfet_03v3 L=0.28U W=0.42U AS=0.2822P AD=0.2822P
+ PS=2.18U PD=2.18U
M$216 \$I206 \!EN0 \$19 VDD pfet_03v3 L=0.28U W=0.42U AS=0.2822P AD=0.2822P
+ PS=2.18U PD=2.18U
M$217 \$I208 \!EN1 \$19 VDD pfet_03v3 L=0.28U W=0.42U AS=0.2822P AD=0.2822P
+ PS=2.18U PD=2.18U
M$218 \$I209 \!EN0 \$19 VDD pfet_03v3 L=0.28U W=0.42U AS=0.2822P AD=0.2822P
+ PS=2.18U PD=2.18U
M$219 \$I205 EN1 \$19 VSS nfet_03v3 L=0.28U W=0.42U AS=0.2646P AD=0.2646P
+ PS=2.1U PD=2.1U
M$220 \$I206 EN0 \$19 VSS nfet_03v3 L=0.28U W=0.42U AS=0.2646P AD=0.2646P
+ PS=2.1U PD=2.1U
M$221 \$I208 EN1 \$19 VSS nfet_03v3 L=0.28U W=0.42U AS=0.2646P AD=0.2646P
+ PS=2.1U PD=2.1U
M$222 \$I209 EN0 \$19 VSS nfet_03v3 L=0.28U W=0.42U AS=0.2646P AD=0.2646P
+ PS=2.1U PD=2.1U
M$223 \$I211 \!EN1 \$25 VDD pfet_03v3 L=0.28U W=0.42U AS=0.2822P AD=0.2822P
+ PS=2.18U PD=2.18U
M$224 \$I212 \!EN0 \$25 VDD pfet_03v3 L=0.28U W=0.42U AS=0.2822P AD=0.2822P
+ PS=2.18U PD=2.18U
M$225 \$I214 \!EN1 \$25 VDD pfet_03v3 L=0.28U W=0.42U AS=0.2822P AD=0.2822P
+ PS=2.18U PD=2.18U
M$226 \$I215 \!EN0 \$25 VDD pfet_03v3 L=0.28U W=0.42U AS=0.2822P AD=0.2822P
+ PS=2.18U PD=2.18U
M$227 \$I211 EN1 \$25 VSS nfet_03v3 L=0.28U W=0.42U AS=0.2646P AD=0.2646P
+ PS=2.1U PD=2.1U
M$228 \$I212 EN0 \$25 VSS nfet_03v3 L=0.28U W=0.42U AS=0.2646P AD=0.2646P
+ PS=2.1U PD=2.1U
M$229 \$I214 EN1 \$25 VSS nfet_03v3 L=0.28U W=0.42U AS=0.2646P AD=0.2646P
+ PS=2.1U PD=2.1U
M$230 \$I215 EN0 \$25 VSS nfet_03v3 L=0.28U W=0.42U AS=0.2646P AD=0.2646P
+ PS=2.1U PD=2.1U
M$231 \$I217 \!EN1 INP VDD pfet_03v3 L=0.28U W=0.42U AS=0.2822P AD=0.2822P
+ PS=2.18U PD=2.18U
M$232 \$I218 \!EN0 INP VDD pfet_03v3 L=0.28U W=0.42U AS=0.2822P AD=0.2822P
+ PS=2.18U PD=2.18U
M$233 \$I220 \!EN1 INN VDD pfet_03v3 L=0.28U W=0.42U AS=0.2822P AD=0.2822P
+ PS=2.18U PD=2.18U
M$234 \$I221 \!EN0 INN VDD pfet_03v3 L=0.28U W=0.42U AS=0.2822P AD=0.2822P
+ PS=2.18U PD=2.18U
M$235 \$I217 EN1 INP VSS nfet_03v3 L=0.28U W=0.42U AS=0.2646P AD=0.2646P
+ PS=2.1U PD=2.1U
M$236 \$I218 EN0 INP VSS nfet_03v3 L=0.28U W=0.42U AS=0.2646P AD=0.2646P
+ PS=2.1U PD=2.1U
M$237 \$I220 EN1 INN VSS nfet_03v3 L=0.28U W=0.42U AS=0.2646P AD=0.2646P
+ PS=2.1U PD=2.1U
M$238 \$I221 EN0 INN VSS nfet_03v3 L=0.28U W=0.42U AS=0.2646P AD=0.2646P
+ PS=2.1U PD=2.1U
M$239 \$I223 \!EN1 \$4 VDD pfet_03v3 L=0.28U W=0.42U AS=0.2822P AD=0.2822P
+ PS=2.18U PD=2.18U
M$240 \$I224 \!EN0 \$4 VDD pfet_03v3 L=0.28U W=0.42U AS=0.2822P AD=0.2822P
+ PS=2.18U PD=2.18U
M$241 \$I227 \!EN1 \$4 VDD pfet_03v3 L=0.28U W=0.42U AS=0.2822P AD=0.2822P
+ PS=2.18U PD=2.18U
M$242 \$I228 \!EN0 \$4 VDD pfet_03v3 L=0.28U W=0.42U AS=0.2822P AD=0.2822P
+ PS=2.18U PD=2.18U
M$243 \$I223 EN1 \$4 VSS nfet_03v3 L=0.28U W=0.42U AS=0.2646P AD=0.2646P
+ PS=2.1U PD=2.1U
M$244 \$I224 EN0 \$4 VSS nfet_03v3 L=0.28U W=0.42U AS=0.2646P AD=0.2646P
+ PS=2.1U PD=2.1U
M$245 \$I227 EN1 \$4 VSS nfet_03v3 L=0.28U W=0.42U AS=0.2646P AD=0.2646P
+ PS=2.1U PD=2.1U
M$246 \$I228 EN0 \$4 VSS nfet_03v3 L=0.28U W=0.42U AS=0.2646P AD=0.2646P
+ PS=2.1U PD=2.1U
M$247 \$I231 \!EN1 \$14 VDD pfet_03v3 L=0.28U W=0.42U AS=0.2822P AD=0.2822P
+ PS=2.18U PD=2.18U
M$248 \$I232 \!EN0 \$14 VDD pfet_03v3 L=0.28U W=0.42U AS=0.2822P AD=0.2822P
+ PS=2.18U PD=2.18U
M$249 \$I235 \!EN1 \$14 VDD pfet_03v3 L=0.28U W=0.42U AS=0.2822P AD=0.2822P
+ PS=2.18U PD=2.18U
M$250 \$I236 \!EN0 \$14 VDD pfet_03v3 L=0.28U W=0.42U AS=0.2822P AD=0.2822P
+ PS=2.18U PD=2.18U
M$251 \$I231 EN1 \$14 VSS nfet_03v3 L=0.28U W=0.42U AS=0.2646P AD=0.2646P
+ PS=2.1U PD=2.1U
M$252 \$I232 EN0 \$14 VSS nfet_03v3 L=0.28U W=0.42U AS=0.2646P AD=0.2646P
+ PS=2.1U PD=2.1U
M$253 \$I235 EN1 \$14 VSS nfet_03v3 L=0.28U W=0.42U AS=0.2646P AD=0.2646P
+ PS=2.1U PD=2.1U
M$254 \$I236 EN0 \$14 VSS nfet_03v3 L=0.28U W=0.42U AS=0.2646P AD=0.2646P
+ PS=2.1U PD=2.1U
.ENDS programmable_folded_cascode

.SUBCKT programmable_telescopic_cascode \!EN1 \!EN0 VDD VSS VG_BIAS EN1 EN0
+ output INP INN
M$1 VSS VG_BIAS \$25 VSS nfet_03v3 L=0.5U W=30U AS=18.3P AD=18.3P PS=61.22U
+ PD=61.22U
M$2 VSS \$28 \$28 VSS nfet_03v3 L=0.5U W=1.5U AS=0.915P AD=0.915P PS=4.22U
+ PD=4.22U
M$3 VDD \$25 \$25 VDD pfet_03v3 L=0.5U W=70U AS=45.5P AD=45.5P PS=141.3U
+ PD=141.3U
M$4 VDD \$25 \$28 VDD pfet_03v3 L=0.5U W=70U AS=45.5P AD=45.5P PS=141.3U
+ PD=141.3U
M$5 VSS \!EN0 \$I52 VSS nfet_03v3 L=0.28U W=0.42U AS=0.2646P AD=0.2646P PS=2.1U
+ PD=2.1U
M$6 VSS \!EN1 \$I53 VSS nfet_03v3 L=0.28U W=0.42U AS=0.2646P AD=0.2646P PS=2.1U
+ PD=2.1U
M$7 \$12 \$I53 VSS VSS nfet_03v3 L=1U W=108.4U AS=47.154P AD=47.154P PS=166.08U
+ PD=166.08U
M$11 VSS VG_BIAS \$12 VSS nfet_03v3 L=1U W=54.2U AS=33.062P AD=33.062P
+ PS=110.84U PD=110.84U
M$13 VSS \$I52 \$12 VSS nfet_03v3 L=1U W=54.2U AS=33.062P AD=33.062P PS=110.84U
+ PD=110.84U
M$15 VSS \!EN0 \$I55 VSS nfet_03v3 L=0.28U W=0.42U AS=0.2646P AD=0.2646P
+ PS=2.1U PD=2.1U
M$16 VSS \!EN1 \$I56 VSS nfet_03v3 L=0.28U W=0.42U AS=0.2646P AD=0.2646P
+ PS=2.1U PD=2.1U
M$17 VSS \!EN0 \$I58 VSS nfet_03v3 L=0.28U W=0.42U AS=0.2646P AD=0.2646P
+ PS=2.1U PD=2.1U
M$18 VSS \!EN1 \$I59 VSS nfet_03v3 L=0.28U W=0.42U AS=0.2646P AD=0.2646P
+ PS=2.1U PD=2.1U
M$19 \$14 \$I56 \$12 VSS nfet_03v3 L=0.5U W=60U AS=26.1P AD=26.1P PS=91.74U
+ PD=91.74U
M$21 \$13 \$I59 \$12 VSS nfet_03v3 L=0.5U W=60U AS=26.1P AD=26.1P PS=91.74U
+ PD=91.74U
M$23 \$12 INN \$14 VSS nfet_03v3 L=0.5U W=30U AS=18.3P AD=18.3P PS=61.22U
+ PD=61.22U
M$24 \$12 \$I55 \$14 VSS nfet_03v3 L=0.5U W=30U AS=18.3P AD=18.3P PS=61.22U
+ PD=61.22U
M$25 \$12 INP \$13 VSS nfet_03v3 L=0.5U W=30U AS=18.3P AD=18.3P PS=61.22U
+ PD=61.22U
M$26 \$12 \$I58 \$13 VSS nfet_03v3 L=0.5U W=30U AS=18.3P AD=18.3P PS=61.22U
+ PD=61.22U
M$27 VSS \!EN0 \$I61 VSS nfet_03v3 L=0.28U W=0.42U AS=0.2646P AD=0.2646P
+ PS=2.1U PD=2.1U
M$28 VSS \!EN1 \$I62 VSS nfet_03v3 L=0.28U W=0.42U AS=0.2646P AD=0.2646P
+ PS=2.1U PD=2.1U
M$29 VSS \!EN0 \$I64 VSS nfet_03v3 L=0.28U W=0.42U AS=0.2646P AD=0.2646P
+ PS=2.1U PD=2.1U
M$30 VSS \!EN1 \$I65 VSS nfet_03v3 L=0.28U W=0.42U AS=0.2646P AD=0.2646P
+ PS=2.1U PD=2.1U
M$31 \$14 \$25 output VSS nfet_03v3 L=0.4U W=270U AS=164.7P AD=164.7P
+ PS=547.32U PD=547.32U
M$37 \$14 \$I61 output VSS nfet_03v3 L=0.4U W=270U AS=164.7P AD=164.7P
+ PS=547.32U PD=547.32U
M$43 \$13 \$25 \$15 VSS nfet_03v3 L=0.4U W=270U AS=164.7P AD=164.7P PS=547.32U
+ PD=547.32U
M$49 \$13 \$I64 \$15 VSS nfet_03v3 L=0.4U W=270U AS=164.7P AD=164.7P PS=547.32U
+ PD=547.32U
M$55 output \$I62 \$14 VSS nfet_03v3 L=0.4U W=540U AS=234.9P AD=234.9P
+ PS=820.44U PD=820.44U
M$67 \$15 \$I65 \$13 VSS nfet_03v3 L=0.4U W=540U AS=234.9P AD=234.9P PS=820.44U
+ PD=820.44U
M$79 VDD EN0 \$I67 VDD pfet_03v3 L=0.28U W=0.42U AS=0.2822P AD=0.2822P PS=2.18U
+ PD=2.18U
M$80 VDD EN1 \$I68 VDD pfet_03v3 L=0.28U W=0.42U AS=0.2822P AD=0.2822P PS=2.18U
+ PD=2.18U
M$81 VDD EN0 \$I70 VDD pfet_03v3 L=0.28U W=0.42U AS=0.2822P AD=0.2822P PS=2.18U
+ PD=2.18U
M$82 VDD EN1 \$I71 VDD pfet_03v3 L=0.28U W=0.42U AS=0.2822P AD=0.2822P PS=2.18U
+ PD=2.18U
M$83 \$21 \$I68 VDD VDD pfet_03v3 L=0.5U W=480U AS=218.4P AD=218.4P PS=730.92U
+ PD=730.92U
M$95 \$20 \$I71 VDD VDD pfet_03v3 L=0.5U W=480U AS=218.4P AD=218.4P PS=730.92U
+ PD=730.92U
M$107 VDD \$I67 \$21 VDD pfet_03v3 L=0.5U W=240U AS=156P AD=156P PS=487.8U
+ PD=487.8U
M$112 VDD \$15 \$21 VDD pfet_03v3 L=0.5U W=240U AS=156P AD=156P PS=487.8U
+ PD=487.8U
M$119 VDD \$I70 \$20 VDD pfet_03v3 L=0.5U W=240U AS=156P AD=156P PS=487.8U
+ PD=487.8U
M$124 VDD \$15 \$20 VDD pfet_03v3 L=0.5U W=240U AS=156P AD=156P PS=487.8U
+ PD=487.8U
M$131 VDD EN0 \$I73 VDD pfet_03v3 L=0.28U W=0.42U AS=0.2822P AD=0.2822P
+ PS=2.18U PD=2.18U
M$132 VDD EN1 \$I74 VDD pfet_03v3 L=0.28U W=0.42U AS=0.2822P AD=0.2822P
+ PS=2.18U PD=2.18U
M$133 VDD EN0 \$I76 VDD pfet_03v3 L=0.28U W=0.42U AS=0.2822P AD=0.2822P
+ PS=2.18U PD=2.18U
M$134 VDD EN1 \$I77 VDD pfet_03v3 L=0.28U W=0.42U AS=0.2822P AD=0.2822P
+ PS=2.18U PD=2.18U
M$135 output \$I74 \$21 VDD pfet_03v3 L=0.5U W=470U AS=213.85P AD=213.85P
+ PS=714.1U PD=714.1U
M$145 \$15 \$I77 \$20 VDD pfet_03v3 L=0.5U W=470U AS=213.85P AD=213.85P
+ PS=714.1U PD=714.1U
M$155 \$21 \$28 output VDD pfet_03v3 L=0.5U W=235U AS=152.75P AD=152.75P
+ PS=476.5U PD=476.5U
M$160 \$21 \$I73 output VDD pfet_03v3 L=0.5U W=235U AS=152.75P AD=152.75P
+ PS=476.5U PD=476.5U
M$165 \$20 \$28 \$15 VDD pfet_03v3 L=0.5U W=235U AS=152.75P AD=152.75P
+ PS=476.5U PD=476.5U
M$170 \$20 \$I76 \$15 VDD pfet_03v3 L=0.5U W=235U AS=152.75P AD=152.75P
+ PS=476.5U PD=476.5U
M$175 \$I52 \!EN0 VG_BIAS VDD pfet_03v3 L=0.28U W=0.42U AS=0.2822P AD=0.2822P
+ PS=2.18U PD=2.18U
M$176 \$I53 \!EN1 VG_BIAS VDD pfet_03v3 L=0.28U W=0.42U AS=0.2822P AD=0.2822P
+ PS=2.18U PD=2.18U
M$177 \$I52 EN0 VG_BIAS VSS nfet_03v3 L=0.28U W=0.42U AS=0.2646P AD=0.2646P
+ PS=2.1U PD=2.1U
M$178 \$I53 EN1 VG_BIAS VSS nfet_03v3 L=0.28U W=0.42U AS=0.2646P AD=0.2646P
+ PS=2.1U PD=2.1U
M$179 \$I55 \!EN0 INN VDD pfet_03v3 L=0.28U W=0.42U AS=0.2822P AD=0.2822P
+ PS=2.18U PD=2.18U
M$180 \$I56 \!EN1 INN VDD pfet_03v3 L=0.28U W=0.42U AS=0.2822P AD=0.2822P
+ PS=2.18U PD=2.18U
M$181 \$I58 \!EN0 INP VDD pfet_03v3 L=0.28U W=0.42U AS=0.2822P AD=0.2822P
+ PS=2.18U PD=2.18U
M$182 \$I59 \!EN1 INP VDD pfet_03v3 L=0.28U W=0.42U AS=0.2822P AD=0.2822P
+ PS=2.18U PD=2.18U
M$183 \$I55 EN0 INN VSS nfet_03v3 L=0.28U W=0.42U AS=0.2646P AD=0.2646P PS=2.1U
+ PD=2.1U
M$184 \$I56 EN1 INN VSS nfet_03v3 L=0.28U W=0.42U AS=0.2646P AD=0.2646P PS=2.1U
+ PD=2.1U
M$185 \$I58 EN0 INP VSS nfet_03v3 L=0.28U W=0.42U AS=0.2646P AD=0.2646P PS=2.1U
+ PD=2.1U
M$186 \$I59 EN1 INP VSS nfet_03v3 L=0.28U W=0.42U AS=0.2646P AD=0.2646P PS=2.1U
+ PD=2.1U
M$187 \$I61 \!EN0 \$25 VDD pfet_03v3 L=0.28U W=0.42U AS=0.2822P AD=0.2822P
+ PS=2.18U PD=2.18U
M$188 \$I62 \!EN1 \$25 VDD pfet_03v3 L=0.28U W=0.42U AS=0.2822P AD=0.2822P
+ PS=2.18U PD=2.18U
M$189 \$I64 \!EN0 \$25 VDD pfet_03v3 L=0.28U W=0.42U AS=0.2822P AD=0.2822P
+ PS=2.18U PD=2.18U
M$190 \$I65 \!EN1 \$25 VDD pfet_03v3 L=0.28U W=0.42U AS=0.2822P AD=0.2822P
+ PS=2.18U PD=2.18U
M$191 \$I61 EN0 \$25 VSS nfet_03v3 L=0.28U W=0.42U AS=0.2646P AD=0.2646P
+ PS=2.1U PD=2.1U
M$192 \$I62 EN1 \$25 VSS nfet_03v3 L=0.28U W=0.42U AS=0.2646P AD=0.2646P
+ PS=2.1U PD=2.1U
M$193 \$I64 EN0 \$25 VSS nfet_03v3 L=0.28U W=0.42U AS=0.2646P AD=0.2646P
+ PS=2.1U PD=2.1U
M$194 \$I65 EN1 \$25 VSS nfet_03v3 L=0.28U W=0.42U AS=0.2646P AD=0.2646P
+ PS=2.1U PD=2.1U
M$195 \$I67 \!EN0 \$15 VDD pfet_03v3 L=0.28U W=0.42U AS=0.2822P AD=0.2822P
+ PS=2.18U PD=2.18U
M$196 \$I68 \!EN1 \$15 VDD pfet_03v3 L=0.28U W=0.42U AS=0.2822P AD=0.2822P
+ PS=2.18U PD=2.18U
M$197 \$I70 \!EN0 \$15 VDD pfet_03v3 L=0.28U W=0.42U AS=0.2822P AD=0.2822P
+ PS=2.18U PD=2.18U
M$198 \$I71 \!EN1 \$15 VDD pfet_03v3 L=0.28U W=0.42U AS=0.2822P AD=0.2822P
+ PS=2.18U PD=2.18U
M$199 \$I67 EN0 \$15 VSS nfet_03v3 L=0.28U W=0.42U AS=0.2646P AD=0.2646P
+ PS=2.1U PD=2.1U
M$200 \$I68 EN1 \$15 VSS nfet_03v3 L=0.28U W=0.42U AS=0.2646P AD=0.2646P
+ PS=2.1U PD=2.1U
M$201 \$I70 EN0 \$15 VSS nfet_03v3 L=0.28U W=0.42U AS=0.2646P AD=0.2646P
+ PS=2.1U PD=2.1U
M$202 \$I71 EN1 \$15 VSS nfet_03v3 L=0.28U W=0.42U AS=0.2646P AD=0.2646P
+ PS=2.1U PD=2.1U
M$203 \$I73 \!EN0 \$28 VDD pfet_03v3 L=0.28U W=0.42U AS=0.2822P AD=0.2822P
+ PS=2.18U PD=2.18U
M$204 \$I74 \!EN1 \$28 VDD pfet_03v3 L=0.28U W=0.42U AS=0.2822P AD=0.2822P
+ PS=2.18U PD=2.18U
M$205 \$I76 \!EN0 \$28 VDD pfet_03v3 L=0.28U W=0.42U AS=0.2822P AD=0.2822P
+ PS=2.18U PD=2.18U
M$206 \$I77 \!EN1 \$28 VDD pfet_03v3 L=0.28U W=0.42U AS=0.2822P AD=0.2822P
+ PS=2.18U PD=2.18U
M$207 \$I73 EN0 \$28 VSS nfet_03v3 L=0.28U W=0.42U AS=0.2646P AD=0.2646P
+ PS=2.1U PD=2.1U
M$208 \$I74 EN1 \$28 VSS nfet_03v3 L=0.28U W=0.42U AS=0.2646P AD=0.2646P
+ PS=2.1U PD=2.1U
M$209 \$I76 EN0 \$28 VSS nfet_03v3 L=0.28U W=0.42U AS=0.2646P AD=0.2646P
+ PS=2.1U PD=2.1U
M$210 \$I77 EN1 \$28 VSS nfet_03v3 L=0.28U W=0.42U AS=0.2646P AD=0.2646P
+ PS=2.1U PD=2.1U
.ENDS programmable_telescopic_cascode

.SUBCKT programmable_5tOTA ena_bar<1> ena<1> VSS vin+ vin\x2d ena<0> ena_bar<0>
+ VOUT VDD V_bias
M$1 VSS ena_bar<1> \$I21 VSS nfet_03v3 L=0.28U W=0.42U AS=0.2646P AD=0.2646P
+ PS=2.1U PD=2.1U
M$2 VSS ena_bar<0> \$I22 VSS nfet_03v3 L=0.28U W=0.42U AS=0.2646P AD=0.2646P
+ PS=2.1U PD=2.1U
M$3 \$1 \$I21 VSS VSS nfet_03v3 L=1U W=136.8U AS=59.508P AD=59.508P PS=210.42U
+ PD=210.42U
M$7 VSS V_bias \$1 VSS nfet_03v3 L=1U W=68.4U AS=41.724P AD=41.724P PS=140.46U
+ PD=140.46U
M$8 VSS \$I22 \$1 VSS nfet_03v3 L=1U W=68.4U AS=41.724P AD=41.724P PS=140.46U
+ PD=140.46U
M$15 VSS ena_bar<0> \$I26 VSS nfet_03v3 L=0.28U W=0.42U AS=0.2646P AD=0.2646P
+ PS=2.1U PD=2.1U
M$16 VSS ena_bar<0> \$I30 VSS nfet_03v3 L=0.28U W=0.42U AS=0.2646P AD=0.2646P
+ PS=2.1U PD=2.1U
M$17 VSS ena_bar<1> \$I24 VSS nfet_03v3 L=0.28U W=0.42U AS=0.2646P AD=0.2646P
+ PS=2.1U PD=2.1U
M$18 VSS ena_bar<1> \$I28 VSS nfet_03v3 L=0.28U W=0.42U AS=0.2646P AD=0.2646P
+ PS=2.1U PD=2.1U
M$19 \$1 vin+ \$8 VSS nfet_03v3 L=0.5U W=34.2U AS=20.862P AD=20.862P PS=72.06U
+ PD=72.06U
M$21 \$1 \$I26 \$8 VSS nfet_03v3 L=0.5U W=34.2U AS=20.862P AD=20.862P PS=72.06U
+ PD=72.06U
M$25 \$1 vin\x2d VOUT VSS nfet_03v3 L=0.5U W=34.2U AS=20.862P AD=20.862P
+ PS=72.06U PD=72.06U
M$27 \$1 \$I30 VOUT VSS nfet_03v3 L=0.5U W=34.2U AS=20.862P AD=20.862P
+ PS=72.06U PD=72.06U
M$31 \$8 \$I24 \$1 VSS nfet_03v3 L=0.5U W=68.4U AS=29.754P AD=29.754P
+ PS=107.82U PD=107.82U
M$37 VOUT \$I28 \$1 VSS nfet_03v3 L=0.5U W=68.4U AS=29.754P AD=29.754P
+ PS=107.82U PD=107.82U
M$43 VDD ena<0> \$I33 VDD pfet_03v3 L=0.28U W=0.42U AS=0.2822P AD=0.2822P
+ PS=2.18U PD=2.18U
M$44 VDD ena<0> \$I37 VDD pfet_03v3 L=0.28U W=0.42U AS=0.2822P AD=0.2822P
+ PS=2.18U PD=2.18U
M$45 VDD ena<1> \$I32 VDD pfet_03v3 L=0.28U W=0.42U AS=0.2822P AD=0.2822P
+ PS=2.18U PD=2.18U
M$46 VDD ena<1> \$I36 VDD pfet_03v3 L=0.28U W=0.42U AS=0.2822P AD=0.2822P
+ PS=2.18U PD=2.18U
M$47 VOUT \$I32 VDD VDD pfet_03v3 L=0.5U W=200U AS=91P AD=91P PS=303.64U
+ PD=303.64U
M$51 \$8 \$I36 VDD VDD pfet_03v3 L=0.5U W=200U AS=91P AD=91P PS=303.64U
+ PD=303.64U
M$55 VDD \$8 VOUT VDD pfet_03v3 L=0.5U W=100U AS=65P AD=65P PS=202.6U PD=202.6U
M$56 VDD \$I33 VOUT VDD pfet_03v3 L=0.5U W=100U AS=65P AD=65P PS=202.6U
+ PD=202.6U
M$59 VDD \$8 \$8 VDD pfet_03v3 L=0.5U W=100U AS=65P AD=65P PS=202.6U PD=202.6U
M$60 VDD \$I37 \$8 VDD pfet_03v3 L=0.5U W=100U AS=65P AD=65P PS=202.6U PD=202.6U
M$63 \$I21 ena_bar<1> V_bias VDD pfet_03v3 L=0.28U W=0.42U AS=0.2822P
+ AD=0.2822P PS=2.18U PD=2.18U
M$64 \$I22 ena_bar<0> V_bias VDD pfet_03v3 L=0.28U W=0.42U AS=0.2822P
+ AD=0.2822P PS=2.18U PD=2.18U
M$65 \$I21 ena<1> V_bias VSS nfet_03v3 L=0.28U W=0.42U AS=0.2646P AD=0.2646P
+ PS=2.1U PD=2.1U
M$66 \$I22 ena<0> V_bias VSS nfet_03v3 L=0.28U W=0.42U AS=0.2646P AD=0.2646P
+ PS=2.1U PD=2.1U
M$67 \$I24 ena_bar<1> vin+ VDD pfet_03v3 L=0.28U W=0.42U AS=0.2822P AD=0.2822P
+ PS=2.18U PD=2.18U
M$68 \$I26 ena_bar<0> vin+ VDD pfet_03v3 L=0.28U W=0.42U AS=0.2822P AD=0.2822P
+ PS=2.18U PD=2.18U
M$69 \$I28 ena_bar<1> vin\x2d VDD pfet_03v3 L=0.28U W=0.42U AS=0.2822P
+ AD=0.2822P PS=2.18U PD=2.18U
M$70 \$I30 ena_bar<0> vin\x2d VDD pfet_03v3 L=0.28U W=0.42U AS=0.2822P
+ AD=0.2822P PS=2.18U PD=2.18U
M$71 \$I24 ena<1> vin+ VSS nfet_03v3 L=0.28U W=0.42U AS=0.2646P AD=0.2646P
+ PS=2.1U PD=2.1U
M$72 \$I26 ena<0> vin+ VSS nfet_03v3 L=0.28U W=0.42U AS=0.2646P AD=0.2646P
+ PS=2.1U PD=2.1U
M$73 \$I28 ena<1> vin\x2d VSS nfet_03v3 L=0.28U W=0.42U AS=0.2646P AD=0.2646P
+ PS=2.1U PD=2.1U
M$74 \$I30 ena<0> vin\x2d VSS nfet_03v3 L=0.28U W=0.42U AS=0.2646P AD=0.2646P
+ PS=2.1U PD=2.1U
M$75 \$I32 ena_bar<1> \$8 VDD pfet_03v3 L=0.28U W=0.42U AS=0.2822P AD=0.2822P
+ PS=2.18U PD=2.18U
M$76 \$I33 ena_bar<0> \$8 VDD pfet_03v3 L=0.28U W=0.42U AS=0.2822P AD=0.2822P
+ PS=2.18U PD=2.18U
M$77 \$I36 ena_bar<1> \$8 VDD pfet_03v3 L=0.28U W=0.42U AS=0.2822P AD=0.2822P
+ PS=2.18U PD=2.18U
M$78 \$I37 ena_bar<0> \$8 VDD pfet_03v3 L=0.28U W=0.42U AS=0.2822P AD=0.2822P
+ PS=2.18U PD=2.18U
M$79 \$I32 ena<1> \$8 VSS nfet_03v3 L=0.28U W=0.42U AS=0.2646P AD=0.2646P
+ PS=2.1U PD=2.1U
M$80 \$I33 ena<0> \$8 VSS nfet_03v3 L=0.28U W=0.42U AS=0.2646P AD=0.2646P
+ PS=2.1U PD=2.1U
M$81 \$I36 ena<1> \$8 VSS nfet_03v3 L=0.28U W=0.42U AS=0.2646P AD=0.2646P
+ PS=2.1U PD=2.1U
M$82 \$I37 ena<0> \$8 VSS nfet_03v3 L=0.28U W=0.42U AS=0.2646P AD=0.2646P
+ PS=2.1U PD=2.1U
.ENDS programmable_5tOTA

.SUBCKT scan_chain CLK EN_0_5T EN_0_CS scan_in scan_out VDD VSS EN_1_CS
+ \!EN_1_CS \!EN_0_CS \!EN_1_5T EN_1_5T \!EN_0_5T \!EN_1_TELESCOPIC
+ EN_1_TELESCOPIC EN_0_TELESCOPIC \!EN_0_TELESCOPIC \!EN_1_FOLDED EN_1_FOLDED
+ EN_0_FOLDED \!EN_0_FOLDED
X$1 CLK VDD VSS EN_0_TELESCOPIC EN_1_TELESCOPIC \!EN_1_TELESCOPIC D_ff1
X$2 CLK VDD VSS EN_1_CS scan_out \$I56 D_ff1
X$3 CLK VDD VSS EN_1_TELESCOPIC EN_0_5T \!EN_0_5T D_ff1
X$4 CLK VDD VSS EN_0_5T EN_1_5T \!EN_1_5T D_ff1
X$5 CLK VDD VSS EN_1_5T EN_0_CS \!EN_0_CS D_ff1
X$6 CLK VDD VSS EN_0_CS EN_1_CS \!EN_1_CS D_ff1
X$7 CLK VDD VSS scan_in EN_0_FOLDED \!EN_0_FOLDED D_ff1
X$8 CLK VDD VSS EN_0_FOLDED EN_1_FOLDED \!EN_1_FOLDED D_ff1
X$9 CLK VDD VSS EN_1_FOLDED EN_0_TELESCOPIC \!EN_0_TELESCOPIC D_ff1
.ENDS scan_chain

.SUBCKT programmable_common_source \!EN0 \!EN1 IN VG_BIAS EN0 EN1 VDD VSS OUT
M$1 VSS \!EN0 \$I2 VSS nfet_03v3 L=0.28U W=0.42U AS=0.2646P AD=0.2646P PS=2.1U
+ PD=2.1U
M$2 VSS \!EN1 \$I1 VSS nfet_03v3 L=0.28U W=0.42U AS=0.2646P AD=0.2646P PS=2.1U
+ PD=2.1U
M$3 OUT \$I1 VSS VSS nfet_03v3 L=1U W=54.2U AS=23.577P AD=23.577P PS=83.04U
+ PD=83.04U
M$5 VSS \$I2 OUT VSS nfet_03v3 L=1U W=27.1U AS=16.531P AD=16.531P PS=55.42U
+ PD=55.42U
M$6 VSS VG_BIAS OUT VSS nfet_03v3 L=1U W=27.1U AS=16.531P AD=16.531P PS=55.42U
+ PD=55.42U
M$7 VDD EN0 \$I4 VDD pfet_03v3 L=0.28U W=0.42U AS=0.2822P AD=0.2822P PS=2.18U
+ PD=2.18U
M$8 VDD EN1 \$I5 VDD pfet_03v3 L=0.28U W=0.42U AS=0.2822P AD=0.2822P PS=2.18U
+ PD=2.18U
M$9 OUT \$I5 VDD VDD pfet_03v3 L=1U W=184U AS=83.72P AD=83.72P PS=294.2U
+ PD=294.2U
M$29 VDD IN OUT VDD pfet_03v3 L=1U W=92U AS=59.8P AD=59.8P PS=197U PD=197U
M$32 VDD \$I4 OUT VDD pfet_03v3 L=1U W=92U AS=59.8P AD=59.8P PS=197U PD=197U
M$49 \$I1 \!EN1 VG_BIAS VDD pfet_03v3 L=0.28U W=0.42U AS=0.2822P AD=0.2822P
+ PS=2.18U PD=2.18U
M$50 \$I2 \!EN0 VG_BIAS VDD pfet_03v3 L=0.28U W=0.42U AS=0.2822P AD=0.2822P
+ PS=2.18U PD=2.18U
M$51 \$I1 EN1 VG_BIAS VSS nfet_03v3 L=0.28U W=0.42U AS=0.2646P AD=0.2646P
+ PS=2.1U PD=2.1U
M$52 \$I2 EN0 VG_BIAS VSS nfet_03v3 L=0.28U W=0.42U AS=0.2646P AD=0.2646P
+ PS=2.1U PD=2.1U
M$53 \$I4 \!EN0 IN VDD pfet_03v3 L=0.28U W=0.42U AS=0.2822P AD=0.2822P PS=2.18U
+ PD=2.18U
M$54 \$I5 \!EN1 IN VDD pfet_03v3 L=0.28U W=0.42U AS=0.2822P AD=0.2822P PS=2.18U
+ PD=2.18U
M$55 \$I4 EN0 IN VSS nfet_03v3 L=0.28U W=0.42U AS=0.2646P AD=0.2646P PS=2.1U
+ PD=2.1U
M$56 \$I5 EN1 IN VSS nfet_03v3 L=0.28U W=0.42U AS=0.2646P AD=0.2646P PS=2.1U
+ PD=2.1U
.ENDS programmable_common_source

.SUBCKT D_ff1 CLK VDD VSS D Q Q_bar
M$1 VDD CLK \$3 VDD pfet_03v3 L=0.28U W=0.84U AS=0.546P AD=0.546P PS=2.98U
+ PD=2.98U
M$2 VSS CLK \$3 VSS nfet_03v3 L=0.28U W=0.42U AS=0.2646P AD=0.2646P PS=2.1U
+ PD=2.1U
M$3 VDD D \$I10 VDD pfet_03v3 L=0.28U W=0.84U AS=0.546P AD=0.546P PS=2.98U
+ PD=2.98U
M$4 VDD \$10 \$I14 VDD pfet_03v3 L=0.28U W=0.84U AS=0.546P AD=0.546P PS=2.98U
+ PD=2.98U
M$5 VSS D \$I10 VSS nfet_03v3 L=0.28U W=0.42U AS=0.2646P AD=0.2646P PS=2.1U
+ PD=2.1U
M$6 VSS \$10 \$I14 VSS nfet_03v3 L=0.28U W=0.42U AS=0.2646P AD=0.2646P PS=2.1U
+ PD=2.1U
M$7 VDD CLK \$I8 VDD pfet_03v3 L=0.28U W=0.42U AS=0.2822P AD=0.2822P PS=2.18U
+ PD=2.18U
M$8 VDD \$I10 \$I8 VDD pfet_03v3 L=0.28U W=0.42U AS=0.2822P AD=0.2822P PS=2.18U
+ PD=2.18U
M$9 VDD \$I8 \$I7 VDD pfet_03v3 L=0.28U W=0.42U AS=0.2822P AD=0.2822P PS=2.18U
+ PD=2.18U
M$10 VDD \$10 \$I7 VDD pfet_03v3 L=0.28U W=0.42U AS=0.2822P AD=0.2822P PS=2.18U
+ PD=2.18U
M$11 VDD \$I7 \$10 VDD pfet_03v3 L=0.28U W=0.42U AS=0.2822P AD=0.2822P PS=2.18U
+ PD=2.18U
M$12 VDD \$I9 \$10 VDD pfet_03v3 L=0.28U W=0.42U AS=0.2822P AD=0.2822P PS=2.18U
+ PD=2.18U
M$13 VDD CLK \$I9 VDD pfet_03v3 L=0.28U W=0.42U AS=0.2822P AD=0.2822P PS=2.18U
+ PD=2.18U
M$14 VDD D \$I9 VDD pfet_03v3 L=0.28U W=0.42U AS=0.2822P AD=0.2822P PS=2.18U
+ PD=2.18U
M$15 VDD \$3 \$I12 VDD pfet_03v3 L=0.28U W=0.42U AS=0.2822P AD=0.2822P PS=2.18U
+ PD=2.18U
M$16 VDD \$I14 \$I12 VDD pfet_03v3 L=0.28U W=0.42U AS=0.2822P AD=0.2822P
+ PS=2.18U PD=2.18U
M$17 VDD \$I12 Q_bar VDD pfet_03v3 L=0.28U W=0.42U AS=0.2822P AD=0.2822P
+ PS=2.18U PD=2.18U
M$18 VDD Q Q_bar VDD pfet_03v3 L=0.28U W=0.42U AS=0.2822P AD=0.2822P PS=2.18U
+ PD=2.18U
M$19 VDD Q_bar Q VDD pfet_03v3 L=0.28U W=0.42U AS=0.2822P AD=0.2822P PS=2.18U
+ PD=2.18U
M$20 VDD \$I13 Q VDD pfet_03v3 L=0.28U W=0.42U AS=0.2822P AD=0.2822P PS=2.18U
+ PD=2.18U
M$21 VDD \$3 \$I13 VDD pfet_03v3 L=0.28U W=0.42U AS=0.2822P AD=0.2822P PS=2.18U
+ PD=2.18U
M$22 VDD \$10 \$I13 VDD pfet_03v3 L=0.28U W=0.42U AS=0.2822P AD=0.2822P
+ PS=2.18U PD=2.18U
M$23 \$I18 CLK VSS VSS nfet_03v3 L=0.28U W=0.42U AS=0.2646P AD=0.2646P PS=2.1U
+ PD=2.1U
M$24 \$I8 \$I10 \$I18 VSS nfet_03v3 L=0.28U W=0.42U AS=0.2646P AD=0.2646P
+ PS=2.1U PD=2.1U
M$25 \$I19 \$I8 VSS VSS nfet_03v3 L=0.28U W=0.42U AS=0.2646P AD=0.2646P PS=2.1U
+ PD=2.1U
M$26 \$I7 \$10 \$I19 VSS nfet_03v3 L=0.28U W=0.42U AS=0.2646P AD=0.2646P
+ PS=2.1U PD=2.1U
M$27 \$I20 \$I7 VSS VSS nfet_03v3 L=0.28U W=0.42U AS=0.2646P AD=0.2646P PS=2.1U
+ PD=2.1U
M$28 \$10 \$I9 \$I20 VSS nfet_03v3 L=0.28U W=0.42U AS=0.2646P AD=0.2646P
+ PS=2.1U PD=2.1U
M$29 \$I21 CLK VSS VSS nfet_03v3 L=0.28U W=0.42U AS=0.2646P AD=0.2646P PS=2.1U
+ PD=2.1U
M$30 \$I9 D \$I21 VSS nfet_03v3 L=0.28U W=0.42U AS=0.2646P AD=0.2646P PS=2.1U
+ PD=2.1U
M$31 \$I22 \$3 VSS VSS nfet_03v3 L=0.28U W=0.42U AS=0.2646P AD=0.2646P PS=2.1U
+ PD=2.1U
M$32 \$I12 \$I14 \$I22 VSS nfet_03v3 L=0.28U W=0.42U AS=0.2646P AD=0.2646P
+ PS=2.1U PD=2.1U
M$33 \$I23 \$I12 VSS VSS nfet_03v3 L=0.28U W=0.42U AS=0.2646P AD=0.2646P
+ PS=2.1U PD=2.1U
M$34 Q_bar Q \$I23 VSS nfet_03v3 L=0.28U W=0.42U AS=0.2646P AD=0.2646P PS=2.1U
+ PD=2.1U
M$35 \$I24 Q_bar VSS VSS nfet_03v3 L=0.28U W=0.42U AS=0.2646P AD=0.2646P
+ PS=2.1U PD=2.1U
M$36 Q \$I13 \$I24 VSS nfet_03v3 L=0.28U W=0.42U AS=0.2646P AD=0.2646P PS=2.1U
+ PD=2.1U
M$37 \$I25 \$3 VSS VSS nfet_03v3 L=0.28U W=0.42U AS=0.2646P AD=0.2646P PS=2.1U
+ PD=2.1U
M$38 \$I13 \$10 \$I25 VSS nfet_03v3 L=0.28U W=0.42U AS=0.2646P AD=0.2646P
+ PS=2.1U PD=2.1U
.ENDS D_ff1
