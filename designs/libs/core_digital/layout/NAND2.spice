** sch_path: /foss/designs/libs/core_digital/schem/NAND2.sch
.subckt NAND2 Vdd Y A B Vss
*.PININFO A:I B:I Vss:I Vdd:I Y:O
M1 Y A net1 Vss nfet_03v3 L=0.28u W=0.42u nf=1 m=1
M2 net1 B Vss Vss nfet_03v3 L=0.28u W=0.42u nf=1 m=1
M3 Y A Vdd Vdd pfet_03v3 L=0.28u W=0.42u nf=1 m=1
M4 Y B Vdd Vdd pfet_03v3 L=0.28u W=0.42u nf=1 m=1
.ends
