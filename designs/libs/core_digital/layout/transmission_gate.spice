** sch_path: /foss/designs/libs/core_digital/schem/transmission_gate.sch
.subckt transmission_gate ena_bar VDD out in VSS ena
*.PININFO in:I ena_bar:I ena:I VSS:I VDD:I out:O
M1 in ena_bar out VDD pfet_03v3 L=0.28u W=0.42u nf=1 m=1
M2 in ena out VSS nfet_03v3 L=0.28u W=0.42u nf=1 m=1
.ends
