* Extracted by KLayout with GF180MCU LVS runset on : 26/07/2026 21:47

.SUBCKT programmable_nfet s d out ena_bar|ena_bar<1> VSS VDD ena|ena<1> g|in
+ ena|ena<0> ena_bar|ena_bar<0> gf180mcu_gnd
M$1 g|in ena_bar|ena_bar<1> out VDD pfet_03v3 L=0.28U W=0.42U AS=0.2822P
+ AD=0.2822P PS=2.18U PD=2.18U
M$2 out ena_bar|ena_bar<0> g|in VDD pfet_03v3 L=0.28U W=0.42U AS=0.2822P
+ AD=0.2822P PS=2.18U PD=2.18U
M$3 d out s gf180mcu_gnd nfet_03v3 L=1U W=81.3U AS=40.108P AD=40.108P
+ PS=138.46U PD=138.46U
M$5 VSS ena_bar|ena_bar<1> out gf180mcu_gnd nfet_03v3 L=0.28U W=0.42U
+ AS=0.2646P AD=0.2646P PS=2.1U PD=2.1U
M$6 g|in ena|ena<1> out gf180mcu_gnd nfet_03v3 L=0.28U W=0.42U AS=0.2646P
+ AD=0.2646P PS=2.1U PD=2.1U
M$7 d g|in s gf180mcu_gnd nfet_03v3 L=1U W=27.1U AS=16.531P AD=16.531P
+ PS=55.42U PD=55.42U
M$8 out ena|ena<0> g|in gf180mcu_gnd nfet_03v3 L=0.28U W=0.42U AS=0.2646P
+ AD=0.2646P PS=2.1U PD=2.1U
M$10 out ena_bar|ena_bar<0> VSS gf180mcu_gnd nfet_03v3 L=0.28U W=0.42U
+ AS=0.2646P AD=0.2646P PS=2.1U PD=2.1U
.ENDS programmable_nfet
