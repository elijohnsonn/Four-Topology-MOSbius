* Extracted by KLayout with GF180MCU LVS runset on : 01/08/2026 14:47

.SUBCKT programmable_pfet b s d g VSS ena<1> ena<0> ena_bar<1> ena_bar<0>
X$31 g \$4 \$9 VSS ena_bar<0> ena<0> transmission_gate
X$33 g \$8 \$9 VSS ena_bar<1> ena<1> transmission_gate
M$1 \$9 ena<0> \$4 \$9 pfet_03v3 L=0.28U W=0.42U AS=0.2822P AD=0.2822P PS=2.18U
+ PD=2.18U
M$2 \$9 ena<1> \$8 \$9 pfet_03v3 L=0.28U W=0.42U AS=0.2822P AD=0.2822P PS=2.18U
+ PD=2.18U
M$3 d \$8 s b pfet_03v3 L=1U W=184U AS=83.72P AD=83.72P PS=294.2U PD=294.2U
M$23 s g d b pfet_03v3 L=1U W=92U AS=59.8P AD=59.8P PS=197U PD=197U
M$26 s \$4 d b pfet_03v3 L=1U W=92U AS=59.8P AD=59.8P PS=197U PD=197U
.ENDS programmable_pfet

.SUBCKT transmission_gate in out VDD VSS ena_bar ena
M$1 out ena_bar in VDD pfet_03v3 L=0.28U W=0.42U AS=0.2822P AD=0.2822P PS=2.18U
+ PD=2.18U
M$2 out ena in VSS nfet_03v3 L=0.28U W=0.42U AS=0.2646P AD=0.2646P PS=2.1U
+ PD=2.1U
.ENDS transmission_gate
