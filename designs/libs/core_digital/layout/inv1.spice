** sch_path: /foss/designs/libs/core_digital/schem/inv1.sch
.subckt inv1 Vdd A Y Vss
*.PININFO Vdd:I A:I Vss:I Y:O
M1 Y A Vss Vss nfet_03v3 L=0.28u W=0.42u nf=1 m=1
M2 Y A Vdd Vdd pfet_03v3 L=0.28u W=0.84u nf=1 m=1
.ends
