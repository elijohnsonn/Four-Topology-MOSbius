** sch_path: /foss/designs/libs/core_digital/schem/D_ff1.sch
.subckt D_ff1 VDD D Q Q_bar CLK VSS
*.PININFO D:I CLK:I VDD:I VSS:I Q:O Q_bar:O
x1 VDD D net2 net3 CLK VSS D_latch1
x2 VDD net2 Q Q_bar net1 VSS D_latch1
* -- flattened x3 (inv1) --
M1_3 net1 CLK VSS VSS nfet_03v3 L=0.28u W=0.42u nf=1 m=1
M2_3 net1 CLK VDD VDD pfet_03v3 L=0.28u W=0.84u nf=1 m=1
* -- end flattened x3 --
.ends

* expanding   symbol:  libs/core_digital/schem/D_latch1.sym # of pins=6
** sym_path: /foss/designs/libs/core_digital/schem/D_latch1.sym
** sch_path: /foss/designs/libs/core_digital/schem/D_latch1.sch
.subckt D_latch1 Vdd D Q Q_bar clk Vss
*.PININFO D:I Vdd:I Vss:I clk:I Q:O Q_bar:O
x1 Vdd net3 D clk Vss NAND2
x2 Vdd net2 net1 clk Vss NAND2
x3 Vdd Q_bar Q net2 Vss NAND2
x4 Vdd Q net3 Q_bar Vss NAND2
* -- flattened x5 (inv1) --
M1_5 net1 D Vss Vss nfet_03v3 L=0.28u W=0.42u nf=1 m=1
M2_5 net1 D Vdd Vdd pfet_03v3 L=0.28u W=0.84u nf=1 m=1
* -- end flattened x5 --
.ends

* expanding   symbol:  libs/core_digital/schem/inv1.sym # of pins=4
** sym_path: /foss/designs/libs/core_digital/schem/inv1.sym
** sch_path: /foss/designs/libs/core_digital/schem/inv1.sch

* expanding   symbol:  libs/core_digital/schem/NAND2.sym # of pins=5
** sym_path: /foss/designs/libs/core_digital/schem/NAND2.sym
** sch_path: /foss/designs/libs/core_digital/schem/NAND2.sch
.subckt NAND2 Vdd Y A B Vss
*.PININFO A:I B:I Vss:I Vdd:I Y:O
M1 Y A net1 Vss nfet_03v3 L=0.28u W=0.42u nf=1 m=1
M2 net1 B Vss Vss nfet_03v3 L=0.28u W=0.42u nf=1 m=1
M3 Y A Vdd Vdd pfet_03v3 L=0.28u W=0.42u nf=1 m=1
M4 Y B Vdd Vdd pfet_03v3 L=0.28u W=0.42u nf=1 m=1
.ends
