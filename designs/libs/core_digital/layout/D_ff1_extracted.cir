* Extracted by KLayout with GF180MCU LVS runset on : 03/09/2026 04:11

.SUBCKT D_ff1 CLK VDD VSS D Q Q_bar
X$1 VSS VDD D \$11 \$I7 CLK D_latch1
X$3 VSS VDD \$11 Q Q_bar \$3 D_latch1
M$1 VDD CLK \$3 VDD pfet_03v3 L=0.28U W=0.84U AS=0.546P AD=0.546P PS=2.98U
+ PD=2.98U
M$2 VSS CLK \$3 VSS nfet_03v3 L=0.28U W=0.42U AS=0.2646P AD=0.2646P PS=2.1U
+ PD=2.1U
.ENDS D_ff1

.SUBCKT D_latch1 VSS Vdd D Q Q_bar clk
X$1 clk \$7 VSS \$1 Vdd NAND2
X$2 \$1 Q VSS Q_bar Vdd NAND2
X$3 Q_bar \$2 VSS Q Vdd NAND2
X$4 clk D VSS \$2 Vdd NAND2
M$1 Vdd D \$7 Vdd pfet_03v3 L=0.28U W=0.84U AS=0.546P AD=0.546P PS=2.98U
+ PD=2.98U
M$2 VSS D \$7 VSS nfet_03v3 L=0.28U W=0.42U AS=0.2646P AD=0.2646P PS=2.1U
+ PD=2.1U
.ENDS D_latch1

.SUBCKT NAND2 B A VSS Y VDD
M$1 VDD B Y VDD pfet_03v3 L=0.28U W=0.42U AS=0.2822P AD=0.2822P PS=2.18U
+ PD=2.18U
M$2 VDD A Y VDD pfet_03v3 L=0.28U W=0.42U AS=0.2822P AD=0.2822P PS=2.18U
+ PD=2.18U
M$3 \$4 B VSS VSS nfet_03v3 L=0.28U W=0.42U AS=0.2646P AD=0.2646P PS=2.1U
+ PD=2.1U
M$4 Y A \$4 VSS nfet_03v3 L=0.28U W=0.42U AS=0.2646P AD=0.2646P PS=2.1U PD=2.1U
.ENDS NAND2
