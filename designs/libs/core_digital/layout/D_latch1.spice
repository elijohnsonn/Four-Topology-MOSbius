** sch_path: /foss/designs/libs/core_digital/schem/D_latch1.sch
.subckt D_latch1 Vdd D Q Q_bar clk Vss
*.PININFO D:I Vdd:I Vss:I clk:I Q:O Q_bar:O
x1 Vdd net3 D clk Vss NAND2
x2 Vdd net2 net1 clk Vss NAND2
x3 Vdd Q_bar Q net2 Vss NAND2
x4 Vdd Q net3 Q_bar Vss NAND2
x5 Vdd D net1 Vss inv1
.ends

* expanding   symbol:  libs/core_digital/schem/NAND2.sym # of pins=5
** sym_path: /foss/designs/libs/core_digital/schem/NAND2.sym
** sch_path: /foss/designs/libs/core_digital/schem/NAND2.sch
.subckt NAND2 Vdd Y A B Vss
*.PININFO A:I B:I Vss:I Vdd:I Y:O
M1 Y A net1 Vss nfet_03v3 L=0.28u W=0.42u nf=1 m=1
M2 net1 B Vss Vss nfet_03v3 L=0.28u W=0.42u nf=1 m=1
M3 Y A Vdd Vdd pfet_03v3 L=0.28u W=0.42u nf=1 m=1
M4 Y B Vdd Vdd pfet_03v3 L=0.28u W=0.42u nf=1 m=1
.ends

* expanding   symbol:  libs/core_digital/schem/inv1.sym # of pins=4
** sym_path: /foss/designs/libs/core_digital/schem/inv1.sym
** sch_path: /foss/designs/libs/core_digital/schem/inv1.sch
.subckt inv1 Vdd A Y Vss
*.PININFO Vdd:I A:I Vss:I Y:O
M1 Y A Vss Vss nfet_03v3 L=0.28u W=0.42u nf=1 m=1
M2 Y A Vdd Vdd pfet_03v3 L=0.28u W=0.84u nf=1 m=1
.ends
