** sch_path: /foss/designs/libs/core_amps/ota_folded_cascode/prgrm_schem/programmable_folded_cascode.sch
.subckt programmable_folded_cascode EN0 VDD !EN0 VSS EN1 !EN1 INN INP OUT VG_BIAS
*.PININFO OUT:B VSS:B VDD:B EN0:B !EN0:B EN1:B !EN1:B INN:B INP:B VG_BIAS:B
M29 net7 net7 VDD VDD pfet_03v3 L=1u W=23u nf=1 m=5
M30 VBP2 VBP2 net7 VDD pfet_03v3 L=.5u W=19.6u nf=1 m=10
M31 VBP2 VG_BIAS VSS VSS nfet_03v3 L=1u W=27.1u nf=1 m=1
M32 VBN1 VBN1 VSS VSS nfet_03v3 L=1u W=27.1u nf=1 m=1
M33 VBN1 net7 VDD VDD pfet_03v3 L=1u W=23u nf=1 m=5
M34 VBP1 VBP1 VDD VDD pfet_03v3 L=1u W=23u nf=1 m=5
M35 VBP1 VG_BIAS VSS VSS nfet_03v3 L=1u W=27.1u nf=1 m=1
x1 net1 VSS VBN1 VSS !EN0 VDD !EN1 EN0 EN1 VSS programmable_nfet width=20u length=1u nf=1 mult=2
x2 net2 VSS INN net1 !EN0 VDD !EN1 EN0 EN1 VSS programmable_nfet width=30u length=0.5u nf=1 mult=2
x3 net3 VSS INP net1 !EN0 VDD !EN1 EN0 EN1 VSS programmable_nfet width=30u length=0.5u nf=1 mult=2
x4 net5 VSS net5 VSS !EN0 VDD !EN1 EN0 EN1 VSS programmable_nfet width=20.5u length=1u nf=1 mult=1
x5 net6 VSS net5 VSS !EN0 VDD !EN1 EN0 EN1 VSS programmable_nfet width=20.5u length=1u nf=1 mult=1
x6 net4 VSS net4 net5 !EN0 VDD !EN1 EN0 EN1 VSS programmable_nfet width=10.5u length=0.5u nf=1 mult=1
x7 OUT VSS net4 net6 !EN0 VDD !EN1 EN0 EN1 VSS programmable_nfet width=10.5u length=0.5u nf=1 mult=1
x8 net4 VDD VBP2 net3 !EN0 VDD !EN1 EN0 EN1 VSS programmable_pfet width=29.6u length=0.5u nf=1 mult=5
x9 OUT VDD VBP2 net2 !EN0 VDD !EN1 EN0 EN1 VSS programmable_pfet width=29.6u length=0.5u nf=1 mult=5
x10 net3 VDD VBP1 VDD !EN0 VDD !EN1 EN0 EN1 VSS programmable_pfet width=34.8u length=1u nf=1 mult=10
x11 net2 VDD VBP1 VDD !EN0 VDD !EN1 EN0 EN1 VSS programmable_pfet width=34.8u length=1u nf=1 mult=10
.ends

* expanding   symbol:  libs/core_digital/schem/programmable_nfet.sym # of pins=10
** sym_path: /foss/designs/libs/core_digital/schem/programmable_nfet.sym
** sch_path: /foss/designs/libs/core_digital/schem/programmable_nfet.sch
.subckt programmable_nfet d b g s ena_bar<0> VDD ena_bar<1> ena<0> ena<1> VSS  width=0.22u length=0.28u nf=1 mult=1
*.PININFO VSS:I VDD:I g:I ena_bar<1>:I ena_bar<0>:I ena<1>:I ena<0>:I d:B s:B b:I
M1 d net2 s b nfet_03v3 L={length} W={width} nf={nf} m={mult}
M3 d net1 s b nfet_03v3 L={length} W={2*width} nf={2*nf} m={mult}
M2 net1 ena_bar<1> VSS VSS nfet_03v3 L=0.28u W=0.42u nf=1 m=1
M4 net2 ena_bar<0> VSS VSS nfet_03v3 L=0.28u W=0.42u nf=1 m=1
* -- flattened x1 (transmission_gate) --
M1_1 g ena_bar<0> net2 VDD pfet_03v3 L=0.28u W=0.42u nf=1 m=1
M2_1 g ena<0> net2 VSS nfet_03v3 L=0.28u W=0.42u nf=1 m=1
* -- end flattened x1 --
* -- flattened x2 (transmission_gate) --
M1_2 g ena_bar<1> net1 VDD pfet_03v3 L=0.28u W=0.42u nf=1 m=1
M2_2 g ena<1> net1 VSS nfet_03v3 L=0.28u W=0.42u nf=1 m=1
* -- end flattened x2 --
M5 d g s b nfet_03v3 L={length} W={width} nf={nf} m={mult}
.ends

* expanding   symbol:  libs/core_digital/schem/programmable_pfet.sym # of pins=10
** sym_path: /foss/designs/libs/core_digital/schem/programmable_pfet.sym
** sch_path: /foss/designs/libs/core_digital/schem/programmable_pfet.sch
.subckt programmable_pfet d b g s ena_bar<0> VDD ena_bar<1> ena<0> ena<1> VSS  width=0.22u length=0.28u nf=1 mult=1
*.PININFO VSS:I VDD:I g:I ena_bar<1>:I ena_bar<0>:I ena<0>:I s:B d:B b:I ena<1>:I
M1 d net2 s b pfet_03v3 L={length} W={width} nf={nf} m={mult}
M3 d net1 s b pfet_03v3 L={length} W={2*width} nf={2*nf} m={mult}
M2 net1 ena<1> VDD VDD pfet_03v3 L=0.28u W=0.42u nf=1 m=1
M4 net2 ena<0> VDD VDD pfet_03v3 L=0.28u W=0.42u nf=1 m=1
* -- flattened x1 (transmission_gate) --
M1_1 g ena_bar<0> net2 VDD pfet_03v3 L=0.28u W=0.42u nf=1 m=1
M2_1 g ena<0> net2 VSS nfet_03v3 L=0.28u W=0.42u nf=1 m=1
* -- end flattened x1 --
* -- flattened x2 (transmission_gate) --
M1_2 g ena_bar<1> net1 VDD pfet_03v3 L=0.28u W=0.42u nf=1 m=1
M2_2 g ena<1> net1 VSS nfet_03v3 L=0.28u W=0.42u nf=1 m=1
* -- end flattened x2 --
M5 d g s b pfet_03v3 L={length} W={width} nf={nf} m={mult}
.ends

* expanding   symbol:  libs/core_digital/schem/transmission_gate.sym # of pins=6
** sym_path: /foss/designs/libs/core_digital/schem/transmission_gate.sym
** sch_path: /foss/designs/libs/core_digital/schem/transmission_gate.sch
