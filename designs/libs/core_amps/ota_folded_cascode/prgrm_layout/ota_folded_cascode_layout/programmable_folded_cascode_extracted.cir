* Extracted by KLayout with GF180MCU LVS runset on : 14/08/2026 04:51

.SUBCKT programmable_folded_cascode VDD VSS VG_BIAS EN1 \!EN1 \!EN0 EN0 OUT INP
+ INN
M$1 \$3 \$4 \$4 VDD pfet_03v3 L=0.5U W=196U AS=127.4P AD=127.4P PS=405U PD=405U
M$11 VDD \$3 \$3 VDD pfet_03v3 L=1U W=115U AS=74.75P AD=74.75P PS=236.5U
+ PD=236.5U
M$12 VDD \$3 \$8 VDD pfet_03v3 L=1U W=115U AS=74.75P AD=74.75P PS=236.5U
+ PD=236.5U
M$21 VDD \$14 \$14 VDD pfet_03v3 L=1U W=115U AS=74.75P AD=74.75P PS=236.5U
+ PD=236.5U
M$26 VSS VG_BIAS \$14 VSS nfet_03v3 L=1U W=27.1U AS=16.531P AD=16.531P
+ PS=55.42U PD=55.42U
M$27 VSS VG_BIAS \$4 VSS nfet_03v3 L=1U W=27.1U AS=16.531P AD=16.531P PS=55.42U
+ PD=55.42U
M$28 VSS \$8 \$8 VSS nfet_03v3 L=1U W=27.1U AS=16.531P AD=16.531P PS=55.42U
+ PD=55.42U
M$29 VSS \!EN0 \$I203 VSS nfet_03v3 L=0.28U W=0.42U AS=0.2646P AD=0.2646P
+ PS=2.1U PD=2.1U
M$30 VSS \!EN1 \$I202 VSS nfet_03v3 L=0.28U W=0.42U AS=0.2646P AD=0.2646P
+ PS=2.1U PD=2.1U
M$31 VSS \$I203 \$27 VSS nfet_03v3 L=1U W=40U AS=24.4P AD=24.4P PS=82.44U
+ PD=82.44U
M$32 VSS \$8 \$27 VSS nfet_03v3 L=1U W=40U AS=24.4P AD=24.4P PS=82.44U PD=82.44U
M$35 \$27 \$I202 VSS VSS nfet_03v3 L=1U W=80U AS=34.8P AD=34.8P PS=123.48U
+ PD=123.48U
M$39 VSS \!EN0 \$I206 VSS nfet_03v3 L=0.28U W=0.42U AS=0.2646P AD=0.2646P
+ PS=2.1U PD=2.1U
M$40 VSS \!EN0 \$I209 VSS nfet_03v3 L=0.28U W=0.42U AS=0.2646P AD=0.2646P
+ PS=2.1U PD=2.1U
M$41 VSS \!EN1 \$I205 VSS nfet_03v3 L=0.28U W=0.42U AS=0.2646P AD=0.2646P
+ PS=2.1U PD=2.1U
M$42 VSS \!EN1 \$I208 VSS nfet_03v3 L=0.28U W=0.42U AS=0.2646P AD=0.2646P
+ PS=2.1U PD=2.1U
M$43 \$19 \$I205 VSS VSS nfet_03v3 L=1U W=41U AS=17.835P AD=17.835P PS=63.24U
+ PD=63.24U
M$45 \$23 \$I208 VSS VSS nfet_03v3 L=1U W=41U AS=17.835P AD=17.835P PS=63.24U
+ PD=63.24U
M$47 VSS \$I206 \$19 VSS nfet_03v3 L=1U W=20.5U AS=12.505P AD=12.505P PS=42.22U
+ PD=42.22U
M$48 VSS \$19 \$19 VSS nfet_03v3 L=1U W=20.5U AS=12.505P AD=12.505P PS=42.22U
+ PD=42.22U
M$49 VSS \$I209 \$23 VSS nfet_03v3 L=1U W=20.5U AS=12.505P AD=12.505P PS=42.22U
+ PD=42.22U
M$50 VSS \$19 \$23 VSS nfet_03v3 L=1U W=20.5U AS=12.505P AD=12.505P PS=42.22U
+ PD=42.22U
M$51 VSS \!EN0 \$I212 VSS nfet_03v3 L=0.28U W=0.42U AS=0.2646P AD=0.2646P
+ PS=2.1U PD=2.1U
M$52 VSS \!EN0 \$I215 VSS nfet_03v3 L=0.28U W=0.42U AS=0.2646P AD=0.2646P
+ PS=2.1U PD=2.1U
M$53 VSS \!EN1 \$I211 VSS nfet_03v3 L=0.28U W=0.42U AS=0.2646P AD=0.2646P
+ PS=2.1U PD=2.1U
M$54 VSS \!EN1 \$I214 VSS nfet_03v3 L=0.28U W=0.42U AS=0.2646P AD=0.2646P
+ PS=2.1U PD=2.1U
M$55 \$25 \$I211 \$19 VSS nfet_03v3 L=0.5U W=21U AS=9.135P AD=9.135P PS=33.24U
+ PD=33.24U
M$57 OUT \$I214 \$23 VSS nfet_03v3 L=0.5U W=21U AS=9.135P AD=9.135P PS=33.24U
+ PD=33.24U
M$59 \$19 \$I212 \$25 VSS nfet_03v3 L=0.5U W=10.5U AS=6.405P AD=6.405P
+ PS=22.22U PD=22.22U
M$60 \$19 \$25 \$25 VSS nfet_03v3 L=0.5U W=10.5U AS=6.405P AD=6.405P PS=22.22U
+ PD=22.22U
M$61 \$23 \$I215 OUT VSS nfet_03v3 L=0.5U W=10.5U AS=6.405P AD=6.405P PS=22.22U
+ PD=22.22U
M$62 \$23 \$25 OUT VSS nfet_03v3 L=0.5U W=10.5U AS=6.405P AD=6.405P PS=22.22U
+ PD=22.22U
M$63 VSS \!EN0 \$I218 VSS nfet_03v3 L=0.28U W=0.42U AS=0.2646P AD=0.2646P
+ PS=2.1U PD=2.1U
M$64 VSS \!EN0 \$I221 VSS nfet_03v3 L=0.28U W=0.42U AS=0.2646P AD=0.2646P
+ PS=2.1U PD=2.1U
M$65 VSS \!EN1 \$I217 VSS nfet_03v3 L=0.28U W=0.42U AS=0.2646P AD=0.2646P
+ PS=2.1U PD=2.1U
M$66 VSS \!EN1 \$I220 VSS nfet_03v3 L=0.28U W=0.42U AS=0.2646P AD=0.2646P
+ PS=2.1U PD=2.1U
M$67 \$32 \$I217 \$27 VSS nfet_03v3 L=0.5U W=120U AS=52.2P AD=52.2P PS=183.48U
+ PD=183.48U
M$71 \$33 \$I220 \$27 VSS nfet_03v3 L=0.5U W=120U AS=52.2P AD=52.2P PS=183.48U
+ PD=183.48U
M$75 \$27 \$I218 \$32 VSS nfet_03v3 L=0.5U W=60U AS=36.6P AD=36.6P PS=122.44U
+ PD=122.44U
M$76 \$27 INP \$32 VSS nfet_03v3 L=0.5U W=60U AS=36.6P AD=36.6P PS=122.44U
+ PD=122.44U
M$79 \$27 \$I221 \$33 VSS nfet_03v3 L=0.5U W=60U AS=36.6P AD=36.6P PS=122.44U
+ PD=122.44U
M$80 \$27 INN \$33 VSS nfet_03v3 L=0.5U W=60U AS=36.6P AD=36.6P PS=122.44U
+ PD=122.44U
M$83 VDD EN0 \$I224 VDD pfet_03v3 L=0.28U W=0.42U AS=0.2822P AD=0.2822P
+ PS=2.18U PD=2.18U
M$84 VDD EN0 \$I228 VDD pfet_03v3 L=0.28U W=0.42U AS=0.2822P AD=0.2822P
+ PS=2.18U PD=2.18U
M$85 VDD EN1 \$I223 VDD pfet_03v3 L=0.28U W=0.42U AS=0.2822P AD=0.2822P
+ PS=2.18U PD=2.18U
M$86 VDD EN1 \$I227 VDD pfet_03v3 L=0.28U W=0.42U AS=0.2822P AD=0.2822P
+ PS=2.18U PD=2.18U
M$87 \$25 \$I223 \$32 VDD pfet_03v3 L=0.5U W=296U AS=134.68P AD=134.68P
+ PS=453.1U PD=453.1U
M$97 OUT \$I227 \$33 VDD pfet_03v3 L=0.5U W=296U AS=134.68P AD=134.68P
+ PS=453.1U PD=453.1U
M$107 \$32 \$4 \$25 VDD pfet_03v3 L=0.5U W=148U AS=96.2P AD=96.2P PS=302.5U
+ PD=302.5U
M$108 \$32 \$I224 \$25 VDD pfet_03v3 L=0.5U W=148U AS=96.2P AD=96.2P PS=302.5U
+ PD=302.5U
M$117 \$33 \$4 OUT VDD pfet_03v3 L=0.5U W=148U AS=96.2P AD=96.2P PS=302.5U
+ PD=302.5U
M$118 \$33 \$I228 OUT VDD pfet_03v3 L=0.5U W=148U AS=96.2P AD=96.2P PS=302.5U
+ PD=302.5U
M$127 VDD EN0 \$I232 VDD pfet_03v3 L=0.28U W=0.42U AS=0.2822P AD=0.2822P
+ PS=2.18U PD=2.18U
M$128 VDD EN0 \$I236 VDD pfet_03v3 L=0.28U W=0.42U AS=0.2822P AD=0.2822P
+ PS=2.18U PD=2.18U
M$129 VDD EN1 \$I231 VDD pfet_03v3 L=0.28U W=0.42U AS=0.2822P AD=0.2822P
+ PS=2.18U PD=2.18U
M$130 VDD EN1 \$I235 VDD pfet_03v3 L=0.28U W=0.42U AS=0.2822P AD=0.2822P
+ PS=2.18U PD=2.18U
M$131 \$33 \$I231 VDD VDD pfet_03v3 L=1U W=696U AS=316.68P AD=316.68P
+ PS=1062.2U PD=1062.2U
M$151 \$32 \$I235 VDD VDD pfet_03v3 L=1U W=696U AS=316.68P AD=316.68P
+ PS=1062.2U PD=1062.2U
M$171 VDD \$14 \$33 VDD pfet_03v3 L=1U W=348U AS=226.2P AD=226.2P PS=709U
+ PD=709U
M$172 VDD \$I232 \$33 VDD pfet_03v3 L=1U W=348U AS=226.2P AD=226.2P PS=709U
+ PD=709U
M$191 VDD \$14 \$32 VDD pfet_03v3 L=1U W=348U AS=226.2P AD=226.2P PS=709U
+ PD=709U
M$192 VDD \$I236 \$32 VDD pfet_03v3 L=1U W=348U AS=226.2P AD=226.2P PS=709U
+ PD=709U
M$211 \$I202 \!EN1 \$8 VDD pfet_03v3 L=0.28U W=0.42U AS=0.2822P AD=0.2822P
+ PS=2.18U PD=2.18U
M$212 \$I203 \!EN0 \$8 VDD pfet_03v3 L=0.28U W=0.42U AS=0.2822P AD=0.2822P
+ PS=2.18U PD=2.18U
M$213 \$I202 EN1 \$8 VSS nfet_03v3 L=0.28U W=0.42U AS=0.2646P AD=0.2646P
+ PS=2.1U PD=2.1U
M$214 \$I203 EN0 \$8 VSS nfet_03v3 L=0.28U W=0.42U AS=0.2646P AD=0.2646P
+ PS=2.1U PD=2.1U
M$215 \$I205 \!EN1 \$19 VDD pfet_03v3 L=0.28U W=0.42U AS=0.2822P AD=0.2822P
+ PS=2.18U PD=2.18U
M$216 \$I206 \!EN0 \$19 VDD pfet_03v3 L=0.28U W=0.42U AS=0.2822P AD=0.2822P
+ PS=2.18U PD=2.18U
M$217 \$I208 \!EN1 \$19 VDD pfet_03v3 L=0.28U W=0.42U AS=0.2822P AD=0.2822P
+ PS=2.18U PD=2.18U
M$218 \$I209 \!EN0 \$19 VDD pfet_03v3 L=0.28U W=0.42U AS=0.2822P AD=0.2822P
+ PS=2.18U PD=2.18U
M$219 \$I205 EN1 \$19 VSS nfet_03v3 L=0.28U W=0.42U AS=0.2646P AD=0.2646P
+ PS=2.1U PD=2.1U
M$220 \$I206 EN0 \$19 VSS nfet_03v3 L=0.28U W=0.42U AS=0.2646P AD=0.2646P
+ PS=2.1U PD=2.1U
M$221 \$I208 EN1 \$19 VSS nfet_03v3 L=0.28U W=0.42U AS=0.2646P AD=0.2646P
+ PS=2.1U PD=2.1U
M$222 \$I209 EN0 \$19 VSS nfet_03v3 L=0.28U W=0.42U AS=0.2646P AD=0.2646P
+ PS=2.1U PD=2.1U
M$223 \$I211 \!EN1 \$25 VDD pfet_03v3 L=0.28U W=0.42U AS=0.2822P AD=0.2822P
+ PS=2.18U PD=2.18U
M$224 \$I212 \!EN0 \$25 VDD pfet_03v3 L=0.28U W=0.42U AS=0.2822P AD=0.2822P
+ PS=2.18U PD=2.18U
M$225 \$I214 \!EN1 \$25 VDD pfet_03v3 L=0.28U W=0.42U AS=0.2822P AD=0.2822P
+ PS=2.18U PD=2.18U
M$226 \$I215 \!EN0 \$25 VDD pfet_03v3 L=0.28U W=0.42U AS=0.2822P AD=0.2822P
+ PS=2.18U PD=2.18U
M$227 \$I211 EN1 \$25 VSS nfet_03v3 L=0.28U W=0.42U AS=0.2646P AD=0.2646P
+ PS=2.1U PD=2.1U
M$228 \$I212 EN0 \$25 VSS nfet_03v3 L=0.28U W=0.42U AS=0.2646P AD=0.2646P
+ PS=2.1U PD=2.1U
M$229 \$I214 EN1 \$25 VSS nfet_03v3 L=0.28U W=0.42U AS=0.2646P AD=0.2646P
+ PS=2.1U PD=2.1U
M$230 \$I215 EN0 \$25 VSS nfet_03v3 L=0.28U W=0.42U AS=0.2646P AD=0.2646P
+ PS=2.1U PD=2.1U
M$231 \$I217 \!EN1 INP VDD pfet_03v3 L=0.28U W=0.42U AS=0.2822P AD=0.2822P
+ PS=2.18U PD=2.18U
M$232 \$I218 \!EN0 INP VDD pfet_03v3 L=0.28U W=0.42U AS=0.2822P AD=0.2822P
+ PS=2.18U PD=2.18U
M$233 \$I220 \!EN1 INN VDD pfet_03v3 L=0.28U W=0.42U AS=0.2822P AD=0.2822P
+ PS=2.18U PD=2.18U
M$234 \$I221 \!EN0 INN VDD pfet_03v3 L=0.28U W=0.42U AS=0.2822P AD=0.2822P
+ PS=2.18U PD=2.18U
M$235 \$I217 EN1 INP VSS nfet_03v3 L=0.28U W=0.42U AS=0.2646P AD=0.2646P
+ PS=2.1U PD=2.1U
M$236 \$I218 EN0 INP VSS nfet_03v3 L=0.28U W=0.42U AS=0.2646P AD=0.2646P
+ PS=2.1U PD=2.1U
M$237 \$I220 EN1 INN VSS nfet_03v3 L=0.28U W=0.42U AS=0.2646P AD=0.2646P
+ PS=2.1U PD=2.1U
M$238 \$I221 EN0 INN VSS nfet_03v3 L=0.28U W=0.42U AS=0.2646P AD=0.2646P
+ PS=2.1U PD=2.1U
M$239 \$I223 \!EN1 \$4 VDD pfet_03v3 L=0.28U W=0.42U AS=0.2822P AD=0.2822P
+ PS=2.18U PD=2.18U
M$240 \$I224 \!EN0 \$4 VDD pfet_03v3 L=0.28U W=0.42U AS=0.2822P AD=0.2822P
+ PS=2.18U PD=2.18U
M$241 \$I227 \!EN1 \$4 VDD pfet_03v3 L=0.28U W=0.42U AS=0.2822P AD=0.2822P
+ PS=2.18U PD=2.18U
M$242 \$I228 \!EN0 \$4 VDD pfet_03v3 L=0.28U W=0.42U AS=0.2822P AD=0.2822P
+ PS=2.18U PD=2.18U
M$243 \$I223 EN1 \$4 VSS nfet_03v3 L=0.28U W=0.42U AS=0.2646P AD=0.2646P
+ PS=2.1U PD=2.1U
M$244 \$I224 EN0 \$4 VSS nfet_03v3 L=0.28U W=0.42U AS=0.2646P AD=0.2646P
+ PS=2.1U PD=2.1U
M$245 \$I227 EN1 \$4 VSS nfet_03v3 L=0.28U W=0.42U AS=0.2646P AD=0.2646P
+ PS=2.1U PD=2.1U
M$246 \$I228 EN0 \$4 VSS nfet_03v3 L=0.28U W=0.42U AS=0.2646P AD=0.2646P
+ PS=2.1U PD=2.1U
M$247 \$I231 \!EN1 \$14 VDD pfet_03v3 L=0.28U W=0.42U AS=0.2822P AD=0.2822P
+ PS=2.18U PD=2.18U
M$248 \$I232 \!EN0 \$14 VDD pfet_03v3 L=0.28U W=0.42U AS=0.2822P AD=0.2822P
+ PS=2.18U PD=2.18U
M$249 \$I235 \!EN1 \$14 VDD pfet_03v3 L=0.28U W=0.42U AS=0.2822P AD=0.2822P
+ PS=2.18U PD=2.18U
M$250 \$I236 \!EN0 \$14 VDD pfet_03v3 L=0.28U W=0.42U AS=0.2822P AD=0.2822P
+ PS=2.18U PD=2.18U
M$251 \$I231 EN1 \$14 VSS nfet_03v3 L=0.28U W=0.42U AS=0.2646P AD=0.2646P
+ PS=2.1U PD=2.1U
M$252 \$I232 EN0 \$14 VSS nfet_03v3 L=0.28U W=0.42U AS=0.2646P AD=0.2646P
+ PS=2.1U PD=2.1U
M$253 \$I235 EN1 \$14 VSS nfet_03v3 L=0.28U W=0.42U AS=0.2646P AD=0.2646P
+ PS=2.1U PD=2.1U
M$254 \$I236 EN0 \$14 VSS nfet_03v3 L=0.28U W=0.42U AS=0.2646P AD=0.2646P
+ PS=2.1U PD=2.1U
.ENDS programmable_folded_cascode
