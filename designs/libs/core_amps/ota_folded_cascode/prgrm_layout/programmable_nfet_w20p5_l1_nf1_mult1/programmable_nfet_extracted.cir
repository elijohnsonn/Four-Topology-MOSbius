* Extracted by KLayout with GF180MCU LVS runset on : 01/08/2026 18:35

.SUBCKT programmable_nfet VSS VDD ena_bar<1> ena_bar<0> g ena<1> ena<0>
X$6 g \$3 VDD VSS ena_bar<1> ena<1> transmission_gate
X$7 g \$4 VDD VSS ena_bar<0> ena<0> transmission_gate
M$1 VSS ena_bar<0> \$4 VSS nfet_03v3 L=0.28U W=0.42U AS=0.2646P AD=0.2646P
+ PS=2.1U PD=2.1U
M$2 VSS ena_bar<1> \$3 VSS nfet_03v3 L=0.28U W=0.42U AS=0.2646P AD=0.2646P
+ PS=2.1U PD=2.1U
M$3 \$1 \$3 \$10 VSS nfet_03v3 L=1U W=41U AS=17.835P AD=17.835P PS=63.24U
+ PD=63.24U
M$5 \$10 \$4 \$1 VSS nfet_03v3 L=1U W=20.5U AS=12.505P AD=12.505P PS=42.22U
+ PD=42.22U
M$6 \$10 g \$1 VSS nfet_03v3 L=1U W=20.5U AS=12.505P AD=12.505P PS=42.22U
+ PD=42.22U
.ENDS programmable_nfet

.SUBCKT transmission_gate in out VDD VSS ena_bar ena
M$1 out ena_bar in VDD pfet_03v3 L=0.28U W=0.42U AS=0.2822P AD=0.2822P PS=2.18U
+ PD=2.18U
M$2 out ena in VSS nfet_03v3 L=0.28U W=0.42U AS=0.2646P AD=0.2646P PS=2.1U
+ PD=2.1U
.ENDS transmission_gate
