* Extracted by KLayout with GF180MCU LVS runset on : 30/07/2026 03:12

.SUBCKT programmable_nmos
M$1 g|in ena_bar|ena_bar<1> out VDD pfet_03v3 L=0.28U W=0.42U AS=0.2822P
+ AD=0.2822P PS=2.18U PD=2.18U
M$2 out ena_bar|ena_bar<0> g|in VDD pfet_03v3 L=0.28U W=0.42U AS=0.2822P
+ AD=0.2822P PS=2.18U PD=2.18U
M$3 \$4 out \$1 VSS nfet_03v3 L=1U W=20U AS=12.2P AD=5.2P PS=41.22U PD=20.52U
M$4 \$1 out \$4 VSS nfet_03v3 L=1U W=20U AS=5.2P AD=12.2P PS=20.52U PD=41.22U
M$5 \$4 out \$1 VSS nfet_03v3 L=1U W=20U AS=12.2P AD=5.2P PS=41.22U PD=20.52U
M$6 \$1 out \$4 VSS nfet_03v3 L=1U W=20U AS=5.2P AD=12.2P PS=20.52U PD=41.22U
M$7 VSS ena_bar|ena_bar<1> out VSS nfet_03v3 L=0.28U W=0.42U AS=0.2646P
+ AD=0.2646P PS=2.1U PD=2.1U
M$8 g|in ena|ena<1> out VSS nfet_03v3 L=0.28U W=0.42U AS=0.2646P AD=0.2646P
+ PS=2.1U PD=2.1U
M$9 \$1 g|in \$4 VSS nfet_03v3 L=1U W=20U AS=12.2P AD=12.2P PS=41.22U PD=41.22U
M$10 \$1 g|in \$4 VSS nfet_03v3 L=1U W=20U AS=12.2P AD=12.2P PS=41.22U PD=41.22U
M$11 out ena|ena<0> g|in VSS nfet_03v3 L=0.28U W=0.42U AS=0.2646P AD=0.2646P
+ PS=2.1U PD=2.1U
M$12 \$1 out \$4 VSS nfet_03v3 L=1U W=20U AS=12.2P AD=12.2P PS=41.22U PD=41.22U
M$13 \$1 out \$4 VSS nfet_03v3 L=1U W=20U AS=12.2P AD=12.2P PS=41.22U PD=41.22U
M$14 out ena_bar|ena_bar<0> VSS VSS nfet_03v3 L=0.28U W=0.42U AS=0.2646P
+ AD=0.2646P PS=2.1U PD=2.1U
.ENDS programmable_nmos
