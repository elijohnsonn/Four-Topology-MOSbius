* Extracted by KLayout with GF180MCU LVS runset on : 01/08/2026 20:49

.SUBCKT programmable_nfet VSS VDD ena_bar<1> ena_bar<0> g ena<1> ena<0>
X$6 g \$5 VDD VSS ena_bar<1> ena<1> transmission_gate
X$7 g \$6 VDD VSS ena_bar<0> ena<0> transmission_gate
M$1 VSS ena_bar<0> \$6 VSS nfet_03v3 L=0.28U W=0.42U AS=0.2646P AD=0.2646P
+ PS=2.1U PD=2.1U
M$2 VSS ena_bar<1> \$5 VSS nfet_03v3 L=0.28U W=0.42U AS=0.2646P AD=0.2646P
+ PS=2.1U PD=2.1U
M$3 \$3 \$5 \$2 VSS nfet_03v3 L=0.5U W=21U AS=9.135P AD=9.135P PS=33.24U
+ PD=33.24U
M$5 \$2 \$6 \$3 VSS nfet_03v3 L=0.5U W=10.5U AS=6.405P AD=6.405P PS=22.22U
+ PD=22.22U
M$6 \$2 g \$3 VSS nfet_03v3 L=0.5U W=10.5U AS=6.405P AD=6.405P PS=22.22U
+ PD=22.22U
.ENDS programmable_nfet

.SUBCKT transmission_gate in out VDD VSS ena_bar ena
M$1 out ena_bar in VDD pfet_03v3 L=0.28U W=0.42U AS=0.2822P AD=0.2822P PS=2.18U
+ PD=2.18U
M$2 out ena in VSS nfet_03v3 L=0.28U W=0.42U AS=0.2646P AD=0.2646P PS=2.1U
+ PD=2.1U
.ENDS transmission_gate
