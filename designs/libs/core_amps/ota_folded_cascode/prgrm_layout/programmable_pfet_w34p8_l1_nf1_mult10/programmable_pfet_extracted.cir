* Extracted by KLayout with GF180MCU LVS runset on : 02/08/2026 20:51

.SUBCKT programmable_pfet ena<1> VSS ena_bar<1> ena<0> g ena_bar<0>
X$32 g \$3 \$6 VSS ena_bar<1> ena<1> transmission_gate
X$34 g \$41 \$6 VSS ena_bar<0> ena<0> transmission_gate
M$1 \$6 ena<0> \$41 \$6 pfet_03v3 L=0.28U W=0.42U AS=0.2822P AD=0.2822P
+ PS=2.18U PD=2.18U
M$2 \$6 ena<1> \$3 \$6 pfet_03v3 L=0.28U W=0.42U AS=0.2822P AD=0.2822P PS=2.18U
+ PD=2.18U
M$3 \$5 \$3 \$2 \$1 pfet_03v3 L=1U W=696U AS=316.68P AD=316.68P PS=1062.2U
+ PD=1062.2U
M$23 \$2 g \$5 \$1 pfet_03v3 L=1U W=348U AS=226.2P AD=226.2P PS=709U PD=709U
M$24 \$2 \$41 \$5 \$1 pfet_03v3 L=1U W=348U AS=226.2P AD=226.2P PS=709U PD=709U
.ENDS programmable_pfet

.SUBCKT transmission_gate in out VDD VSS ena_bar ena
M$1 out ena_bar in VDD pfet_03v3 L=0.28U W=0.42U AS=0.2822P AD=0.2822P PS=2.18U
+ PD=2.18U
M$2 out ena in VSS nfet_03v3 L=0.28U W=0.42U AS=0.2646P AD=0.2646P PS=2.1U
+ PD=2.1U
.ENDS transmission_gate
