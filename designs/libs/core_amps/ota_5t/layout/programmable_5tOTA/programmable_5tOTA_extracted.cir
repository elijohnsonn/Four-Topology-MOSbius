* Extracted by KLayout with GF180MCU LVS runset on : 05/08/2026 21:12

.SUBCKT programmable_5tOTA ena_bar<1> ena<1> VSS ena<0> VDD ena_bar<0> \$1.g
+ \$3.g \$4.g \$2.g \$5.g
X$28 \$3.g \$I21 VDD VSS ena_bar<1> ena<1> transmission_gate
X$31 \$3.g \$I25 VDD VSS ena_bar<0> ena<0> transmission_gate
X$41 \$4.g \$I28 VDD VSS ena_bar<1> ena<1> transmission_gate
X$44 \$4.g \$I32 VDD VSS ena_bar<0> ena<0> transmission_gate
M$1 VSS ena_bar<1> \$I16 VSS nfet_03v3 L=0.28U W=0.42U AS=0.2646P AD=0.2646P
+ PS=2.1U PD=2.1U
M$2 VSS ena_bar<0> \$I17 VSS nfet_03v3 L=0.28U W=0.42U AS=0.2646P AD=0.2646P
+ PS=2.1U PD=2.1U
M$3 \$I13 \$I16 \$I15 VSS nfet_03v3 L=1U W=136.8U AS=59.508P AD=59.508P
+ PS=210.42U PD=210.42U
M$7 \$I15 \$1.g \$I13 VSS nfet_03v3 L=1U W=68.4U AS=41.724P AD=41.724P
+ PS=140.46U PD=140.46U
M$8 \$I15 \$I17 \$I13 VSS nfet_03v3 L=1U W=68.4U AS=41.724P AD=41.724P
+ PS=140.46U PD=140.46U
M$15 VSS ena_bar<0> \$I25 VSS nfet_03v3 L=0.28U W=0.42U AS=0.2646P AD=0.2646P
+ PS=2.1U PD=2.1U
M$16 VSS ena_bar<0> \$I32 VSS nfet_03v3 L=0.28U W=0.42U AS=0.2646P AD=0.2646P
+ PS=2.1U PD=2.1U
M$17 VSS ena_bar<1> \$I21 VSS nfet_03v3 L=0.28U W=0.42U AS=0.2646P AD=0.2646P
+ PS=2.1U PD=2.1U
M$18 VSS ena_bar<1> \$I28 VSS nfet_03v3 L=0.28U W=0.42U AS=0.2646P AD=0.2646P
+ PS=2.1U PD=2.1U
M$19 \$I22 \$3.g \$I20 VSS nfet_03v3 L=0.5U W=34.2U AS=20.862P AD=20.862P
+ PS=72.06U PD=72.06U
M$21 \$I22 \$I25 \$I20 VSS nfet_03v3 L=0.5U W=34.2U AS=20.862P AD=20.862P
+ PS=72.06U PD=72.06U
M$25 \$I29 \$4.g \$I27 VSS nfet_03v3 L=0.5U W=34.2U AS=20.862P AD=20.862P
+ PS=72.06U PD=72.06U
M$27 \$I29 \$I32 \$I27 VSS nfet_03v3 L=0.5U W=34.2U AS=20.862P AD=20.862P
+ PS=72.06U PD=72.06U
M$31 \$I20 \$I21 \$I22 VSS nfet_03v3 L=0.5U W=68.4U AS=29.754P AD=29.754P
+ PS=107.82U PD=107.82U
M$37 \$I27 \$I28 \$I29 VSS nfet_03v3 L=0.5U W=68.4U AS=29.754P AD=29.754P
+ PS=107.82U PD=107.82U
M$43 VDD ena<0> \$I39 VDD pfet_03v3 L=0.28U W=0.42U AS=0.2822P AD=0.2822P
+ PS=2.18U PD=2.18U
M$44 VDD ena<0> \$I47 VDD pfet_03v3 L=0.28U W=0.42U AS=0.2822P AD=0.2822P
+ PS=2.18U PD=2.18U
M$45 VDD ena<1> \$I34 VDD pfet_03v3 L=0.28U W=0.42U AS=0.2822P AD=0.2822P
+ PS=2.18U PD=2.18U
M$46 VDD ena<1> \$I42 VDD pfet_03v3 L=0.28U W=0.42U AS=0.2822P AD=0.2822P
+ PS=2.18U PD=2.18U
M$47 \$I37 \$I34 \$I36 \$I35 pfet_03v3 L=0.5U W=200U AS=91P AD=91P PS=303.64U
+ PD=303.64U
M$51 \$I45 \$I42 \$I44 \$I43 pfet_03v3 L=0.5U W=200U AS=91P AD=91P PS=303.64U
+ PD=303.64U
M$55 \$I36 \$2.g \$I37 \$I35 pfet_03v3 L=0.5U W=100U AS=65P AD=65P PS=202.6U
+ PD=202.6U
M$56 \$I36 \$I39 \$I37 \$I35 pfet_03v3 L=0.5U W=100U AS=65P AD=65P PS=202.6U
+ PD=202.6U
M$59 \$I44 \$5.g \$I45 \$I43 pfet_03v3 L=0.5U W=100U AS=65P AD=65P PS=202.6U
+ PD=202.6U
M$60 \$I44 \$I47 \$I45 \$I43 pfet_03v3 L=0.5U W=100U AS=65P AD=65P PS=202.6U
+ PD=202.6U
M$63 \$I16 ena_bar<1> \$1.g VDD pfet_03v3 L=0.28U W=0.42U AS=0.2822P AD=0.2822P
+ PS=2.18U PD=2.18U
M$64 \$I17 ena_bar<0> \$1.g VDD pfet_03v3 L=0.28U W=0.42U AS=0.2822P AD=0.2822P
+ PS=2.18U PD=2.18U
M$65 \$I16 ena<1> \$1.g VSS nfet_03v3 L=0.28U W=0.42U AS=0.2646P AD=0.2646P
+ PS=2.1U PD=2.1U
M$66 \$I17 ena<0> \$1.g VSS nfet_03v3 L=0.28U W=0.42U AS=0.2646P AD=0.2646P
+ PS=2.1U PD=2.1U
M$67 \$I34 ena_bar<1> \$2.g VDD pfet_03v3 L=0.28U W=0.42U AS=0.2822P AD=0.2822P
+ PS=2.18U PD=2.18U
M$68 \$I39 ena_bar<0> \$2.g VDD pfet_03v3 L=0.28U W=0.42U AS=0.2822P AD=0.2822P
+ PS=2.18U PD=2.18U
M$69 \$I42 ena_bar<1> \$5.g VDD pfet_03v3 L=0.28U W=0.42U AS=0.2822P AD=0.2822P
+ PS=2.18U PD=2.18U
M$70 \$I47 ena_bar<0> \$5.g VDD pfet_03v3 L=0.28U W=0.42U AS=0.2822P AD=0.2822P
+ PS=2.18U PD=2.18U
M$71 \$I34 ena<1> \$2.g VSS nfet_03v3 L=0.28U W=0.42U AS=0.2646P AD=0.2646P
+ PS=2.1U PD=2.1U
M$72 \$I39 ena<0> \$2.g VSS nfet_03v3 L=0.28U W=0.42U AS=0.2646P AD=0.2646P
+ PS=2.1U PD=2.1U
M$73 \$I42 ena<1> \$5.g VSS nfet_03v3 L=0.28U W=0.42U AS=0.2646P AD=0.2646P
+ PS=2.1U PD=2.1U
M$74 \$I47 ena<0> \$5.g VSS nfet_03v3 L=0.28U W=0.42U AS=0.2646P AD=0.2646P
+ PS=2.1U PD=2.1U
.ENDS programmable_5tOTA

.SUBCKT transmission_gate in out VDD VSS ena_bar ena
M$1 out ena_bar in VDD pfet_03v3 L=0.28U W=0.42U AS=0.2822P AD=0.2822P PS=2.18U
+ PD=2.18U
M$2 out ena in VSS nfet_03v3 L=0.28U W=0.42U AS=0.2646P AD=0.2646P PS=2.1U
+ PD=2.1U
.ENDS transmission_gate
