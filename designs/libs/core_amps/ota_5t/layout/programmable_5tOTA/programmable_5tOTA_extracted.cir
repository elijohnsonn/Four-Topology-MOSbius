* Extracted by KLayout with GF180MCU LVS runset on : 06/08/2026 04:55

.SUBCKT programmable_5tOTA s ena_bar<1> VIN\x2d ena<1> VSS VDD VIN+ ena<0>
+ ena_bar<0> g vout V_BIAS
X$47 g \$I31 VDD VSS ena_bar<1> ena<1> transmission_gate
X$54 g \$I34 VDD VSS ena_bar<0> ena<0> transmission_gate
X$57 g \$I37 VDD VSS ena_bar<1> ena<1> transmission_gate
X$64 g \$I40 VDD VSS ena_bar<0> ena<0> transmission_gate
M$1 VSS ena_bar<1> \$I20 VSS nfet_03v3 L=0.28U W=0.42U AS=0.2646P AD=0.2646P
+ PS=2.1U PD=2.1U
M$2 VSS ena_bar<0> \$I21 VSS nfet_03v3 L=0.28U W=0.42U AS=0.2646P AD=0.2646P
+ PS=2.1U PD=2.1U
M$3 s \$I20 \$I19 VSS nfet_03v3 L=1U W=136.8U AS=59.508P AD=59.508P PS=210.42U
+ PD=210.42U
M$7 \$I19 V_BIAS s VSS nfet_03v3 L=1U W=68.4U AS=41.724P AD=41.724P PS=140.46U
+ PD=140.46U
M$8 \$I19 \$I21 s VSS nfet_03v3 L=1U W=68.4U AS=41.724P AD=41.724P PS=140.46U
+ PD=140.46U
M$15 VSS ena_bar<0> \$I25 VSS nfet_03v3 L=0.28U W=0.42U AS=0.2646P AD=0.2646P
+ PS=2.1U PD=2.1U
M$16 VSS ena_bar<0> \$I29 VSS nfet_03v3 L=0.28U W=0.42U AS=0.2646P AD=0.2646P
+ PS=2.1U PD=2.1U
M$17 VSS ena_bar<1> \$I23 VSS nfet_03v3 L=0.28U W=0.42U AS=0.2646P AD=0.2646P
+ PS=2.1U PD=2.1U
M$18 VSS ena_bar<1> \$I27 VSS nfet_03v3 L=0.28U W=0.42U AS=0.2646P AD=0.2646P
+ PS=2.1U PD=2.1U
M$19 s VIN+ g VSS nfet_03v3 L=0.5U W=34.2U AS=20.862P AD=20.862P PS=72.06U
+ PD=72.06U
M$21 s \$I25 g VSS nfet_03v3 L=0.5U W=34.2U AS=20.862P AD=20.862P PS=72.06U
+ PD=72.06U
M$25 s VIN\x2d vout VSS nfet_03v3 L=0.5U W=34.2U AS=20.862P AD=20.862P
+ PS=72.06U PD=72.06U
M$27 s \$I29 vout VSS nfet_03v3 L=0.5U W=34.2U AS=20.862P AD=20.862P PS=72.06U
+ PD=72.06U
M$31 g \$I23 s VSS nfet_03v3 L=0.5U W=68.4U AS=29.754P AD=29.754P PS=107.82U
+ PD=107.82U
M$37 vout \$I27 s VSS nfet_03v3 L=0.5U W=68.4U AS=29.754P AD=29.754P PS=107.82U
+ PD=107.82U
M$43 VDD ena<0> \$I34 VDD pfet_03v3 L=0.28U W=0.42U AS=0.2822P AD=0.2822P
+ PS=2.18U PD=2.18U
M$44 VDD ena<0> \$I40 VDD pfet_03v3 L=0.28U W=0.42U AS=0.2822P AD=0.2822P
+ PS=2.18U PD=2.18U
M$45 VDD ena<1> \$I31 VDD pfet_03v3 L=0.28U W=0.42U AS=0.2822P AD=0.2822P
+ PS=2.18U PD=2.18U
M$46 VDD ena<1> \$I37 VDD pfet_03v3 L=0.28U W=0.42U AS=0.2822P AD=0.2822P
+ PS=2.18U PD=2.18U
M$47 vout \$I31 \$I33 \$I32 pfet_03v3 L=0.5U W=200U AS=91P AD=91P PS=303.64U
+ PD=303.64U
M$51 g \$I37 \$I39 \$I38 pfet_03v3 L=0.5U W=200U AS=91P AD=91P PS=303.64U
+ PD=303.64U
M$55 \$I33 g vout \$I32 pfet_03v3 L=0.5U W=100U AS=65P AD=65P PS=202.6U
+ PD=202.6U
M$56 \$I33 \$I34 vout \$I32 pfet_03v3 L=0.5U W=100U AS=65P AD=65P PS=202.6U
+ PD=202.6U
M$59 \$I39 g g \$I38 pfet_03v3 L=0.5U W=100U AS=65P AD=65P PS=202.6U PD=202.6U
M$60 \$I39 \$I40 g \$I38 pfet_03v3 L=0.5U W=100U AS=65P AD=65P PS=202.6U
+ PD=202.6U
M$63 \$I20 ena_bar<1> V_BIAS VDD pfet_03v3 L=0.28U W=0.42U AS=0.2822P
+ AD=0.2822P PS=2.18U PD=2.18U
M$64 \$I21 ena_bar<0> V_BIAS VDD pfet_03v3 L=0.28U W=0.42U AS=0.2822P
+ AD=0.2822P PS=2.18U PD=2.18U
M$65 \$I20 ena<1> V_BIAS VSS nfet_03v3 L=0.28U W=0.42U AS=0.2646P AD=0.2646P
+ PS=2.1U PD=2.1U
M$66 \$I21 ena<0> V_BIAS VSS nfet_03v3 L=0.28U W=0.42U AS=0.2646P AD=0.2646P
+ PS=2.1U PD=2.1U
M$67 \$I23 ena_bar<1> VIN+ VDD pfet_03v3 L=0.28U W=0.42U AS=0.2822P AD=0.2822P
+ PS=2.18U PD=2.18U
M$68 \$I25 ena_bar<0> VIN+ VDD pfet_03v3 L=0.28U W=0.42U AS=0.2822P AD=0.2822P
+ PS=2.18U PD=2.18U
M$69 \$I27 ena_bar<1> VIN\x2d VDD pfet_03v3 L=0.28U W=0.42U AS=0.2822P
+ AD=0.2822P PS=2.18U PD=2.18U
M$70 \$I29 ena_bar<0> VIN\x2d VDD pfet_03v3 L=0.28U W=0.42U AS=0.2822P
+ AD=0.2822P PS=2.18U PD=2.18U
M$71 \$I23 ena<1> VIN+ VSS nfet_03v3 L=0.28U W=0.42U AS=0.2646P AD=0.2646P
+ PS=2.1U PD=2.1U
M$72 \$I25 ena<0> VIN+ VSS nfet_03v3 L=0.28U W=0.42U AS=0.2646P AD=0.2646P
+ PS=2.1U PD=2.1U
M$73 \$I27 ena<1> VIN\x2d VSS nfet_03v3 L=0.28U W=0.42U AS=0.2646P AD=0.2646P
+ PS=2.1U PD=2.1U
M$74 \$I29 ena<0> VIN\x2d VSS nfet_03v3 L=0.28U W=0.42U AS=0.2646P AD=0.2646P
+ PS=2.1U PD=2.1U
.ENDS programmable_5tOTA

.SUBCKT transmission_gate in out VDD VSS ena_bar ena
M$1 out ena_bar in VDD pfet_03v3 L=0.28U W=0.42U AS=0.2822P AD=0.2822P PS=2.18U
+ PD=2.18U
M$2 out ena in VSS nfet_03v3 L=0.28U W=0.42U AS=0.2646P AD=0.2646P PS=2.1U
+ PD=2.1U
.ENDS transmission_gate
