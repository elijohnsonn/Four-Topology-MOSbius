* Extracted by KLayout with GF180MCU LVS runset on : 07/08/2026 05:29

.SUBCKT programmable_5tOTA ena_bar<1> ena<1> VSS VDD vin+ vin\x2d ena<0>
+ ena_bar<0>
M$1 VSS ena_bar<1> \$I21 VSS nfet_03v3 L=0.28U W=0.42U AS=0.2646P AD=0.2646P
+ PS=2.1U PD=2.1U
M$2 VSS ena_bar<0> \$I22 VSS nfet_03v3 L=0.28U W=0.42U AS=0.2646P AD=0.2646P
+ PS=2.1U PD=2.1U
M$3 \$1 \$I21 VSS VSS nfet_03v3 L=1U W=136.8U AS=59.508P AD=59.508P PS=210.42U
+ PD=210.42U
M$7 VSS \$12 \$1 VSS nfet_03v3 L=1U W=68.4U AS=41.724P AD=41.724P PS=140.46U
+ PD=140.46U
M$8 VSS \$I22 \$1 VSS nfet_03v3 L=1U W=68.4U AS=41.724P AD=41.724P PS=140.46U
+ PD=140.46U
M$15 VSS ena_bar<0> \$I26 VSS nfet_03v3 L=0.28U W=0.42U AS=0.2646P AD=0.2646P
+ PS=2.1U PD=2.1U
M$16 VSS ena_bar<0> \$I30 VSS nfet_03v3 L=0.28U W=0.42U AS=0.2646P AD=0.2646P
+ PS=2.1U PD=2.1U
M$17 VSS ena_bar<1> \$I24 VSS nfet_03v3 L=0.28U W=0.42U AS=0.2646P AD=0.2646P
+ PS=2.1U PD=2.1U
M$18 VSS ena_bar<1> \$I28 VSS nfet_03v3 L=0.28U W=0.42U AS=0.2646P AD=0.2646P
+ PS=2.1U PD=2.1U
M$19 \$1 vin+ \$9 VSS nfet_03v3 L=0.5U W=34.2U AS=20.862P AD=20.862P PS=72.06U
+ PD=72.06U
M$21 \$1 \$I26 \$9 VSS nfet_03v3 L=0.5U W=34.2U AS=20.862P AD=20.862P PS=72.06U
+ PD=72.06U
M$25 \$1 vin\x2d \$11 VSS nfet_03v3 L=0.5U W=34.2U AS=20.862P AD=20.862P
+ PS=72.06U PD=72.06U
M$27 \$1 \$I30 \$11 VSS nfet_03v3 L=0.5U W=34.2U AS=20.862P AD=20.862P
+ PS=72.06U PD=72.06U
M$31 \$9 \$I24 \$1 VSS nfet_03v3 L=0.5U W=68.4U AS=29.754P AD=29.754P
+ PS=107.82U PD=107.82U
M$37 \$11 \$I28 \$1 VSS nfet_03v3 L=0.5U W=68.4U AS=29.754P AD=29.754P
+ PS=107.82U PD=107.82U
M$43 VDD ena<0> \$I33 VDD pfet_03v3 L=0.28U W=0.42U AS=0.2822P AD=0.2822P
+ PS=2.18U PD=2.18U
M$44 VDD ena<0> \$I37 VDD pfet_03v3 L=0.28U W=0.42U AS=0.2822P AD=0.2822P
+ PS=2.18U PD=2.18U
M$45 VDD ena<1> \$I32 VDD pfet_03v3 L=0.28U W=0.42U AS=0.2822P AD=0.2822P
+ PS=2.18U PD=2.18U
M$46 VDD ena<1> \$I36 VDD pfet_03v3 L=0.28U W=0.42U AS=0.2822P AD=0.2822P
+ PS=2.18U PD=2.18U
M$47 \$11 \$I32 VDD VDD pfet_03v3 L=0.5U W=200U AS=91P AD=91P PS=303.64U
+ PD=303.64U
M$51 \$9 \$I36 VDD VDD pfet_03v3 L=0.5U W=200U AS=91P AD=91P PS=303.64U
+ PD=303.64U
M$55 VDD \$9 \$11 VDD pfet_03v3 L=0.5U W=100U AS=65P AD=65P PS=202.6U PD=202.6U
M$56 VDD \$I33 \$11 VDD pfet_03v3 L=0.5U W=100U AS=65P AD=65P PS=202.6U
+ PD=202.6U
M$59 VDD \$9 \$9 VDD pfet_03v3 L=0.5U W=100U AS=65P AD=65P PS=202.6U PD=202.6U
M$60 VDD \$I37 \$9 VDD pfet_03v3 L=0.5U W=100U AS=65P AD=65P PS=202.6U PD=202.6U
M$63 \$I21 ena_bar<1> \$12 VDD pfet_03v3 L=0.28U W=0.42U AS=0.2822P AD=0.2822P
+ PS=2.18U PD=2.18U
M$64 \$I22 ena_bar<0> \$12 VDD pfet_03v3 L=0.28U W=0.42U AS=0.2822P AD=0.2822P
+ PS=2.18U PD=2.18U
M$65 \$I21 ena<1> \$12 VSS nfet_03v3 L=0.28U W=0.42U AS=0.2646P AD=0.2646P
+ PS=2.1U PD=2.1U
M$66 \$I22 ena<0> \$12 VSS nfet_03v3 L=0.28U W=0.42U AS=0.2646P AD=0.2646P
+ PS=2.1U PD=2.1U
M$67 \$I24 ena_bar<1> vin+ VDD pfet_03v3 L=0.28U W=0.42U AS=0.2822P AD=0.2822P
+ PS=2.18U PD=2.18U
M$68 \$I26 ena_bar<0> vin+ VDD pfet_03v3 L=0.28U W=0.42U AS=0.2822P AD=0.2822P
+ PS=2.18U PD=2.18U
M$69 \$I28 ena_bar<1> vin\x2d VDD pfet_03v3 L=0.28U W=0.42U AS=0.2822P
+ AD=0.2822P PS=2.18U PD=2.18U
M$70 \$I30 ena_bar<0> vin\x2d VDD pfet_03v3 L=0.28U W=0.42U AS=0.2822P
+ AD=0.2822P PS=2.18U PD=2.18U
M$71 \$I24 ena<1> vin+ VSS nfet_03v3 L=0.28U W=0.42U AS=0.2646P AD=0.2646P
+ PS=2.1U PD=2.1U
M$72 \$I26 ena<0> vin+ VSS nfet_03v3 L=0.28U W=0.42U AS=0.2646P AD=0.2646P
+ PS=2.1U PD=2.1U
M$73 \$I28 ena<1> vin\x2d VSS nfet_03v3 L=0.28U W=0.42U AS=0.2646P AD=0.2646P
+ PS=2.1U PD=2.1U
M$74 \$I30 ena<0> vin\x2d VSS nfet_03v3 L=0.28U W=0.42U AS=0.2646P AD=0.2646P
+ PS=2.1U PD=2.1U
M$75 \$I32 ena_bar<1> \$9 VDD pfet_03v3 L=0.28U W=0.42U AS=0.2822P AD=0.2822P
+ PS=2.18U PD=2.18U
M$76 \$I33 ena_bar<0> \$9 VDD pfet_03v3 L=0.28U W=0.42U AS=0.2822P AD=0.2822P
+ PS=2.18U PD=2.18U
M$77 \$I36 ena_bar<1> \$9 VDD pfet_03v3 L=0.28U W=0.42U AS=0.2822P AD=0.2822P
+ PS=2.18U PD=2.18U
M$78 \$I37 ena_bar<0> \$9 VDD pfet_03v3 L=0.28U W=0.42U AS=0.2822P AD=0.2822P
+ PS=2.18U PD=2.18U
M$79 \$I32 ena<1> \$9 VSS nfet_03v3 L=0.28U W=0.42U AS=0.2646P AD=0.2646P
+ PS=2.1U PD=2.1U
M$80 \$I33 ena<0> \$9 VSS nfet_03v3 L=0.28U W=0.42U AS=0.2646P AD=0.2646P
+ PS=2.1U PD=2.1U
M$81 \$I36 ena<1> \$9 VSS nfet_03v3 L=0.28U W=0.42U AS=0.2646P AD=0.2646P
+ PS=2.1U PD=2.1U
M$82 \$I37 ena<0> \$9 VSS nfet_03v3 L=0.28U W=0.42U AS=0.2646P AD=0.2646P
+ PS=2.1U PD=2.1U
.ENDS programmable_5tOTA
