* Extracted by KLayout with GF180MCU LVS runset on : 06/08/2026 06:37

.SUBCKT programmable_5tOTA ena_bar<1> ena<1> VSS VDD ena<0> vin+ vin\x2d
+ ena_bar<0> VOUT V_BIAS
M$1 VSS ena_bar<1> \$I20 VSS nfet_03v3 L=0.28U W=0.42U AS=0.2646P AD=0.2646P
+ PS=2.1U PD=2.1U
M$2 VSS ena_bar<0> \$I21 VSS nfet_03v3 L=0.28U W=0.42U AS=0.2646P AD=0.2646P
+ PS=2.1U PD=2.1U
M$3 \$1 \$I20 \$I19 VSS nfet_03v3 L=1U W=136.8U AS=59.508P AD=59.508P
+ PS=210.42U PD=210.42U
M$7 \$I19 V_BIAS \$1 VSS nfet_03v3 L=1U W=68.4U AS=41.724P AD=41.724P
+ PS=140.46U PD=140.46U
M$8 \$I19 \$I21 \$1 VSS nfet_03v3 L=1U W=68.4U AS=41.724P AD=41.724P PS=140.46U
+ PD=140.46U
M$15 VSS ena_bar<0> \$I25 VSS nfet_03v3 L=0.28U W=0.42U AS=0.2646P AD=0.2646P
+ PS=2.1U PD=2.1U
M$16 VSS ena_bar<0> \$I29 VSS nfet_03v3 L=0.28U W=0.42U AS=0.2646P AD=0.2646P
+ PS=2.1U PD=2.1U
M$17 VSS ena_bar<1> \$I23 VSS nfet_03v3 L=0.28U W=0.42U AS=0.2646P AD=0.2646P
+ PS=2.1U PD=2.1U
M$18 VSS ena_bar<1> \$I27 VSS nfet_03v3 L=0.28U W=0.42U AS=0.2646P AD=0.2646P
+ PS=2.1U PD=2.1U
M$19 \$1 vin+ \$9 VSS nfet_03v3 L=0.5U W=34.2U AS=20.862P AD=20.862P PS=72.06U
+ PD=72.06U
M$21 \$1 \$I25 \$9 VSS nfet_03v3 L=0.5U W=34.2U AS=20.862P AD=20.862P PS=72.06U
+ PD=72.06U
M$25 \$1 vin\x2d VOUT VSS nfet_03v3 L=0.5U W=34.2U AS=20.862P AD=20.862P
+ PS=72.06U PD=72.06U
M$27 \$1 \$I29 VOUT VSS nfet_03v3 L=0.5U W=34.2U AS=20.862P AD=20.862P
+ PS=72.06U PD=72.06U
M$31 \$9 \$I23 \$1 VSS nfet_03v3 L=0.5U W=68.4U AS=29.754P AD=29.754P
+ PS=107.82U PD=107.82U
M$37 VOUT \$I27 \$1 VSS nfet_03v3 L=0.5U W=68.4U AS=29.754P AD=29.754P
+ PS=107.82U PD=107.82U
M$43 VDD ena<0> \$I34 VDD pfet_03v3 L=0.28U W=0.42U AS=0.2822P AD=0.2822P
+ PS=2.18U PD=2.18U
M$44 VDD ena<0> \$I40 VDD pfet_03v3 L=0.28U W=0.42U AS=0.2822P AD=0.2822P
+ PS=2.18U PD=2.18U
M$45 VDD ena<1> \$I31 VDD pfet_03v3 L=0.28U W=0.42U AS=0.2822P AD=0.2822P
+ PS=2.18U PD=2.18U
M$46 VDD ena<1> \$I37 VDD pfet_03v3 L=0.28U W=0.42U AS=0.2822P AD=0.2822P
+ PS=2.18U PD=2.18U
M$47 VOUT \$I31 \$I33 \$I32 pfet_03v3 L=0.5U W=200U AS=91P AD=91P PS=303.64U
+ PD=303.64U
M$51 \$9 \$I37 \$I39 \$I38 pfet_03v3 L=0.5U W=200U AS=91P AD=91P PS=303.64U
+ PD=303.64U
M$55 \$I33 \$9 VOUT \$I32 pfet_03v3 L=0.5U W=100U AS=65P AD=65P PS=202.6U
+ PD=202.6U
M$56 \$I33 \$I34 VOUT \$I32 pfet_03v3 L=0.5U W=100U AS=65P AD=65P PS=202.6U
+ PD=202.6U
M$59 \$I39 \$9 \$9 \$I38 pfet_03v3 L=0.5U W=100U AS=65P AD=65P PS=202.6U
+ PD=202.6U
M$60 \$I39 \$I40 \$9 \$I38 pfet_03v3 L=0.5U W=100U AS=65P AD=65P PS=202.6U
+ PD=202.6U
M$63 \$I20 ena_bar<1> V_BIAS VDD pfet_03v3 L=0.28U W=0.42U AS=0.2822P
+ AD=0.2822P PS=2.18U PD=2.18U
M$64 \$I21 ena_bar<0> V_BIAS VDD pfet_03v3 L=0.28U W=0.42U AS=0.2822P
+ AD=0.2822P PS=2.18U PD=2.18U
M$65 \$I20 ena<1> V_BIAS VSS nfet_03v3 L=0.28U W=0.42U AS=0.2646P AD=0.2646P
+ PS=2.1U PD=2.1U
M$66 \$I21 ena<0> V_BIAS VSS nfet_03v3 L=0.28U W=0.42U AS=0.2646P AD=0.2646P
+ PS=2.1U PD=2.1U
M$67 \$I23 ena_bar<1> vin+ VDD pfet_03v3 L=0.28U W=0.42U AS=0.2822P AD=0.2822P
+ PS=2.18U PD=2.18U
M$68 \$I25 ena_bar<0> vin+ VDD pfet_03v3 L=0.28U W=0.42U AS=0.2822P AD=0.2822P
+ PS=2.18U PD=2.18U
M$69 \$I27 ena_bar<1> vin\x2d VDD pfet_03v3 L=0.28U W=0.42U AS=0.2822P
+ AD=0.2822P PS=2.18U PD=2.18U
M$70 \$I29 ena_bar<0> vin\x2d VDD pfet_03v3 L=0.28U W=0.42U AS=0.2822P
+ AD=0.2822P PS=2.18U PD=2.18U
M$71 \$I23 ena<1> vin+ VSS nfet_03v3 L=0.28U W=0.42U AS=0.2646P AD=0.2646P
+ PS=2.1U PD=2.1U
M$72 \$I25 ena<0> vin+ VSS nfet_03v3 L=0.28U W=0.42U AS=0.2646P AD=0.2646P
+ PS=2.1U PD=2.1U
M$73 \$I27 ena<1> vin\x2d VSS nfet_03v3 L=0.28U W=0.42U AS=0.2646P AD=0.2646P
+ PS=2.1U PD=2.1U
M$74 \$I29 ena<0> vin\x2d VSS nfet_03v3 L=0.28U W=0.42U AS=0.2646P AD=0.2646P
+ PS=2.1U PD=2.1U
M$75 \$I31 ena_bar<1> \$9 VDD pfet_03v3 L=0.28U W=0.42U AS=0.2822P AD=0.2822P
+ PS=2.18U PD=2.18U
M$76 \$I34 ena_bar<0> \$9 VDD pfet_03v3 L=0.28U W=0.42U AS=0.2822P AD=0.2822P
+ PS=2.18U PD=2.18U
M$77 \$I37 ena_bar<1> \$9 VDD pfet_03v3 L=0.28U W=0.42U AS=0.2822P AD=0.2822P
+ PS=2.18U PD=2.18U
M$78 \$I40 ena_bar<0> \$9 VDD pfet_03v3 L=0.28U W=0.42U AS=0.2822P AD=0.2822P
+ PS=2.18U PD=2.18U
M$79 \$I31 ena<1> \$9 VSS nfet_03v3 L=0.28U W=0.42U AS=0.2646P AD=0.2646P
+ PS=2.1U PD=2.1U
M$80 \$I34 ena<0> \$9 VSS nfet_03v3 L=0.28U W=0.42U AS=0.2646P AD=0.2646P
+ PS=2.1U PD=2.1U
M$81 \$I37 ena<1> \$9 VSS nfet_03v3 L=0.28U W=0.42U AS=0.2646P AD=0.2646P
+ PS=2.1U PD=2.1U
M$82 \$I40 ena<0> \$9 VSS nfet_03v3 L=0.28U W=0.42U AS=0.2646P AD=0.2646P
+ PS=2.1U PD=2.1U
.ENDS programmable_5tOTA
