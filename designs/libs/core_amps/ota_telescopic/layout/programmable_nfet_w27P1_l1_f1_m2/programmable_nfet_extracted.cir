* Extracted by KLayout with GF180MCU LVS runset on : 04/08/2026 00:46

.SUBCKT programmable_nfet g ena_bar<0> ena_bar<1> vss d s ena<0> ena<1>
X$2 g \$2 \$6 ena_bar<0> ena<0> vss transmission_gate
X$3 g \$7 \$6 ena_bar<1> ena<1> vss transmission_gate
M$1 vss ena_bar<0> \$2 vss nfet_03v3 L=0.28U W=0.42U AS=0.2646P AD=0.2646P
+ PS=2.1U PD=2.1U
M$2 vss ena_bar<1> \$7 vss nfet_03v3 L=0.28U W=0.42U AS=0.2646P AD=0.2646P
+ PS=2.1U PD=2.1U
M$3 d \$7 s vss nfet_03v3 L=1U W=108.4U AS=47.154P AD=47.154P PS=166.08U
+ PD=166.08U
M$7 s g d vss nfet_03v3 L=1U W=54.2U AS=33.062P AD=33.062P PS=110.84U PD=110.84U
M$9 s \$2 d vss nfet_03v3 L=1U W=54.2U AS=33.062P AD=33.062P PS=110.84U
+ PD=110.84U
.ENDS programmable_nfet

.SUBCKT transmission_gate in out VDD ena_bar ena vss
M$1 out ena_bar in VDD pfet_03v3 L=0.28U W=0.42U AS=0.2822P AD=0.2822P PS=2.18U
+ PD=2.18U
M$2 out ena in vss nfet_03v3 L=0.28U W=0.42U AS=0.2646P AD=0.2646P PS=2.1U
+ PD=2.1U
.ENDS transmission_gate
