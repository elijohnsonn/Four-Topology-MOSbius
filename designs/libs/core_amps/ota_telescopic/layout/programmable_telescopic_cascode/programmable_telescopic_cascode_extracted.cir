* Extracted by KLayout with GF180MCU LVS runset on : 07/08/2026 03:45

.SUBCKT programmable_telescopic_cascode \!EN0 \!EN1 VDD VSS VG_BIAS EN1 EN0
+ output INP INN
M$1 VSS VG_BIAS \$25 VSS nfet_03v3 L=0.5U W=30U AS=18.3P AD=18.3P PS=61.22U
+ PD=61.22U
M$2 VSS \$28 \$28 VSS nfet_03v3 L=0.5U W=1.5U AS=0.915P AD=0.915P PS=4.22U
+ PD=4.22U
M$3 VDD \$25 \$25 VDD pfet_03v3 L=0.5U W=70U AS=45.5P AD=45.5P PS=141.3U
+ PD=141.3U
M$4 VDD \$25 \$28 VDD pfet_03v3 L=0.5U W=70U AS=45.5P AD=45.5P PS=141.3U
+ PD=141.3U
M$5 VSS \!EN0 \$I52 VSS nfet_03v3 L=0.28U W=0.42U AS=0.2646P AD=0.2646P PS=2.1U
+ PD=2.1U
M$6 VSS \!EN1 \$I53 VSS nfet_03v3 L=0.28U W=0.42U AS=0.2646P AD=0.2646P PS=2.1U
+ PD=2.1U
M$7 \$12 \$I53 VSS VSS nfet_03v3 L=1U W=108.4U AS=47.154P AD=47.154P PS=166.08U
+ PD=166.08U
M$11 VSS VG_BIAS \$12 VSS nfet_03v3 L=1U W=54.2U AS=33.062P AD=33.062P
+ PS=110.84U PD=110.84U
M$13 VSS \$I52 \$12 VSS nfet_03v3 L=1U W=54.2U AS=33.062P AD=33.062P PS=110.84U
+ PD=110.84U
M$15 VSS \!EN0 \$I55 VSS nfet_03v3 L=0.28U W=0.42U AS=0.2646P AD=0.2646P
+ PS=2.1U PD=2.1U
M$16 VSS \!EN1 \$I56 VSS nfet_03v3 L=0.28U W=0.42U AS=0.2646P AD=0.2646P
+ PS=2.1U PD=2.1U
M$17 VSS \!EN0 \$I58 VSS nfet_03v3 L=0.28U W=0.42U AS=0.2646P AD=0.2646P
+ PS=2.1U PD=2.1U
M$18 VSS \!EN1 \$I59 VSS nfet_03v3 L=0.28U W=0.42U AS=0.2646P AD=0.2646P
+ PS=2.1U PD=2.1U
M$19 \$14 \$I56 \$12 VSS nfet_03v3 L=0.5U W=60U AS=26.1P AD=26.1P PS=91.74U
+ PD=91.74U
M$21 \$13 \$I59 \$12 VSS nfet_03v3 L=0.5U W=60U AS=26.1P AD=26.1P PS=91.74U
+ PD=91.74U
M$23 \$12 INN \$14 VSS nfet_03v3 L=0.5U W=30U AS=18.3P AD=18.3P PS=61.22U
+ PD=61.22U
M$24 \$12 \$I55 \$14 VSS nfet_03v3 L=0.5U W=30U AS=18.3P AD=18.3P PS=61.22U
+ PD=61.22U
M$25 \$12 INP \$13 VSS nfet_03v3 L=0.5U W=30U AS=18.3P AD=18.3P PS=61.22U
+ PD=61.22U
M$26 \$12 \$I58 \$13 VSS nfet_03v3 L=0.5U W=30U AS=18.3P AD=18.3P PS=61.22U
+ PD=61.22U
M$27 VSS \!EN0 \$I61 VSS nfet_03v3 L=0.28U W=0.42U AS=0.2646P AD=0.2646P
+ PS=2.1U PD=2.1U
M$28 VSS \!EN1 \$I62 VSS nfet_03v3 L=0.28U W=0.42U AS=0.2646P AD=0.2646P
+ PS=2.1U PD=2.1U
M$29 VSS \!EN0 \$I64 VSS nfet_03v3 L=0.28U W=0.42U AS=0.2646P AD=0.2646P
+ PS=2.1U PD=2.1U
M$30 VSS \!EN1 \$I65 VSS nfet_03v3 L=0.28U W=0.42U AS=0.2646P AD=0.2646P
+ PS=2.1U PD=2.1U
M$31 \$14 \$25 output VSS nfet_03v3 L=0.4U W=270U AS=164.7P AD=164.7P
+ PS=547.32U PD=547.32U
M$37 \$14 \$I61 output VSS nfet_03v3 L=0.4U W=270U AS=164.7P AD=164.7P
+ PS=547.32U PD=547.32U
M$43 \$13 \$25 \$15 VSS nfet_03v3 L=0.4U W=270U AS=164.7P AD=164.7P PS=547.32U
+ PD=547.32U
M$49 \$13 \$I64 \$15 VSS nfet_03v3 L=0.4U W=270U AS=164.7P AD=164.7P PS=547.32U
+ PD=547.32U
M$55 output \$I62 \$14 VSS nfet_03v3 L=0.4U W=540U AS=234.9P AD=234.9P
+ PS=820.44U PD=820.44U
M$67 \$15 \$I65 \$13 VSS nfet_03v3 L=0.4U W=540U AS=234.9P AD=234.9P PS=820.44U
+ PD=820.44U
M$79 VDD EN1 \$I67 VDD pfet_03v3 L=0.28U W=0.42U AS=0.2822P AD=0.2822P PS=2.18U
+ PD=2.18U
M$80 VDD EN0 \$I68 VDD pfet_03v3 L=0.28U W=0.42U AS=0.2822P AD=0.2822P PS=2.18U
+ PD=2.18U
M$81 VDD EN1 \$I70 VDD pfet_03v3 L=0.28U W=0.42U AS=0.2822P AD=0.2822P PS=2.18U
+ PD=2.18U
M$82 VDD EN0 \$I71 VDD pfet_03v3 L=0.28U W=0.42U AS=0.2822P AD=0.2822P PS=2.18U
+ PD=2.18U
M$83 \$21 \$I67 VDD VDD pfet_03v3 L=0.5U W=480U AS=218.4P AD=218.4P PS=730.92U
+ PD=730.92U
M$95 \$20 \$I70 VDD VDD pfet_03v3 L=0.5U W=480U AS=218.4P AD=218.4P PS=730.92U
+ PD=730.92U
M$107 VDD \$I68 \$21 VDD pfet_03v3 L=0.5U W=240U AS=156P AD=156P PS=487.8U
+ PD=487.8U
M$109 VDD \$15 \$21 VDD pfet_03v3 L=0.5U W=240U AS=156P AD=156P PS=487.8U
+ PD=487.8U
M$119 VDD \$I71 \$20 VDD pfet_03v3 L=0.5U W=240U AS=156P AD=156P PS=487.8U
+ PD=487.8U
M$121 VDD \$15 \$20 VDD pfet_03v3 L=0.5U W=240U AS=156P AD=156P PS=487.8U
+ PD=487.8U
M$131 VDD EN0 \$I73 VDD pfet_03v3 L=0.28U W=0.42U AS=0.2822P AD=0.2822P
+ PS=2.18U PD=2.18U
M$132 VDD EN1 \$I74 VDD pfet_03v3 L=0.28U W=0.42U AS=0.2822P AD=0.2822P
+ PS=2.18U PD=2.18U
M$133 VDD EN0 \$I76 VDD pfet_03v3 L=0.28U W=0.42U AS=0.2822P AD=0.2822P
+ PS=2.18U PD=2.18U
M$134 VDD EN1 \$I77 VDD pfet_03v3 L=0.28U W=0.42U AS=0.2822P AD=0.2822P
+ PS=2.18U PD=2.18U
M$135 output \$I74 \$21 VDD pfet_03v3 L=0.5U W=470U AS=213.85P AD=213.85P
+ PS=714.1U PD=714.1U
M$145 \$15 \$I77 \$20 VDD pfet_03v3 L=0.5U W=470U AS=213.85P AD=213.85P
+ PS=714.1U PD=714.1U
M$155 \$21 \$28 output VDD pfet_03v3 L=0.5U W=235U AS=152.75P AD=152.75P
+ PS=476.5U PD=476.5U
M$160 \$21 \$I73 output VDD pfet_03v3 L=0.5U W=235U AS=152.75P AD=152.75P
+ PS=476.5U PD=476.5U
M$165 \$20 \$28 \$15 VDD pfet_03v3 L=0.5U W=235U AS=152.75P AD=152.75P
+ PS=476.5U PD=476.5U
M$170 \$20 \$I76 \$15 VDD pfet_03v3 L=0.5U W=235U AS=152.75P AD=152.75P
+ PS=476.5U PD=476.5U
M$175 \$I52 \!EN0 VG_BIAS VDD pfet_03v3 L=0.28U W=0.42U AS=0.2822P AD=0.2822P
+ PS=2.18U PD=2.18U
M$176 \$I53 \!EN1 VG_BIAS VDD pfet_03v3 L=0.28U W=0.42U AS=0.2822P AD=0.2822P
+ PS=2.18U PD=2.18U
M$177 \$I52 EN0 VG_BIAS VSS nfet_03v3 L=0.28U W=0.42U AS=0.2646P AD=0.2646P
+ PS=2.1U PD=2.1U
M$178 \$I53 EN1 VG_BIAS VSS nfet_03v3 L=0.28U W=0.42U AS=0.2646P AD=0.2646P
+ PS=2.1U PD=2.1U
M$179 \$I55 \!EN0 INN VDD pfet_03v3 L=0.28U W=0.42U AS=0.2822P AD=0.2822P
+ PS=2.18U PD=2.18U
M$180 \$I56 \!EN1 INN VDD pfet_03v3 L=0.28U W=0.42U AS=0.2822P AD=0.2822P
+ PS=2.18U PD=2.18U
M$181 \$I58 \!EN0 INP VDD pfet_03v3 L=0.28U W=0.42U AS=0.2822P AD=0.2822P
+ PS=2.18U PD=2.18U
M$182 \$I59 \!EN1 INP VDD pfet_03v3 L=0.28U W=0.42U AS=0.2822P AD=0.2822P
+ PS=2.18U PD=2.18U
M$183 \$I55 EN0 INN VSS nfet_03v3 L=0.28U W=0.42U AS=0.2646P AD=0.2646P PS=2.1U
+ PD=2.1U
M$184 \$I56 EN1 INN VSS nfet_03v3 L=0.28U W=0.42U AS=0.2646P AD=0.2646P PS=2.1U
+ PD=2.1U
M$185 \$I58 EN0 INP VSS nfet_03v3 L=0.28U W=0.42U AS=0.2646P AD=0.2646P PS=2.1U
+ PD=2.1U
M$186 \$I59 EN1 INP VSS nfet_03v3 L=0.28U W=0.42U AS=0.2646P AD=0.2646P PS=2.1U
+ PD=2.1U
M$187 \$I61 \!EN0 \$25 VDD pfet_03v3 L=0.28U W=0.42U AS=0.2822P AD=0.2822P
+ PS=2.18U PD=2.18U
M$188 \$I62 \!EN1 \$25 VDD pfet_03v3 L=0.28U W=0.42U AS=0.2822P AD=0.2822P
+ PS=2.18U PD=2.18U
M$189 \$I64 \!EN0 \$25 VDD pfet_03v3 L=0.28U W=0.42U AS=0.2822P AD=0.2822P
+ PS=2.18U PD=2.18U
M$190 \$I65 \!EN1 \$25 VDD pfet_03v3 L=0.28U W=0.42U AS=0.2822P AD=0.2822P
+ PS=2.18U PD=2.18U
M$191 \$I61 EN0 \$25 VSS nfet_03v3 L=0.28U W=0.42U AS=0.2646P AD=0.2646P
+ PS=2.1U PD=2.1U
M$192 \$I62 EN1 \$25 VSS nfet_03v3 L=0.28U W=0.42U AS=0.2646P AD=0.2646P
+ PS=2.1U PD=2.1U
M$193 \$I64 EN0 \$25 VSS nfet_03v3 L=0.28U W=0.42U AS=0.2646P AD=0.2646P
+ PS=2.1U PD=2.1U
M$194 \$I65 EN1 \$25 VSS nfet_03v3 L=0.28U W=0.42U AS=0.2646P AD=0.2646P
+ PS=2.1U PD=2.1U
M$195 \$I67 \!EN1 \$15 VDD pfet_03v3 L=0.28U W=0.42U AS=0.2822P AD=0.2822P
+ PS=2.18U PD=2.18U
M$196 \$I68 \!EN0 \$15 VDD pfet_03v3 L=0.28U W=0.42U AS=0.2822P AD=0.2822P
+ PS=2.18U PD=2.18U
M$197 \$I70 \!EN1 \$15 VDD pfet_03v3 L=0.28U W=0.42U AS=0.2822P AD=0.2822P
+ PS=2.18U PD=2.18U
M$198 \$I71 \!EN0 \$15 VDD pfet_03v3 L=0.28U W=0.42U AS=0.2822P AD=0.2822P
+ PS=2.18U PD=2.18U
M$199 \$I67 EN1 \$15 VSS nfet_03v3 L=0.28U W=0.42U AS=0.2646P AD=0.2646P
+ PS=2.1U PD=2.1U
M$200 \$I68 EN0 \$15 VSS nfet_03v3 L=0.28U W=0.42U AS=0.2646P AD=0.2646P
+ PS=2.1U PD=2.1U
M$201 \$I70 EN1 \$15 VSS nfet_03v3 L=0.28U W=0.42U AS=0.2646P AD=0.2646P
+ PS=2.1U PD=2.1U
M$202 \$I71 EN0 \$15 VSS nfet_03v3 L=0.28U W=0.42U AS=0.2646P AD=0.2646P
+ PS=2.1U PD=2.1U
M$203 \$I73 \!EN0 \$28 VDD pfet_03v3 L=0.28U W=0.42U AS=0.2822P AD=0.2822P
+ PS=2.18U PD=2.18U
M$204 \$I74 \!EN1 \$28 VDD pfet_03v3 L=0.28U W=0.42U AS=0.2822P AD=0.2822P
+ PS=2.18U PD=2.18U
M$205 \$I76 \!EN0 \$28 VDD pfet_03v3 L=0.28U W=0.42U AS=0.2822P AD=0.2822P
+ PS=2.18U PD=2.18U
M$206 \$I77 \!EN1 \$28 VDD pfet_03v3 L=0.28U W=0.42U AS=0.2822P AD=0.2822P
+ PS=2.18U PD=2.18U
M$207 \$I73 EN0 \$28 VSS nfet_03v3 L=0.28U W=0.42U AS=0.2646P AD=0.2646P
+ PS=2.1U PD=2.1U
M$208 \$I74 EN1 \$28 VSS nfet_03v3 L=0.28U W=0.42U AS=0.2646P AD=0.2646P
+ PS=2.1U PD=2.1U
M$209 \$I76 EN0 \$28 VSS nfet_03v3 L=0.28U W=0.42U AS=0.2646P AD=0.2646P
+ PS=2.1U PD=2.1U
M$210 \$I77 EN1 \$28 VSS nfet_03v3 L=0.28U W=0.42U AS=0.2646P AD=0.2646P
+ PS=2.1U PD=2.1U
.ENDS programmable_telescopic_cascode
