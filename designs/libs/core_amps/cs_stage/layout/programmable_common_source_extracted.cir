* Extracted by KLayout with GF180MCU LVS runset on : 30/07/2026 01:31

.SUBCKT programmable_common_source \!EN0 \!EN1 IN VG_BIAS EN0 EN1 VDD VSS OUT
X$3 VG_BIAS \$I1 VDD VSS \!EN1 EN1 transmission_gate
X$8 VG_BIAS \$I2 VDD VSS \!EN0 EN0 transmission_gate
M$1 VSS \!EN0 \$I2 VSS nfet_03v3 L=0.28U W=0.42U AS=0.2646P AD=0.2646P PS=2.1U
+ PD=2.1U
M$2 VSS \!EN1 \$I1 VSS nfet_03v3 L=0.28U W=0.42U AS=0.2646P AD=0.2646P PS=2.1U
+ PD=2.1U
M$3 OUT \$I1 VSS VSS nfet_03v3 L=1U W=54.2U AS=23.577P AD=23.577P PS=83.04U
+ PD=83.04U
M$5 VSS \$I2 OUT VSS nfet_03v3 L=1U W=27.1U AS=16.531P AD=16.531P PS=55.42U
+ PD=55.42U
M$6 VSS VG_BIAS OUT VSS nfet_03v3 L=1U W=27.1U AS=16.531P AD=16.531P PS=55.42U
+ PD=55.42U
M$7 VDD EN0 \$I4 VDD pfet_03v3 L=0.28U W=0.42U AS=0.2822P AD=0.2822P PS=2.18U
+ PD=2.18U
M$8 VDD EN1 \$I5 VDD pfet_03v3 L=0.28U W=0.42U AS=0.2822P AD=0.2822P PS=2.18U
+ PD=2.18U
M$9 OUT \$I5 VDD VDD pfet_03v3 L=1U W=184U AS=83.72P AD=83.72P PS=294.2U
+ PD=294.2U
M$29 VDD IN OUT VDD pfet_03v3 L=1U W=92U AS=59.8P AD=59.8P PS=197U PD=197U
M$32 VDD \$I4 OUT VDD pfet_03v3 L=1U W=92U AS=59.8P AD=59.8P PS=197U PD=197U
M$49 \$I4 \!EN0 IN VDD pfet_03v3 L=0.28U W=0.42U AS=0.2822P AD=0.2822P PS=2.18U
+ PD=2.18U
M$50 \$I5 \!EN1 IN VDD pfet_03v3 L=0.28U W=0.42U AS=0.2822P AD=0.2822P PS=2.18U
+ PD=2.18U
M$51 \$I4 EN0 IN VSS nfet_03v3 L=0.28U W=0.42U AS=0.2646P AD=0.2646P PS=2.1U
+ PD=2.1U
M$52 \$I5 EN1 IN VSS nfet_03v3 L=0.28U W=0.42U AS=0.2646P AD=0.2646P PS=2.1U
+ PD=2.1U
.ENDS programmable_common_source

.SUBCKT transmission_gate in out VDD VSS ena_bar ena
M$1 out ena_bar in VDD pfet_03v3 L=0.28U W=0.42U AS=0.2822P AD=0.2822P PS=2.18U
+ PD=2.18U
M$2 out ena in VSS nfet_03v3 L=0.28U W=0.42U AS=0.2646P AD=0.2646P PS=2.1U
+ PD=2.1U
.ENDS transmission_gate
