* NGSPICE file created from DUT.ext - technology: gf180mcuD

.subckt DUT CLK SCAN_OUT SCAN_IN VSS VDD OUT_FOLDED INP_FOLDED OUT_5T IBIAS INN_FOLDED INP_5T INN_5T INP_TELESCOPIC OUT_TELESCOPIC
+ OUT_CS IN_CS INN_TELESCOPIC PROG_ENA
X0 a_45880_2844.t39 programmable_folded_cascode_0.programmable_pfet_1.transmission_gate$16_1.out.t3 VDD.t346 VDD.t321 pfet_03v3 ad=9.048p pd=35.32u as=22.62p ps=70.9u w=34.8u l=1u
X1 scan_chain_0.D_ff1_8.D_latch1$1_0.inv1$3_0.Y scan_chain_0.D_ff1_8.D_latch1$1_0.D VDD.t458 VDD.t457 pfet_03v3 ad=0.546p pd=2.98u as=0.546p ps=2.98u w=0.84u l=0.28u
X2 scan_chain_0.D_ff1_2.D_latch1$1_1.inv1$3_0.Y transmission_gate$2$1_3.out.t5 VDD.t222 VDD.t221 pfet_03v3 ad=0.546p pd=2.98u as=0.546p ps=2.98u w=0.84u l=0.28u
X3 programmable_telescopic_cascode_0.programmable_nfet$5_1.transmission_gate$25_0.out transmission_gate$2$1_4.out.t5 INN_TELESCOPIC.t3 VSS.t379 nfet_03v3 ad=0.2646p pd=2.1u as=0.2646p ps=2.1u w=0.42u l=0.28u
X4 programmable_folded_cascode_0.programmable_nfet_0.transmission_gate$18_1.out programmable_folded_cascode_0.EN1.t3 INN_FOLDED.t1 VDD.t674 pfet_03v3 ad=0.2822p pd=2.18u as=0.2822p ps=2.18u w=0.42u l=0.28u
X5 a_55117_79808# programmable_common_source_0.EN0.t5 scan_chain_0.D_ff1_4.D_latch1$1_1.NAND2$2_0.A VSS.t300 nfet_03v3 ad=0.2646p pd=2.1u as=0.2646p ps=2.1u w=0.42u l=0.28u
X6 programmable_5tOTA_0.programmable_pfet$4_1.transmission_gate$27_1.out.t0 transmission_gate$2$1_3.out.t6 programmable_5tOTA_0.programmable_pfet$4_0.g.t21 VSS.t316 nfet_03v3 ad=0.2646p pd=2.1u as=0.2646p ps=2.1u w=0.42u l=0.28u
X7 VDD.t591 programmable_common_source_0.programmable_pfet$5_0.transmission_gate$30_1.out.t3 OUT_CS.t23 VDD.t256 pfet_03v3 ad=5.98p pd=19.7u as=5.98p ps=19.7u w=9.2u l=1u
X8 programmable_5tOTA_0.ena_bar<1>.t1 transmission_gate$2$1_2.out.t5 a_45053_79067# VSS.t419 nfet_03v3 ad=0.2646p pd=2.1u as=0.2646p ps=2.1u w=0.42u l=0.28u
X9 VDD.t702 programmable_folded_cascode_0.programmable_pfet_0.transmission_gate$16_1.out.t3 a_49197_2844.t41 VDD.t78 pfet_03v3 ad=22.62p pd=70.9u as=9.048p ps=35.32u w=34.8u l=1u
X10 programmable_folded_cascode_0.programmable_pfet_0.g.t13 transmission_gate$2$1_7.out.t5 programmable_folded_cascode_0.programmable_pfet_0.transmission_gate$16_0.out.t1 VSS.t179 nfet_03v3 ad=0.2646p pd=2.1u as=0.2646p ps=2.1u w=0.42u l=0.28u
X11 OUT_CS.t2 programmable_common_source_0.programmable_nfet$9_0.transmission_gate$31_1.out VSS.t126 VSS.t125 nfet_03v3 ad=7.046p pd=27.62u as=16.531p ps=55.42u w=27.1u l=1u
X12 VSS.t98 programmable_telescopic_cascode_0.programmable_nfet$6_0.transmission_gate$26_0.out.t3 programmable_telescopic_cascode_0.programmable_nfet$6_0.d.t13 VSS.t97 nfet_03v3 ad=16.531p pd=55.42u as=7.046p ps=27.62u w=27.1u l=1u
X13 programmable_telescopic_cascode_0.programmable_nfet$5_1.d.t21 programmable_telescopic_cascode_0.programmable_nfet$4_0.g.t11 OUT_TELESCOPIC.t26 VSS.t189 nfet_03v3 ad=27.45p pd=91.22u as=27.45p ps=91.22u w=45u l=0.4u
X14 VDD.t569 CLK.t0 scan_chain_0.D_ff1_0.D_latch1$1_1.NAND2$2_0.A VDD.t568 pfet_03v3 ad=0.2822p pd=2.18u as=0.2822p ps=2.18u w=0.42u l=0.28u
X15 VSS.t60 scan_chain_0.D_ff1_1.inv1$4_0.Y a_35869_79067# VSS.t59 nfet_03v3 ad=0.2646p pd=2.1u as=0.2646p ps=2.1u w=0.42u l=0.28u
X16 programmable_folded_cascode_0.programmable_pfet$1_0.transmission_gate$17_1.out.t1 transmission_gate$2$1_6.out.t5 programmable_folded_cascode_0.programmable_pfet$1_0.g.t26 VSS.t413 nfet_03v3 ad=0.2646p pd=2.1u as=0.2646p ps=2.1u w=0.42u l=0.28u
X17 a_32014_79808# transmission_gate$2$1_4.out.t6 scan_chain_0.D_ff1_1.D_latch1$1_1.NAND2$2_0.A VSS.t378 nfet_03v3 ad=0.2646p pd=2.1u as=0.2646p ps=2.1u w=0.42u l=0.28u
X18 programmable_5tOTA_0.programmable_nfet$7_0.transmission_gate$28_0.out transmission_gate$2$1_3.out.t7 INN_5T.t2 VSS.t315 nfet_03v3 ad=0.2646p pd=2.1u as=0.2646p ps=2.1u w=0.42u l=0.28u
X19 VDD.t446 scan_chain_0.D_ff1_3.D_latch1$1_1.Q_bar scan_chain_0.D_ff1_3.D_latch1$1_0.D VDD.t445 pfet_03v3 ad=0.2822p pd=2.18u as=0.2822p ps=2.18u w=0.42u l=0.28u
X20 scan_chain_0.D_ff1_1.inv1$4_0.Y CLK.t1 VSS.t438 VSS.t437 nfet_03v3 ad=0.2646p pd=2.1u as=0.2646p ps=2.1u w=0.42u l=0.28u
X21 programmable_telescopic_cascode_0.programmable_nfet$4_1.transmission_gate$24_0.out.t1 programmable_telescopic_cascode_0.EN1.t3 programmable_telescopic_cascode_0.programmable_nfet$4_0.g.t3 VDD.t152 pfet_03v3 ad=0.2822p pd=2.18u as=0.2822p ps=2.18u w=0.42u l=0.28u
X22 programmable_telescopic_cascode_0.programmable_nfet$5_1.d.t11 programmable_telescopic_cascode_0.programmable_nfet$4_1.transmission_gate$24_1.out.t3 OUT_TELESCOPIC.t14 VSS.t145 nfet_03v3 ad=27.45p pd=91.22u as=27.45p ps=91.22u w=45u l=0.4u
X23 VDD.t310 programmable_5tOTA_0.programmable_pfet$4_0.g.t30 OUT_5T.t14 VDD.t309 pfet_03v3 ad=32.5p pd=0.1013m as=32.5p ps=0.1013m w=50u l=0.5u
X24 scan_chain_0.D_ff1_6.D_latch1$1_0.NAND2$2_0.A scan_chain_0.D_ff1_6.D_latch1$1_0.D VDD.t721 VDD.t720 pfet_03v3 ad=0.2822p pd=2.18u as=0.2822p ps=2.18u w=0.42u l=0.28u
X25 programmable_folded_cascode_0.programmable_nfet$1_0.g.t11 programmable_folded_cascode_0.programmable_pfet$1_0.g.t29 a_45880_2844.t43 VDD.t361 pfet_03v3 ad=19.24p pd=60.5u as=19.24p ps=60.5u w=29.6u l=0.5u
X26 programmable_5tOTA_0.programmable_pfet$4_0.g.t24 programmable_5tOTA_0.programmable_nfet$7_1.transmission_gate$28_0.out a_91570_47942.t32 VSS.t334 nfet_03v3 ad=6.954p pd=24.02u as=6.954p ps=24.02u w=11.4u l=0.5u
X27 a_61069_4063.t9 programmable_folded_cascode_0.programmable_pfet$1_0.g.t4 programmable_folded_cascode_0.programmable_pfet$1_0.g.t5 VDD.t165 pfet_03v3 ad=12.74p pd=40.5u as=12.74p ps=40.5u w=19.6u l=0.5u
X28 programmable_telescopic_cascode_0.programmable_pfet$3_0.d.t17 programmable_telescopic_cascode_0.programmable_pfet$2_0.transmission_gate$22_1.out.t3 programmable_telescopic_cascode_0.programmable_pfet$3_0.g.t22 VDD.t653 pfet_03v3 ad=30.55p pd=95.3u as=30.55p ps=95.3u w=47u l=0.5u
X29 OUT_CS.t43 programmable_common_source_0.programmable_pfet$5_0.transmission_gate$30_0.out.t3 VDD.t693 VDD.t465 pfet_03v3 ad=2.392p pd=9.72u as=5.98p ps=19.7u w=9.2u l=1u
X30 OUT_5T.t6 INN_5T.t4 a_91570_47942.t23 VSS.t228 nfet_03v3 ad=6.954p pd=24.02u as=6.954p ps=24.02u w=11.4u l=0.5u
X31 VDD.t571 CLK.t2 scan_chain_0.D_ff1_4.D_latch1$1_1.NAND2$2_2.B VDD.t570 pfet_03v3 ad=0.2822p pd=2.18u as=0.2822p ps=2.18u w=0.42u l=0.28u
X32 programmable_folded_cascode_0.OUT.t15 programmable_folded_cascode_0.programmable_pfet$1_0.transmission_gate$17_1.out.t3 a_49197_2844.t42 VDD.t151 pfet_03v3 ad=7.696p pd=30.12u as=19.24p ps=60.5u w=29.6u l=0.5u
X33 OUT_TELESCOPIC.t43 programmable_telescopic_cascode_0.programmable_pfet$2_1.transmission_gate$22_0.out.t3 programmable_telescopic_cascode_0.programmable_pfet$3_1.d.t15 VDD.t139 pfet_03v3 ad=12.22p pd=47.52u as=30.55p ps=95.3u w=47u l=0.5u
X34 programmable_telescopic_cascode_0.programmable_nfet$4_0.s.t25 programmable_telescopic_cascode_0.programmable_nfet$4_0.transmission_gate$24_0.out.t3 programmable_telescopic_cascode_0.programmable_pfet$3_0.g.t31 VSS.t428 nfet_03v3 ad=27.45p pd=91.22u as=11.7p ps=45.52u w=45u l=0.4u
X35 a_91570_47942.t16 IBIAS.t14 VSS.t166 VSS.t110 nfet_03v3 ad=13.908p pd=46.82u as=13.908p ps=46.82u w=22.8u l=1u
X36 VDD.t676 programmable_folded_cascode_0.EN1.t4 transmission_gate$2$1_6.out.t2 VDD.t675 pfet_03v3 ad=0.2822p pd=2.18u as=0.2822p ps=2.18u w=0.42u l=0.28u
X37 VDD.t304 scan_chain_0.D_ff1_7.inv1$4_0.Y scan_chain_0.D_ff1_7.D_latch1$1_0.NAND2$2_0.A VDD.t303 pfet_03v3 ad=0.2822p pd=2.18u as=0.2822p ps=2.18u w=0.42u l=0.28u
X38 scan_chain_0.D_ff1_7.D_latch1$1_1.Q_bar scan_chain_0.D_ff1_7.D_latch1$1_1.NAND2$2_2.B VDD.t271 VDD.t270 pfet_03v3 ad=0.2822p pd=2.18u as=0.2822p ps=2.18u w=0.42u l=0.28u
X39 programmable_folded_cascode_0.programmable_pfet_0.g.t17 programmable_folded_cascode_0.EN0.t3 programmable_folded_cascode_0.programmable_pfet_1.transmission_gate$16_0.out.t0 VDD.t556 pfet_03v3 ad=0.2822p pd=2.18u as=0.2822p ps=2.18u w=0.42u l=0.28u
X40 a_45880_2844.t45 programmable_folded_cascode_0.programmable_pfet_0.g.t19 VDD.t582 VDD.t185 pfet_03v3 ad=22.62p pd=70.9u as=22.62p ps=70.9u w=34.8u l=1u
X41 VDD.t549 transmission_gate$2$1_2.out.t6 programmable_5tOTA_0.programmable_pfet$4_0.transmission_gate$27_0.out.t2 VDD.t548 pfet_03v3 ad=0.2822p pd=2.18u as=0.2822p ps=2.18u w=0.42u l=0.28u
X42 VSS.t440 CLK.t3 a_24313_79808# VSS.t439 nfet_03v3 ad=0.2646p pd=2.1u as=0.2646p ps=2.1u w=0.42u l=0.28u
X43 scan_chain_0.D_ff1_0.D_latch1$1_0.inv1$3_0.Y scan_chain_0.D_ff1_0.D_latch1$1_0.D VSS.t257 VSS.t256 nfet_03v3 ad=0.2646p pd=2.1u as=0.2646p ps=2.1u w=0.42u l=0.28u
X44 VDD.t440 scan_chain_0.D_ff1_5.D_latch1$1_0.D scan_chain_0.D_ff1_5.D_latch1$1_1.Q_bar VDD.t439 pfet_03v3 ad=0.2822p pd=2.18u as=0.2822p ps=2.18u w=0.42u l=0.28u
X45 programmable_telescopic_cascode_0.programmable_pfet$3_0.g.t32 programmable_telescopic_cascode_0.programmable_nfet$4_0.transmission_gate$24_0.out.t4 programmable_telescopic_cascode_0.programmable_nfet$4_0.s.t24 VSS.t161 nfet_03v3 ad=11.7p pd=45.52u as=27.45p ps=91.22u w=45u l=0.4u
X46 VSS.t241 programmable_folded_cascode_0.programmable_nfet$2_1.transmission_gate$20_1.out programmable_folded_cascode_0.programmable_nfet$2_0.g.t10 VSS.t240 nfet_03v3 ad=12.505p pd=42.22u as=5.33p ps=21.02u w=20.5u l=1u
X47 a_45880_2844.t13 programmable_folded_cascode_0.programmable_pfet$1_1.transmission_gate$17_1.out.t3 programmable_folded_cascode_0.programmable_nfet$1_0.g.t22 VDD.t123 pfet_03v3 ad=19.24p pd=60.5u as=7.696p ps=30.12u w=29.6u l=0.5u
X48 programmable_5tOTA_0.programmable_pfet$4_0.g.t23 programmable_5tOTA_0.programmable_nfet$7_1.transmission_gate$28_0.out a_91570_47942.t31 VSS.t334 nfet_03v3 ad=6.954p pd=24.02u as=6.954p ps=24.02u w=11.4u l=0.5u
X49 a_64302_79808# scan_chain_0.D_ff1_0.D_latch1$1_1.NAND2$2_0.A scan_chain_0.D_ff1_0.D_latch1$1_0.D VSS.t432 nfet_03v3 ad=0.2646p pd=2.1u as=0.2646p ps=2.1u w=0.42u l=0.28u
X50 scan_chain_0.D_ff1_8.D_latch1$1_0.NAND2$2_0.A scan_chain_0.D_ff1_8.D_latch1$1_0.D VDD.t456 VDD.t455 pfet_03v3 ad=0.2822p pd=2.18u as=0.2822p ps=2.18u w=0.42u l=0.28u
X51 VSS.t299 scan_chain_0.D_ff1_2.D_latch1$1_1.Q_bar a_41199_79808# VSS.t298 nfet_03v3 ad=0.2646p pd=2.1u as=0.2646p ps=2.1u w=0.42u l=0.28u
X52 a_55661_23626.t3 programmable_folded_cascode_0.programmable_nfet_0.transmission_gate$18_1.out a_49197_2844.t3 VSS.t14 nfet_03v3 ad=18.3p pd=61.22u as=7.8p ps=30.52u w=30u l=0.5u
X53 a_91570_47942.t18 programmable_5tOTA_0.programmable_nfet$8_0.transmission_gate$29_0.out.t3 VSS.t174 VSS.t173 nfet_03v3 ad=13.908p pd=46.82u as=13.908p ps=46.82u w=22.8u l=1u
X54 VSS.t232 scan_chain_0.D_ff1_8.inv1$4_0.Y a_28168_79067# VSS.t231 nfet_03v3 ad=0.2646p pd=2.1u as=0.2646p ps=2.1u w=0.42u l=0.28u
X55 a_45880_2844.t46 programmable_folded_cascode_0.programmable_pfet_0.g.t20 VDD.t583 VDD.t185 pfet_03v3 ad=22.62p pd=70.9u as=22.62p ps=70.9u w=34.8u l=1u
X56 programmable_folded_cascode_0.programmable_nfet$1_0.g.t16 transmission_gate$2$1_7.out.t6 programmable_folded_cascode_0.programmable_nfet$1_1.transmission_gate$19_0.out VSS.t180 nfet_03v3 ad=0.2646p pd=2.1u as=0.2646p ps=2.1u w=0.42u l=0.28u
X57 VDD.t402 scan_chain_0.D_ff1_6.inv1$4_0.Y scan_chain_0.D_ff1_6.D_latch1$1_0.NAND2$2_2.B VDD.t401 pfet_03v3 ad=0.2822p pd=2.18u as=0.2822p ps=2.18u w=0.42u l=0.28u
X58 VDD.t703 programmable_folded_cascode_0.programmable_pfet_0.transmission_gate$16_1.out.t4 a_49197_2844.t40 VDD.t78 pfet_03v3 ad=22.62p pd=70.9u as=9.048p ps=35.32u w=34.8u l=1u
X59 VDD.t722 programmable_telescopic_cascode_0.programmable_pfet$3_0.transmission_gate$23_1.out.t3 programmable_telescopic_cascode_0.programmable_pfet$3_0.d.t42 VDD.t543 pfet_03v3 ad=26p pd=81.3u as=26p ps=81.3u w=40u l=0.5u
X60 programmable_common_source_0.programmable_nfet$9_0.transmission_gate$31_0.out programmable_common_source_0.EN0.t6 IBIAS.t2 VSS.t301 nfet_03v3 ad=0.2646p pd=2.1u as=0.2646p ps=2.1u w=0.42u l=0.28u
X61 a_33497_79067# scan_chain_0.D_ff1_1.D_latch1$1_1.NAND2$2_2.B VSS.t67 VSS.t66 nfet_03v3 ad=0.2646p pd=2.1u as=0.2646p ps=2.1u w=0.42u l=0.28u
X62 scan_chain_0.D_ff1_3.D_latch1$1_0.NAND2$2_2.B scan_chain_0.D_ff1_3.D_latch1$1_0.inv1$3_0.Y VDD.t491 VDD.t490 pfet_03v3 ad=0.2822p pd=2.18u as=0.2822p ps=2.18u w=0.42u l=0.28u
X63 VSS.t456 scan_chain_0.D_ff1_4.D_latch1$1_1.Q_bar a_56601_79808# VSS.t455 nfet_03v3 ad=0.2646p pd=2.1u as=0.2646p ps=2.1u w=0.42u l=0.28u
X64 a_49197_2844.t39 programmable_folded_cascode_0.programmable_pfet_0.transmission_gate$16_1.out.t5 VDD.t704 VDD.t81 pfet_03v3 ad=9.048p pd=35.32u as=22.62p ps=70.9u w=34.8u l=1u
X65 a_61069_4063.t8 programmable_folded_cascode_0.programmable_pfet$1_0.g.t2 programmable_folded_cascode_0.programmable_pfet$1_0.g.t3 VDD.t165 pfet_03v3 ad=12.74p pd=40.5u as=12.74p ps=40.5u w=19.6u l=0.5u
X66 VDD.t143 scan_chain_0.D_ff1_5.inv1$4_0.Y scan_chain_0.D_ff1_5.D_latch1$1_0.NAND2$2_2.B VDD.t142 pfet_03v3 ad=0.2822p pd=2.18u as=0.2822p ps=2.18u w=0.42u l=0.28u
X67 programmable_telescopic_cascode_0.programmable_nfet$5_1.d.t14 programmable_telescopic_cascode_0.programmable_nfet$4_1.transmission_gate$24_0.out.t3 OUT_TELESCOPIC.t17 VSS.t119 nfet_03v3 ad=27.45p pd=91.22u as=11.7p ps=45.52u w=45u l=0.4u
X68 a_66673_79808# scan_chain_0.D_ff1_0.D_latch1$1_0.D scan_chain_0.D_ff1_0.D_latch1$1_0.NAND2$2_0.A VSS.t255 nfet_03v3 ad=0.2646p pd=2.1u as=0.2646p ps=2.1u w=0.42u l=0.28u
X69 VSS.t178 programmable_5tOTA_0.ena_bar<1>.t3 programmable_5tOTA_0.programmable_nfet$8_0.transmission_gate$29_1.out.t0 VSS.t177 nfet_03v3 ad=0.2646p pd=2.1u as=0.2646p ps=2.1u w=0.42u l=0.28u
X70 VDD.t410 programmable_common_source_0.EN0.t7 programmable_common_source_0.EN0.t1 VDD.t409 pfet_03v3 ad=0.2822p pd=2.18u as=0.2822p ps=2.18u w=0.42u l=0.28u
X71 transmission_gate$2$1_2.out.t1 scan_chain_0.D_ff1_2.D_latch1$1_0.NAND2$2_0.A VDD.t147 VDD.t146 pfet_03v3 ad=0.2822p pd=2.18u as=0.2822p ps=2.18u w=0.42u l=0.28u
X72 programmable_folded_cascode_0.programmable_nfet$1_0.g.t23 programmable_folded_cascode_0.programmable_pfet$1_1.transmission_gate$17_1.out.t4 a_45880_2844.t14 VDD.t208 pfet_03v3 ad=7.696p pd=30.12u as=19.24p ps=60.5u w=29.6u l=0.5u
X73 VSS.t38 programmable_telescopic_cascode_0.EN0.t3 a_21951_79808# VSS.t37 nfet_03v3 ad=0.2646p pd=2.1u as=0.2646p ps=2.1u w=0.42u l=0.28u
X74 programmable_telescopic_cascode_0.programmable_nfet$4_0.s.t13 programmable_telescopic_cascode_0.programmable_nfet$4_0.g.t12 programmable_telescopic_cascode_0.programmable_pfet$3_0.g.t30 VSS.t190 nfet_03v3 ad=27.45p pd=91.22u as=27.45p ps=91.22u w=45u l=0.4u
X75 a_47416_79067# scan_chain_0.D_ff1_3.D_latch1$1_1.inv1$3_0.Y scan_chain_0.D_ff1_3.D_latch1$1_1.NAND2$2_2.B VSS.t392 nfet_03v3 ad=0.2646p pd=2.1u as=0.2646p ps=2.1u w=0.42u l=0.28u
X76 programmable_folded_cascode_0.programmable_pfet$1_0.g.t21 transmission_gate$2$1_7.out.t7 programmable_folded_cascode_0.programmable_pfet$1_1.transmission_gate$17_0.out.t1 VSS.t181 nfet_03v3 ad=0.2646p pd=2.1u as=0.2646p ps=2.1u w=0.42u l=0.28u
X77 VDD.t398 IN_CS.t4 OUT_CS.t11 VDD.t274 pfet_03v3 ad=5.98p pd=19.7u as=5.98p ps=19.7u w=9.2u l=1u
X78 programmable_folded_cascode_0.OUT.t5 programmable_folded_cascode_0.programmable_pfet$1_0.g.t30 a_49197_2844.t50 VDD.t364 pfet_03v3 ad=19.24p pd=60.5u as=19.24p ps=60.5u w=29.6u l=0.5u
X79 VSS.t495 scan_chain_0.D_ff1_4.inv1$4_0.Y a_58972_79808# VSS.t494 nfet_03v3 ad=0.2646p pd=2.1u as=0.2646p ps=2.1u w=0.42u l=0.28u
X80 a_45880_2844.t58 programmable_folded_cascode_0.programmable_pfet_1.transmission_gate$16_0.out.t3 VDD.t614 VDD.t607 pfet_03v3 ad=22.62p pd=70.9u as=22.62p ps=70.9u w=34.8u l=1u
X81 programmable_folded_cascode_0.programmable_nfet_1.transmission_gate$18_1.out transmission_gate$2$1_6.out.t6 INP_FOLDED.t3 VSS.t414 nfet_03v3 ad=0.2646p pd=2.1u as=0.2646p ps=2.1u w=0.42u l=0.28u
X82 a_14249_79067# scan_chain_0.D_ff1_6.D_latch1$1_0.NAND2$2_2.B VSS.t307 VSS.t306 nfet_03v3 ad=0.2646p pd=2.1u as=0.2646p ps=2.1u w=0.42u l=0.28u
X83 programmable_telescopic_cascode_0.programmable_nfet$5_1.transmission_gate$25_0.out programmable_telescopic_cascode_0.EN1.t4 INN_TELESCOPIC.t2 VDD.t153 pfet_03v3 ad=0.2822p pd=2.18u as=0.2822p ps=2.18u w=0.42u l=0.28u
X84 VDD.t121 transmission_gate$2$1_5.out.t5 programmable_telescopic_cascode_0.programmable_pfet$3_0.transmission_gate$23_1.out.t1 VDD.t120 pfet_03v3 ad=0.2822p pd=2.18u as=0.2822p ps=2.18u w=0.42u l=0.28u
X85 OUT_CS.t33 programmable_common_source_0.programmable_pfet$5_0.transmission_gate$30_0.out.t4 VDD.t500 VDD.t465 pfet_03v3 ad=2.392p pd=9.72u as=5.98p ps=19.7u w=9.2u l=1u
X86 a_45880_2844.t59 programmable_folded_cascode_0.programmable_pfet_1.transmission_gate$16_0.out.t4 VDD.t615 VDD.t607 pfet_03v3 ad=22.62p pd=70.9u as=22.62p ps=70.9u w=34.8u l=1u
X87 VDD.t345 programmable_folded_cascode_0.programmable_pfet_1.transmission_gate$16_1.out.t4 a_45880_2844.t38 VDD.t342 pfet_03v3 ad=22.62p pd=70.9u as=9.048p ps=35.32u w=34.8u l=1u
X88 OUT_CS.t34 programmable_common_source_0.programmable_pfet$5_0.transmission_gate$30_0.out.t5 VDD.t501 VDD.t465 pfet_03v3 ad=2.392p pd=9.72u as=5.98p ps=19.7u w=9.2u l=1u
X89 VDD.t23 programmable_telescopic_cascode_0.programmable_pfet$3_1.transmission_gate$23_1.out.t3 programmable_telescopic_cascode_0.programmable_pfet$3_1.d.t0 VDD.t22 pfet_03v3 ad=26p pd=81.3u as=26p ps=81.3u w=40u l=0.5u
X90 programmable_folded_cascode_0.programmable_nfet$1_0.g.t30 programmable_folded_cascode_0.EN0.t4 programmable_folded_cascode_0.programmable_nfet$1_1.transmission_gate$19_0.out VDD.t557 pfet_03v3 ad=0.2822p pd=2.18u as=0.2822p ps=2.18u w=0.42u l=0.28u
X91 a_45880_2844.t37 programmable_folded_cascode_0.programmable_pfet_1.transmission_gate$16_1.out.t5 VDD.t344 VDD.t321 pfet_03v3 ad=9.048p pd=35.32u as=22.62p ps=70.9u w=34.8u l=1u
X92 programmable_folded_cascode_0.programmable_nfet$2_1.transmission_gate$20_1.out transmission_gate$2$1_6.out.t7 programmable_folded_cascode_0.programmable_nfet$2_0.g.t8 VSS.t415 nfet_03v3 ad=0.2646p pd=2.1u as=0.2646p ps=2.1u w=0.42u l=0.28u
X93 a_6548_79067# scan_chain_0.D_ff1_5.D_latch1$1_0.NAND2$2_2.B VSS.t132 VSS.t131 nfet_03v3 ad=0.2646p pd=2.1u as=0.2646p ps=2.1u w=0.42u l=0.28u
X94 scan_chain_0.D_ff1_1.D_latch1$1_1.inv1$3_0.Y transmission_gate$2$1_4.out.t7 VDD.t476 VDD.t475 pfet_03v3 ad=0.546p pd=2.98u as=0.546p ps=2.98u w=0.84u l=0.28u
X95 a_68156_79067# scan_chain_0.D_ff1_0.D_latch1$1_0.NAND2$2_2.B VSS.t402 VSS.t401 nfet_03v3 ad=0.2646p pd=2.1u as=0.2646p ps=2.1u w=0.42u l=0.28u
X96 scan_chain_0.D_ff1_3.D_latch1$1_1.inv1$3_0.Y transmission_gate$2$1_2.out.t7 VSS.t421 VSS.t420 nfet_03v3 ad=0.2646p pd=2.1u as=0.2646p ps=2.1u w=0.42u l=0.28u
X97 programmable_telescopic_cascode_0.programmable_pfet$3_1.d.t36 programmable_telescopic_cascode_0.programmable_pfet$2_1.transmission_gate$22_1.out.t3 OUT_TELESCOPIC.t19 VDD.t472 pfet_03v3 ad=30.55p pd=95.3u as=30.55p ps=95.3u w=47u l=0.5u
X98 OUT_CS.t35 programmable_common_source_0.programmable_pfet$5_0.transmission_gate$30_0.out.t6 VDD.t502 VDD.t465 pfet_03v3 ad=2.392p pd=9.72u as=5.98p ps=19.7u w=9.2u l=1u
X99 VDD.t573 CLK.t4 scan_chain_0.D_ff1_5.D_latch1$1_1.NAND2$2_0.A VDD.t572 pfet_03v3 ad=0.2822p pd=2.18u as=0.2822p ps=2.18u w=0.42u l=0.28u
X100 scan_chain_0.D_ff1_7.D_latch1$1_1.Q_bar scan_chain_0.D_ff1_7.D_latch1$1_0.D a_18095_79067# VSS.t272 nfet_03v3 ad=0.2646p pd=2.1u as=0.2646p ps=2.1u w=0.42u l=0.28u
X101 VDD.t175 programmable_telescopic_cascode_0.programmable_pfet$3_0.g.t52 programmable_telescopic_cascode_0.programmable_pfet$3_0.d.t23 VDD.t155 pfet_03v3 ad=26p pd=81.3u as=26p ps=81.3u w=40u l=0.5u
X102 a_39715_79067# scan_chain_0.D_ff1_2.D_latch1$1_1.inv1$3_0.Y scan_chain_0.D_ff1_2.D_latch1$1_1.NAND2$2_2.B VSS.t41 nfet_03v3 ad=0.2646p pd=2.1u as=0.2646p ps=2.1u w=0.42u l=0.28u
X103 VDD.t211 programmable_5tOTA_0.programmable_pfet$4_0.transmission_gate$27_0.out.t3 programmable_5tOTA_0.programmable_pfet$4_0.g.t12 VDD.t210 pfet_03v3 ad=32.5p pd=0.1013m as=13p ps=50.52u w=50u l=0.5u
X104 a_55661_23626.t12 programmable_folded_cascode_0.programmable_nfet$3_0.g.t11 VSS.t78 VSS.t77 nfet_03v3 ad=12.2p pd=41.22u as=12.2p ps=41.22u w=20u l=1u
X105 programmable_telescopic_cascode_0.programmable_pfet$3_0.d.t6 programmable_telescopic_cascode_0.programmable_pfet$3_0.transmission_gate$23_0.out.t3 VDD.t109 VDD.t99 pfet_03v3 ad=10.4p pd=40.52u as=26p ps=81.3u w=40u l=0.5u
X106 VSS.t427 programmable_folded_cascode_0.EN0.t5 programmable_folded_cascode_0.programmable_nfet$1_0.transmission_gate$19_0.out VSS.t426 nfet_03v3 ad=0.2646p pd=2.1u as=0.2646p ps=2.1u w=0.42u l=0.28u
X107 scan_chain_0.D_ff1_0.inv1$4_0.Y CLK.t5 VDD.t575 VDD.t574 pfet_03v3 ad=0.546p pd=2.98u as=0.546p ps=2.98u w=0.84u l=0.28u
X108 VDD.t171 programmable_5tOTA_0.programmable_pfet$4_0.transmission_gate$27_1.out.t3 programmable_5tOTA_0.programmable_pfet$4_0.g.t10 VDD.t170 pfet_03v3 ad=32.5p pd=0.1013m as=32.5p ps=0.1013m w=50u l=0.5u
X109 scan_chain_0.D_ff1_6.D_latch1$1_0.inv1$3_0.Y scan_chain_0.D_ff1_6.D_latch1$1_0.D VSS.t536 VSS.t535 nfet_03v3 ad=0.2646p pd=2.1u as=0.2646p ps=2.1u w=0.42u l=0.28u
X110 VDD.t134 a_61069_4063.t20 programmable_folded_cascode_0.programmable_nfet$3_0.g.t5 VDD.t133 pfet_03v3 ad=14.95p pd=47.3u as=14.95p ps=47.3u w=23u l=1u
X111 a_91570_47942.t7 programmable_5tOTA_0.programmable_nfet$7_1.transmission_gate$28_1.out programmable_5tOTA_0.programmable_pfet$4_0.g.t1 VSS.t46 nfet_03v3 ad=6.954p pd=24.02u as=2.964p ps=11.92u w=11.4u l=0.5u
X112 VSS.t442 CLK.t6 a_62818_79067# VSS.t441 nfet_03v3 ad=0.2646p pd=2.1u as=0.2646p ps=2.1u w=0.42u l=0.28u
X113 a_61069_4063.t7 programmable_folded_cascode_0.programmable_pfet$1_0.g.t0 programmable_folded_cascode_0.programmable_pfet$1_0.g.t1 VDD.t165 pfet_03v3 ad=12.74p pd=40.5u as=12.74p ps=40.5u w=19.6u l=0.5u
X114 VDD.t577 CLK.t7 scan_chain_0.D_ff1_7.D_latch1$1_1.NAND2$2_2.B VDD.t576 pfet_03v3 ad=0.2822p pd=2.18u as=0.2822p ps=2.18u w=0.42u l=0.28u
X115 programmable_common_source_0.EN1.t3 PROG_ENA.t0 VSS.t69 VDD.t83 pfet_03v3 ad=0.2822p pd=2.18u as=0.2822p ps=2.18u w=0.42u l=0.28u
X116 VDD.t224 transmission_gate$2$1_7.out.t8 programmable_folded_cascode_0.programmable_pfet_1.transmission_gate$16_0.out.t2 VDD.t223 pfet_03v3 ad=0.2822p pd=2.18u as=0.2822p ps=2.18u w=0.42u l=0.28u
X117 programmable_folded_cascode_0.OUT.t14 programmable_folded_cascode_0.programmable_pfet$1_0.transmission_gate$17_1.out.t4 a_49197_2844.t43 VDD.t151 pfet_03v3 ad=7.696p pd=30.12u as=19.24p ps=60.5u w=29.6u l=0.5u
X118 scan_chain_0.D_ff1_2.D_latch1$1_1.inv1$3_0.Y transmission_gate$2$1_3.out.t8 VSS.t314 VSS.t313 nfet_03v3 ad=0.2646p pd=2.1u as=0.2646p ps=2.1u w=0.42u l=0.28u
X119 a_58972_79067# scan_chain_0.D_ff1_4.D_latch1$1_0.inv1$3_0.Y scan_chain_0.D_ff1_4.D_latch1$1_0.NAND2$2_2.B VSS.t62 nfet_03v3 ad=0.2646p pd=2.1u as=0.2646p ps=2.1u w=0.42u l=0.28u
X120 VDD.t343 programmable_folded_cascode_0.programmable_pfet_1.transmission_gate$16_1.out.t6 a_45880_2844.t36 VDD.t342 pfet_03v3 ad=22.62p pd=70.9u as=9.048p ps=35.32u w=34.8u l=1u
X121 programmable_telescopic_cascode_0.programmable_pfet$3_1.d.t37 programmable_telescopic_cascode_0.programmable_pfet$2_1.transmission_gate$22_1.out.t4 OUT_TELESCOPIC.t20 VDD.t472 pfet_03v3 ad=30.55p pd=95.3u as=30.55p ps=95.3u w=47u l=0.5u
X122 scan_chain_0.D_ff1_8.D_latch1$1_0.D scan_chain_0.D_ff1_8.D_latch1$1_1.NAND2$2_0.A VDD.t360 VDD.t359 pfet_03v3 ad=0.2822p pd=2.18u as=0.2822p ps=2.18u w=0.42u l=0.28u
X123 scan_chain_0.D_ff1_8.D_latch1$1_0.inv1$3_0.Y scan_chain_0.D_ff1_8.D_latch1$1_0.D VSS.t360 VSS.t359 nfet_03v3 ad=0.2646p pd=2.1u as=0.2646p ps=2.1u w=0.42u l=0.28u
X124 scan_chain_0.D_ff1_4.D_latch1$1_1.NAND2$2_2.B scan_chain_0.D_ff1_4.D_latch1$1_1.inv1$3_0.Y VDD.t73 VDD.t72 pfet_03v3 ad=0.2822p pd=2.18u as=0.2822p ps=2.18u w=0.42u l=0.28u
X125 programmable_telescopic_cascode_0.programmable_pfet$2_0.g.t6 programmable_telescopic_cascode_0.EN0.t4 programmable_telescopic_cascode_0.programmable_pfet$2_1.transmission_gate$22_1.out.t2 VDD.t42 pfet_03v3 ad=0.2822p pd=2.18u as=0.2822p ps=2.18u w=0.42u l=0.28u
X126 VDD.t275 IN_CS.t5 OUT_CS.t4 VDD.t274 pfet_03v3 ad=5.98p pd=19.7u as=5.98p ps=19.7u w=9.2u l=1u
X127 VDD.t705 programmable_folded_cascode_0.programmable_pfet_0.transmission_gate$16_1.out.t6 a_49197_2844.t38 VDD.t78 pfet_03v3 ad=22.62p pd=70.9u as=9.048p ps=35.32u w=34.8u l=1u
X128 VDD.t202 scan_chain_0.D_ff1_2.inv1$4_0.Y scan_chain_0.D_ff1_2.D_latch1$1_0.NAND2$2_0.A VDD.t201 pfet_03v3 ad=0.2822p pd=2.18u as=0.2822p ps=2.18u w=0.42u l=0.28u
X129 VDD.t579 CLK.t8 scan_chain_0.D_ff1_6.D_latch1$1_1.NAND2$2_2.B VDD.t578 pfet_03v3 ad=0.2822p pd=2.18u as=0.2822p ps=2.18u w=0.42u l=0.28u
X130 a_45880_2844.t35 programmable_folded_cascode_0.programmable_pfet_1.transmission_gate$16_1.out.t7 VDD.t341 VDD.t321 pfet_03v3 ad=9.048p pd=35.32u as=22.62p ps=70.9u w=34.8u l=1u
X131 VDD.t276 IN_CS.t6 OUT_CS.t5 VDD.t274 pfet_03v3 ad=5.98p pd=19.7u as=5.98p ps=19.7u w=9.2u l=1u
X132 scan_chain_0.D_ff1_5.D_latch1$1_0.inv1$3_0.Y scan_chain_0.D_ff1_5.D_latch1$1_0.D VDD.t438 VDD.t437 pfet_03v3 ad=0.546p pd=2.98u as=0.546p ps=2.98u w=0.84u l=0.28u
X133 a_12766_79808# scan_chain_0.D_ff1_6.D_latch1$1_0.D scan_chain_0.D_ff1_6.D_latch1$1_0.NAND2$2_0.A VSS.t534 nfet_03v3 ad=0.2646p pd=2.1u as=0.2646p ps=2.1u w=0.42u l=0.28u
X134 VSS.t236 scan_chain_0.D_ff1_7.inv1$4_0.Y a_20467_79067# VSS.t235 nfet_03v3 ad=0.2646p pd=2.1u as=0.2646p ps=2.1u w=0.42u l=0.28u
X135 VSS.t188 programmable_telescopic_cascode_0.EN0.t5 programmable_telescopic_cascode_0.programmable_nfet$6_0.transmission_gate$26_1.out VSS.t187 nfet_03v3 ad=0.2646p pd=2.1u as=0.2646p ps=2.1u w=0.42u l=0.28u
X136 programmable_telescopic_cascode_0.programmable_nfet$6_0.transmission_gate$26_0.out.t0 programmable_telescopic_cascode_0.EN1.t5 VSS.t135 VSS.t134 nfet_03v3 ad=0.2646p pd=2.1u as=0.2646p ps=2.1u w=0.42u l=0.28u
X137 VDD.t176 programmable_telescopic_cascode_0.programmable_pfet$3_0.g.t53 programmable_telescopic_cascode_0.programmable_pfet$3_1.d.t35 VDD.t160 pfet_03v3 ad=26p pd=81.3u as=26p ps=81.3u w=40u l=0.5u
X138 a_45880_2844.t47 programmable_folded_cascode_0.programmable_pfet_0.g.t21 VDD.t584 VDD.t185 pfet_03v3 ad=22.62p pd=70.9u as=22.62p ps=70.9u w=34.8u l=1u
X139 a_49197_2844.t2 programmable_folded_cascode_0.programmable_nfet_0.transmission_gate$18_1.out a_55661_23626.t2 VSS.t13 nfet_03v3 ad=7.8p pd=30.52u as=18.3p ps=61.22u w=30u l=0.5u
X140 VDD.t314 scan_chain_0.D_ff1_1.D_latch1$1_1.Q_bar scan_chain_0.D_ff1_1.D_latch1$1_0.D VDD.t313 pfet_03v3 ad=0.2822p pd=2.18u as=0.2822p ps=2.18u w=0.42u l=0.28u
X141 VDD.t719 scan_chain_0.D_ff1_6.D_latch1$1_0.D scan_chain_0.D_ff1_6.D_latch1$1_1.Q_bar VDD.t718 pfet_03v3 ad=0.2822p pd=2.18u as=0.2822p ps=2.18u w=0.42u l=0.28u
X142 scan_chain_0.D_ff1_1.D_latch1$1_1.NAND2$2_2.B scan_chain_0.D_ff1_1.D_latch1$1_1.inv1$3_0.Y VDD.t663 VDD.t662 pfet_03v3 ad=0.2822p pd=2.18u as=0.2822p ps=2.18u w=0.42u l=0.28u
X143 a_49197_2844.t59 programmable_folded_cascode_0.programmable_pfet_0.g.t22 VDD.t585 VDD.t183 pfet_03v3 ad=22.62p pd=70.9u as=22.62p ps=70.9u w=34.8u l=1u
X144 VDD.t277 IN_CS.t7 OUT_CS.t6 VDD.t274 pfet_03v3 ad=5.98p pd=19.7u as=5.98p ps=19.7u w=9.2u l=1u
X145 programmable_folded_cascode_0.programmable_pfet_1.transmission_gate$16_1.out.t0 transmission_gate$2$1_6.out.t8 VDD.t542 VDD.t541 pfet_03v3 ad=0.2822p pd=2.18u as=0.2822p ps=2.18u w=0.42u l=0.28u
X146 VDD.t119 programmable_folded_cascode_0.programmable_pfet_0.g.t10 programmable_folded_cascode_0.programmable_pfet_0.g.t11 VDD.t117 pfet_03v3 ad=14.95p pd=47.3u as=14.95p ps=47.3u w=23u l=1u
X147 VSS.t138 programmable_folded_cascode_0.programmable_nfet$3_0.g.t9 programmable_folded_cascode_0.programmable_nfet$3_0.g.t10 VSS.t137 nfet_03v3 ad=16.531p pd=55.42u as=16.531p ps=55.42u w=27.1u l=1u
X148 programmable_folded_cascode_0.programmable_nfet$3_0.transmission_gate$21_1.out.t2 transmission_gate$2$1_6.out.t9 programmable_folded_cascode_0.programmable_nfet$3_0.g.t8 VSS.t416 nfet_03v3 ad=0.2646p pd=2.1u as=0.2646p ps=2.1u w=0.42u l=0.28u
X149 VSS.t165 programmable_folded_cascode_0.EN0.t6 programmable_folded_cascode_0.programmable_nfet_0.transmission_gate$18_0.out VSS.t164 nfet_03v3 ad=0.2646p pd=2.1u as=0.2646p ps=2.1u w=0.42u l=0.28u
X150 VDD.t255 programmable_5tOTA_0.programmable_pfet$4_0.g.t18 programmable_5tOTA_0.programmable_pfet$4_0.g.t19 VDD.t253 pfet_03v3 ad=32.5p pd=0.1013m as=32.5p ps=0.1013m w=50u l=0.5u
X151 OUT_TELESCOPIC.t18 programmable_telescopic_cascode_0.programmable_nfet$4_1.transmission_gate$24_0.out.t4 programmable_telescopic_cascode_0.programmable_nfet$5_1.d.t15 VSS.t120 nfet_03v3 ad=11.7p pd=45.52u as=27.45p ps=91.22u w=45u l=0.4u
X152 programmable_5tOTA_0.programmable_pfet$4_0.g.t26 transmission_gate$2$1_2.out.t8 programmable_5tOTA_0.programmable_pfet$4_1.transmission_gate$27_0.out.t1 VSS.t422 nfet_03v3 ad=0.2646p pd=2.1u as=0.2646p ps=2.1u w=0.42u l=0.28u
X153 a_28168_79808# scan_chain_0.D_ff1_8.D_latch1$1_0.D scan_chain_0.D_ff1_8.D_latch1$1_0.NAND2$2_0.A VSS.t358 nfet_03v3 ad=0.2646p pd=2.1u as=0.2646p ps=2.1u w=0.42u l=0.28u
X154 programmable_telescopic_cascode_0.programmable_nfet$4_0.transmission_gate$24_0.out.t2 transmission_gate$2$1_4.out.t8 programmable_telescopic_cascode_0.programmable_nfet$4_0.g.t8 VSS.t377 nfet_03v3 ad=0.2646p pd=2.1u as=0.2646p ps=2.1u w=0.42u l=0.28u
X155 VDD.t723 programmable_telescopic_cascode_0.programmable_pfet$3_0.transmission_gate$23_1.out.t4 programmable_telescopic_cascode_0.programmable_pfet$3_0.d.t43 VDD.t543 pfet_03v3 ad=26p pd=81.3u as=26p ps=81.3u w=40u l=0.5u
X156 VDD.t118 programmable_folded_cascode_0.programmable_pfet_0.g.t8 programmable_folded_cascode_0.programmable_pfet_0.g.t9 VDD.t117 pfet_03v3 ad=14.95p pd=47.3u as=14.95p ps=47.3u w=23u l=1u
X157 VDD.t454 scan_chain_0.D_ff1_8.D_latch1$1_0.D scan_chain_0.D_ff1_8.D_latch1$1_1.Q_bar VDD.t453 pfet_03v3 ad=0.2822p pd=2.18u as=0.2822p ps=2.18u w=0.42u l=0.28u
X158 a_45880_2844.t66 programmable_folded_cascode_0.programmable_nfet_1.transmission_gate$18_1.out a_55661_23626.t23 VSS.t460 nfet_03v3 ad=7.8p pd=30.52u as=18.3p ps=61.22u w=30u l=0.5u
X159 programmable_telescopic_cascode_0.programmable_nfet$6_0.d.t2 programmable_telescopic_cascode_0.programmable_nfet$5_1.transmission_gate$25_0.out programmable_telescopic_cascode_0.programmable_nfet$5_1.d.t1 VSS.t43 nfet_03v3 ad=18.3p pd=61.22u as=7.8p ps=30.52u w=30u l=0.5u
X160 programmable_telescopic_cascode_0.programmable_nfet$4_0.s.t23 programmable_telescopic_cascode_0.programmable_nfet$4_0.transmission_gate$24_0.out.t5 programmable_telescopic_cascode_0.programmable_pfet$3_0.g.t43 VSS.t428 nfet_03v3 ad=27.45p pd=91.22u as=11.7p ps=45.52u w=45u l=0.4u
X161 VSS.t10 programmable_common_source_0.EN1.t3 programmable_common_source_0.programmable_nfet$9_0.transmission_gate$31_1.out VSS.t9 nfet_03v3 ad=0.2646p pd=2.1u as=0.2646p ps=2.1u w=0.42u l=0.28u
X162 VDD.t67 scan_chain_0.D_ff1_1.inv1$4_0.Y scan_chain_0.D_ff1_1.D_latch1$1_0.NAND2$2_0.A VDD.t66 pfet_03v3 ad=0.2822p pd=2.18u as=0.2822p ps=2.18u w=0.42u l=0.28u
X163 VDD.t19 programmable_common_source_0.EN1.t4 programmable_common_source_0.EN1.t0 VDD.t18 pfet_03v3 ad=0.2822p pd=2.18u as=0.2822p ps=2.18u w=0.42u l=0.28u
X164 scan_chain_0.D_ff1_0.D_latch1$1_1.Q_bar scan_chain_0.D_ff1_0.D_latch1$1_1.NAND2$2_2.B VDD.t358 VDD.t357 pfet_03v3 ad=0.2822p pd=2.18u as=0.2822p ps=2.18u w=0.42u l=0.28u
X165 programmable_telescopic_cascode_0.programmable_nfet$4_0.s.t6 programmable_telescopic_cascode_0.programmable_nfet$4_0.transmission_gate$24_1.out.t3 programmable_telescopic_cascode_0.programmable_pfet$3_0.g.t15 VSS.t142 nfet_03v3 ad=27.45p pd=91.22u as=27.45p ps=91.22u w=45u l=0.4u
X166 INN_5T.t1 transmission_gate$2$1_2.out.t9 programmable_5tOTA_0.programmable_nfet$7_0.transmission_gate$28_1.out VSS.t423 nfet_03v3 ad=0.2646p pd=2.1u as=0.2646p ps=2.1u w=0.42u l=0.28u
X167 programmable_telescopic_cascode_0.programmable_pfet$3_0.g.t44 programmable_telescopic_cascode_0.programmable_nfet$4_0.transmission_gate$24_0.out.t6 programmable_telescopic_cascode_0.programmable_nfet$4_0.s.t22 VSS.t161 nfet_03v3 ad=11.7p pd=45.52u as=27.45p ps=91.22u w=45u l=0.4u
X168 VDD.t132 a_61069_4063.t18 a_61069_4063.t19 VDD.t131 pfet_03v3 ad=14.95p pd=47.3u as=14.95p ps=47.3u w=23u l=1u
X169 a_91570_47942.t29 programmable_5tOTA_0.programmable_nfet$7_0.transmission_gate$28_1.out OUT_5T.t12 VSS.t242 nfet_03v3 ad=6.954p pd=24.02u as=2.964p ps=11.92u w=11.4u l=0.5u
X170 scan_chain_0.D_ff1_5.D_latch1$1_0.NAND2$2_0.A scan_chain_0.D_ff1_5.D_latch1$1_0.D VDD.t436 VDD.t435 pfet_03v3 ad=0.2822p pd=2.18u as=0.2822p ps=2.18u w=0.42u l=0.28u
X171 a_55661_23626.t17 programmable_folded_cascode_0.programmable_nfet$3_0.transmission_gate$21_0.out VSS.t215 VSS.t213 nfet_03v3 ad=12.2p pd=41.22u as=12.2p ps=41.22u w=20u l=1u
X172 a_61069_4063.t6 programmable_folded_cascode_0.programmable_pfet$1_0.g.t18 programmable_folded_cascode_0.programmable_pfet$1_0.g.t19 VDD.t165 pfet_03v3 ad=12.74p pd=40.5u as=12.74p ps=40.5u w=19.6u l=0.5u
X173 a_61069_4063.t5 programmable_folded_cascode_0.programmable_pfet$1_0.g.t16 programmable_folded_cascode_0.programmable_pfet$1_0.g.t17 VDD.t165 pfet_03v3 ad=12.74p pd=40.5u as=12.74p ps=40.5u w=19.6u l=0.5u
X174 programmable_folded_cascode_0.programmable_nfet$1_0.g.t21 programmable_folded_cascode_0.EN0.t7 programmable_folded_cascode_0.programmable_nfet$1_0.transmission_gate$19_0.out VDD.t203 pfet_03v3 ad=0.2822p pd=2.18u as=0.2822p ps=2.18u w=0.42u l=0.28u
X175 programmable_folded_cascode_0.programmable_nfet$1_0.g.t24 programmable_folded_cascode_0.programmable_pfet$1_1.transmission_gate$17_1.out.t5 a_45880_2844.t15 VDD.t208 pfet_03v3 ad=7.696p pd=30.12u as=19.24p ps=60.5u w=29.6u l=0.5u
X176 a_61069_4063.t4 programmable_folded_cascode_0.programmable_pfet$1_0.g.t14 programmable_folded_cascode_0.programmable_pfet$1_0.g.t15 VDD.t165 pfet_03v3 ad=12.74p pd=40.5u as=12.74p ps=40.5u w=19.6u l=0.5u
X177 a_45880_2844.t48 programmable_folded_cascode_0.programmable_pfet_0.g.t23 VDD.t586 VDD.t185 pfet_03v3 ad=22.62p pd=70.9u as=22.62p ps=70.9u w=34.8u l=1u
X178 VDD.t300 scan_chain_0.D_ff1_8.inv1$4_0.Y scan_chain_0.D_ff1_8.D_latch1$1_0.NAND2$2_2.B VDD.t299 pfet_03v3 ad=0.2822p pd=2.18u as=0.2822p ps=2.18u w=0.42u l=0.28u
X179 programmable_telescopic_cascode_0.programmable_nfet$4_0.s.t27 programmable_telescopic_cascode_0.programmable_nfet$5_0.transmission_gate$25_0.out programmable_telescopic_cascode_0.programmable_nfet$6_0.d.t15 VSS.t491 nfet_03v3 ad=7.8p pd=30.52u as=18.3p ps=61.22u w=30u l=0.5u
X180 programmable_5tOTA_0.programmable_nfet$8_0.transmission_gate$29_0.out.t2 programmable_5tOTA_0.ena_bar<0>.t3 IBIAS.t13 VDD.t651 pfet_03v3 ad=0.2822p pd=2.18u as=0.2822p ps=2.18u w=0.42u l=0.28u
X181 a_45880_2844.t60 programmable_folded_cascode_0.programmable_pfet_1.transmission_gate$16_0.out.t5 VDD.t616 VDD.t607 pfet_03v3 ad=22.62p pd=70.9u as=22.62p ps=70.9u w=34.8u l=1u
X182 programmable_folded_cascode_0.programmable_nfet$1_0.g.t10 programmable_folded_cascode_0.programmable_pfet$1_0.g.t31 a_45880_2844.t44 VDD.t363 pfet_03v3 ad=19.24p pd=60.5u as=19.24p ps=60.5u w=29.6u l=0.5u
X183 programmable_folded_cascode_0.OUT.t18 programmable_folded_cascode_0.programmable_nfet$1_0.transmission_gate$19_1.out a_58284_41264.t6 VSS.t364 nfet_03v3 ad=2.73p pd=11.02u as=6.405p ps=22.22u w=10.5u l=0.5u
X184 VDD.t205 programmable_folded_cascode_0.EN0.t8 transmission_gate$2$1_7.out.t0 VDD.t204 pfet_03v3 ad=0.2822p pd=2.18u as=0.2822p ps=2.18u w=0.42u l=0.28u
X185 a_45054_79808# scan_chain_0.D_ff1_2.D_latch1$1_0.NAND2$2_0.A transmission_gate$2$1_2.out.t2 VSS.t133 nfet_03v3 ad=0.2646p pd=2.1u as=0.2646p ps=2.1u w=0.42u l=0.28u
X186 a_48899_79067# scan_chain_0.D_ff1_3.D_latch1$1_1.NAND2$2_2.B VSS.t394 VSS.t393 nfet_03v3 ad=0.2646p pd=2.1u as=0.2646p ps=2.1u w=0.42u l=0.28u
X187 scan_chain_0.D_ff1_0.D_latch1$1_0.NAND2$2_2.B scan_chain_0.D_ff1_0.D_latch1$1_0.inv1$3_0.Y VDD.t354 VDD.t353 pfet_03v3 ad=0.2822p pd=2.18u as=0.2822p ps=2.18u w=0.42u l=0.28u
X188 programmable_telescopic_cascode_0.programmable_pfet$3_1.d.t41 programmable_telescopic_cascode_0.programmable_pfet$3_1.transmission_gate$23_0.out.t3 VDD.t671 VDD.t239 pfet_03v3 ad=10.4p pd=40.52u as=26p ps=81.3u w=40u l=0.5u
X189 a_49197_2844.t6 programmable_folded_cascode_0.programmable_pfet$1_0.transmission_gate$17_1.out.t5 programmable_folded_cascode_0.OUT.t13 VDD.t148 pfet_03v3 ad=19.24p pd=60.5u as=7.696p ps=30.12u w=29.6u l=0.5u
X190 scan_chain_0.D_ff1_6.inv1$4_0.Y CLK.t9 VDD.t581 VDD.t580 pfet_03v3 ad=0.546p pd=2.98u as=0.546p ps=2.98u w=0.84u l=0.28u
X191 a_49197_2844.t14 programmable_folded_cascode_0.programmable_pfet_0.transmission_gate$16_0.out.t3 VDD.t174 VDD.t173 pfet_03v3 ad=22.62p pd=70.9u as=22.62p ps=70.9u w=34.8u l=1u
X192 programmable_telescopic_cascode_0.programmable_pfet$3_1.d.t38 programmable_telescopic_cascode_0.programmable_pfet$2_1.transmission_gate$22_1.out.t5 OUT_TELESCOPIC.t21 VDD.t472 pfet_03v3 ad=30.55p pd=95.3u as=30.55p ps=95.3u w=47u l=0.5u
X193 programmable_telescopic_cascode_0.programmable_nfet$5_1.d.t20 programmable_telescopic_cascode_0.programmable_nfet$4_0.g.t13 OUT_TELESCOPIC.t31 VSS.t189 nfet_03v3 ad=27.45p pd=91.22u as=27.45p ps=91.22u w=45u l=0.4u
X194 programmable_telescopic_cascode_0.programmable_nfet$4_0.g.t0 transmission_gate$2$1_5.out.t6 programmable_telescopic_cascode_0.programmable_nfet$4_1.transmission_gate$24_1.out.t1 VSS.t93 nfet_03v3 ad=0.2646p pd=2.1u as=0.2646p ps=2.1u w=0.42u l=0.28u
X195 scan_chain_0.D_ff1_4.D_latch1$1_1.inv1$3_0.Y programmable_common_source_0.EN0.t8 VDD.t412 VDD.t411 pfet_03v3 ad=0.546p pd=2.98u as=0.546p ps=2.98u w=0.84u l=0.28u
X196 VDD.t665 SCAN_OUT.t3 scan_chain_0.D_ff1_0.Q_bar VDD.t664 pfet_03v3 ad=0.2822p pd=2.18u as=0.2822p ps=2.18u w=0.42u l=0.28u
X197 scan_chain_0.D_ff1_5.inv1$4_0.Y CLK.t10 VDD.t389 VDD.t388 pfet_03v3 ad=0.546p pd=2.98u as=0.546p ps=2.98u w=0.84u l=0.28u
X198 transmission_gate$2$1_5.out.t3 transmission_gate$2$1_7.ena VSS.t354 VSS.t353 nfet_03v3 ad=0.2646p pd=2.1u as=0.2646p ps=2.1u w=0.42u l=0.28u
X199 VDD.t226 transmission_gate$2$1_7.out.t9 programmable_folded_cascode_0.programmable_pfet_0.transmission_gate$16_0.out.t2 VDD.t225 pfet_03v3 ad=0.2822p pd=2.18u as=0.2822p ps=2.18u w=0.42u l=0.28u
X200 VSS.t168 IBIAS.t15 programmable_telescopic_cascode_0.programmable_nfet$6_0.d.t5 VSS.t167 nfet_03v3 ad=16.531p pd=55.42u as=16.531p ps=55.42u w=27.1u l=1u
X201 IBIAS.t3 programmable_common_source_0.EN1.t5 programmable_common_source_0.programmable_nfet$9_0.transmission_gate$31_1.out VSS.t84 nfet_03v3 ad=0.2646p pd=2.1u as=0.2646p ps=2.1u w=0.42u l=0.28u
X202 VSS.t489 programmable_5tOTA_0.ena_bar<0>.t4 a_37353_79808# VSS.t488 nfet_03v3 ad=0.2646p pd=2.1u as=0.2646p ps=2.1u w=0.42u l=0.28u
X203 programmable_telescopic_cascode_0.programmable_nfet$5_1.d.t8 programmable_telescopic_cascode_0.programmable_nfet$4_1.transmission_gate$24_1.out.t4 OUT_TELESCOPIC.t6 VSS.t145 nfet_03v3 ad=27.45p pd=91.22u as=27.45p ps=91.22u w=45u l=0.4u
X204 VDD.t177 programmable_telescopic_cascode_0.programmable_pfet$3_0.g.t54 programmable_telescopic_cascode_0.programmable_pfet$3_0.d.t22 VDD.t155 pfet_03v3 ad=26p pd=81.3u as=26p ps=81.3u w=40u l=0.5u
X205 VSS.t280 CLK.t11 a_1210_79067# VSS.t279 nfet_03v3 ad=0.2646p pd=2.1u as=0.2646p ps=2.1u w=0.42u l=0.28u
X206 scan_chain_0.D_ff1_5.D_latch1$1_1.Q_bar scan_chain_0.D_ff1_5.D_latch1$1_0.D a_2693_79067# VSS.t331 nfet_03v3 ad=0.2646p pd=2.1u as=0.2646p ps=2.1u w=0.42u l=0.28u
X207 programmable_telescopic_cascode_0.programmable_pfet$3_1.d.t14 programmable_telescopic_cascode_0.programmable_pfet$2_1.transmission_gate$22_0.out.t4 OUT_TELESCOPIC.t39 VDD.t477 pfet_03v3 ad=30.55p pd=95.3u as=12.22p ps=47.52u w=47u l=0.5u
X208 a_49197_2844.t15 programmable_folded_cascode_0.programmable_pfet_0.g.t24 VDD.t184 VDD.t183 pfet_03v3 ad=22.62p pd=70.9u as=22.62p ps=70.9u w=34.8u l=1u
X209 programmable_folded_cascode_0.programmable_nfet$1_0.g.t9 programmable_folded_cascode_0.programmable_pfet$1_0.g.t32 a_45880_2844.t40 VDD.t361 pfet_03v3 ad=19.24p pd=60.5u as=19.24p ps=60.5u w=29.6u l=0.5u
X210 transmission_gate$2$1_3.out.t3 transmission_gate$2$1_7.ena VSS.t352 VSS.t351 nfet_03v3 ad=0.2646p pd=2.1u as=0.2646p ps=2.1u w=0.42u l=0.28u
X211 a_29651_79067# scan_chain_0.D_ff1_8.D_latch1$1_0.NAND2$2_2.B VSS.t274 VSS.t273 nfet_03v3 ad=0.2646p pd=2.1u as=0.2646p ps=2.1u w=0.42u l=0.28u
X212 a_60455_79067# scan_chain_0.D_ff1_4.D_latch1$1_0.NAND2$2_2.B VSS.t399 VSS.t398 nfet_03v3 ad=0.2646p pd=2.1u as=0.2646p ps=2.1u w=0.42u l=0.28u
X213 a_45880_2844.t34 programmable_folded_cascode_0.programmable_pfet_1.transmission_gate$16_1.out.t8 VDD.t340 VDD.t321 pfet_03v3 ad=9.048p pd=35.32u as=22.62p ps=70.9u w=34.8u l=1u
X214 a_51271_79067# scan_chain_0.D_ff1_3.D_latch1$1_0.inv1$3_0.Y scan_chain_0.D_ff1_3.D_latch1$1_0.NAND2$2_2.B VSS.t395 nfet_03v3 ad=0.2646p pd=2.1u as=0.2646p ps=2.1u w=0.42u l=0.28u
X215 VDD.t391 CLK.t12 scan_chain_0.D_ff1_8.D_latch1$1_1.NAND2$2_0.A VDD.t390 pfet_03v3 ad=0.2822p pd=2.18u as=0.2822p ps=2.18u w=0.42u l=0.28u
X216 scan_chain_0.D_ff1_1.D_latch1$1_1.inv1$3_0.Y transmission_gate$2$1_4.out.t9 VSS.t376 VSS.t375 nfet_03v3 ad=0.2646p pd=2.1u as=0.2646p ps=2.1u w=0.42u l=0.28u
X217 programmable_folded_cascode_0.programmable_nfet$1_0.transmission_gate$19_1.out programmable_folded_cascode_0.EN1.t5 VSS.t503 VSS.t502 nfet_03v3 ad=0.2646p pd=2.1u as=0.2646p ps=2.1u w=0.42u l=0.28u
X218 a_45880_2844.t61 programmable_folded_cascode_0.programmable_pfet_1.transmission_gate$16_0.out.t6 VDD.t617 VDD.t607 pfet_03v3 ad=22.62p pd=70.9u as=22.62p ps=70.9u w=34.8u l=1u
X219 INP_FOLDED.t1 transmission_gate$2$1_7.out.t10 programmable_folded_cascode_0.programmable_nfet_1.transmission_gate$18_0.out VSS.t182 nfet_03v3 ad=0.2646p pd=2.1u as=0.2646p ps=2.1u w=0.42u l=0.28u
X220 scan_chain_0.D_ff1_1.D_latch1$1_0.inv1$3_0.Y scan_chain_0.D_ff1_1.D_latch1$1_0.D VDD.t320 VDD.t319 pfet_03v3 ad=0.546p pd=2.98u as=0.546p ps=2.98u w=0.84u l=0.28u
X221 VDD.t24 programmable_telescopic_cascode_0.programmable_pfet$3_1.transmission_gate$23_1.out.t4 programmable_telescopic_cascode_0.programmable_pfet$3_1.d.t1 VDD.t22 pfet_03v3 ad=26p pd=81.3u as=26p ps=81.3u w=40u l=0.5u
X222 programmable_5tOTA_0.programmable_pfet$4_0.g.t7 INP_5T.t4 a_91570_47942.t13 VSS.t139 nfet_03v3 ad=6.954p pd=24.02u as=6.954p ps=24.02u w=11.4u l=0.5u
X223 scan_chain_0.D_ff1_0.D_latch1$1_1.NAND2$2_0.A programmable_common_source_0.EN1.t6 VDD.t106 VDD.t105 pfet_03v3 ad=0.2822p pd=2.18u as=0.2822p ps=2.18u w=0.42u l=0.28u
X224 programmable_folded_cascode_0.programmable_nfet$1_0.g.t25 programmable_folded_cascode_0.programmable_pfet$1_1.transmission_gate$17_1.out.t6 a_45880_2844.t16 VDD.t209 pfet_03v3 ad=7.696p pd=30.12u as=19.24p ps=60.5u w=29.6u l=0.5u
X225 programmable_folded_cascode_0.programmable_pfet$1_1.transmission_gate$17_1.out.t1 transmission_gate$2$1_6.out.t10 programmable_folded_cascode_0.programmable_pfet$1_0.g.t25 VSS.t417 nfet_03v3 ad=0.2646p pd=2.1u as=0.2646p ps=2.1u w=0.42u l=0.28u
X226 programmable_telescopic_cascode_0.programmable_nfet$4_0.s.t12 programmable_telescopic_cascode_0.programmable_nfet$4_0.g.t14 programmable_telescopic_cascode_0.programmable_pfet$3_0.g.t29 VSS.t190 nfet_03v3 ad=27.45p pd=91.22u as=27.45p ps=91.22u w=45u l=0.4u
X227 programmable_common_source_0.EN0.t0 programmable_common_source_0.EN0.t9 a_52754_79067# VSS.t302 nfet_03v3 ad=0.2646p pd=2.1u as=0.2646p ps=2.1u w=0.42u l=0.28u
X228 programmable_telescopic_cascode_0.programmable_pfet$3_1.d.t13 programmable_telescopic_cascode_0.programmable_pfet$2_1.transmission_gate$22_0.out.t5 OUT_TELESCOPIC.t40 VDD.t477 pfet_03v3 ad=30.55p pd=95.3u as=12.22p ps=47.52u w=47u l=0.5u
X229 programmable_folded_cascode_0.programmable_nfet$2_1.transmission_gate$20_1.out programmable_folded_cascode_0.EN1.t6 programmable_folded_cascode_0.programmable_nfet$2_0.g.t6 VDD.t677 pfet_03v3 ad=0.2822p pd=2.18u as=0.2822p ps=2.18u w=0.42u l=0.28u
X230 programmable_telescopic_cascode_0.programmable_nfet$4_0.transmission_gate$24_0.out.t1 programmable_telescopic_cascode_0.EN1.t6 programmable_telescopic_cascode_0.programmable_nfet$4_0.g.t4 VDD.t154 pfet_03v3 ad=0.2822p pd=2.18u as=0.2822p ps=2.18u w=0.42u l=0.28u
X231 OUT_TELESCOPIC.t32 programmable_telescopic_cascode_0.programmable_nfet$4_1.transmission_gate$24_0.out.t5 programmable_telescopic_cascode_0.programmable_nfet$5_1.d.t22 VSS.t120 nfet_03v3 ad=11.7p pd=45.52u as=27.45p ps=91.22u w=45u l=0.4u
X232 programmable_folded_cascode_0.programmable_pfet_1.transmission_gate$16_1.out.t1 programmable_folded_cascode_0.EN1.t7 programmable_folded_cascode_0.programmable_pfet_0.g.t15 VDD.t678 pfet_03v3 ad=0.2822p pd=2.18u as=0.2822p ps=2.18u w=0.42u l=0.28u
X233 VDD.t589 programmable_folded_cascode_0.programmable_pfet_0.g.t6 programmable_folded_cascode_0.programmable_pfet_0.g.t7 VDD.t117 pfet_03v3 ad=14.95p pd=47.3u as=14.95p ps=47.3u w=23u l=1u
X234 VSS.t525 programmable_5tOTA_0.ena_bar<1>.t4 programmable_5tOTA_0.programmable_nfet$7_1.transmission_gate$28_1.out VSS.t524 nfet_03v3 ad=0.2646p pd=2.1u as=0.2646p ps=2.1u w=0.42u l=0.28u
X235 VSS.t160 scan_chain_0.D_ff1_2.inv1$4_0.Y a_43570_79067# VSS.t159 nfet_03v3 ad=0.2646p pd=2.1u as=0.2646p ps=2.1u w=0.42u l=0.28u
X236 programmable_folded_cascode_0.programmable_nfet$2_0.g.t3 transmission_gate$2$1_7.out.t11 programmable_folded_cascode_0.programmable_nfet$2_1.transmission_gate$20_0.out VSS.t183 nfet_03v3 ad=0.2646p pd=2.1u as=0.2646p ps=2.1u w=0.42u l=0.28u
X237 VSS.t156 programmable_folded_cascode_0.programmable_nfet$2_0.transmission_gate$20_1.out a_58284_41264.t2 VSS.t155 nfet_03v3 ad=12.505p pd=42.22u as=5.33p ps=21.02u w=20.5u l=1u
X238 transmission_gate$2$1_5.out.t0 PROG_ENA.t1 VSS.t70 VDD.t84 pfet_03v3 ad=0.2822p pd=2.18u as=0.2822p ps=2.18u w=0.42u l=0.28u
X239 scan_chain_0.D_ff1_2.inv1$4_0.Y CLK.t13 VSS.t282 VSS.t281 nfet_03v3 ad=0.2646p pd=2.1u as=0.2646p ps=2.1u w=0.42u l=0.28u
X240 programmable_telescopic_cascode_0.programmable_pfet$3_0.d.t7 programmable_telescopic_cascode_0.programmable_pfet$3_0.transmission_gate$23_0.out.t4 VDD.t110 VDD.t99 pfet_03v3 ad=10.4p pd=40.52u as=26p ps=81.3u w=40u l=0.5u
X241 programmable_telescopic_cascode_0.programmable_nfet$6_0.d.t12 programmable_telescopic_cascode_0.programmable_nfet$6_0.transmission_gate$26_0.out.t4 VSS.t100 VSS.t99 nfet_03v3 ad=7.046p pd=27.62u as=16.531p ps=55.42u w=27.1u l=1u
X242 a_61069_4063.t3 programmable_folded_cascode_0.programmable_pfet$1_0.g.t12 programmable_folded_cascode_0.programmable_pfet$1_0.g.t13 VDD.t165 pfet_03v3 ad=12.74p pd=40.5u as=12.74p ps=40.5u w=19.6u l=0.5u
X243 a_61069_4063.t2 programmable_folded_cascode_0.programmable_pfet$1_0.g.t10 programmable_folded_cascode_0.programmable_pfet$1_0.g.t11 VDD.t165 pfet_03v3 ad=12.74p pd=40.5u as=12.74p ps=40.5u w=19.6u l=0.5u
X244 programmable_folded_cascode_0.programmable_nfet$1_0.transmission_gate$19_1.out transmission_gate$2$1_6.out.t11 programmable_folded_cascode_0.programmable_nfet$1_0.g.t19 VSS.t406 nfet_03v3 ad=0.2646p pd=2.1u as=0.2646p ps=2.1u w=0.42u l=0.28u
X245 VDD.t625 scan_chain_0.D_ff1_4.D_latch1$1_1.Q_bar scan_chain_0.D_ff1_4.D_latch1$1_0.D VDD.t624 pfet_03v3 ad=0.2822p pd=2.18u as=0.2822p ps=2.18u w=0.42u l=0.28u
X246 a_25797_79808# scan_chain_0.D_ff1_8.D_latch1$1_1.NAND2$2_0.A scan_chain_0.D_ff1_8.D_latch1$1_0.D VSS.t263 nfet_03v3 ad=0.2646p pd=2.1u as=0.2646p ps=2.1u w=0.42u l=0.28u
X247 scan_chain_0.D_ff1_7.D_latch1$1_0.NAND2$2_0.A scan_chain_0.D_ff1_7.D_latch1$1_0.D VDD.t378 VDD.t377 pfet_03v3 ad=0.2822p pd=2.18u as=0.2822p ps=2.18u w=0.42u l=0.28u
X248 programmable_telescopic_cascode_0.programmable_pfet$3_0.g.t17 programmable_telescopic_cascode_0.EN0.t6 programmable_telescopic_cascode_0.programmable_pfet$3_0.transmission_gate$23_1.out.t2 VDD.t245 pfet_03v3 ad=0.2822p pd=2.18u as=0.2822p ps=2.18u w=0.42u l=0.28u
X249 programmable_telescopic_cascode_0.programmable_pfet$3_0.d.t35 programmable_telescopic_cascode_0.programmable_pfet$2_0.transmission_gate$22_0.out.t3 programmable_telescopic_cascode_0.programmable_pfet$3_0.g.t39 VDD.t623 pfet_03v3 ad=30.55p pd=95.3u as=12.22p ps=47.52u w=47u l=0.5u
X250 scan_chain_0.D_ff1_6.D_latch1$1_0.D scan_chain_0.D_ff1_6.D_latch1$1_1.NAND2$2_0.A VDD.t116 VDD.t115 pfet_03v3 ad=0.2822p pd=2.18u as=0.2822p ps=2.18u w=0.42u l=0.28u
X251 a_49197_2844.t67 programmable_folded_cascode_0.programmable_pfet_0.transmission_gate$16_0.out.t4 VDD.t689 VDD.t173 pfet_03v3 ad=22.62p pd=70.9u as=22.62p ps=70.9u w=34.8u l=1u
X252 VDD.t393 CLK.t14 scan_chain_0.D_ff1_0.D_latch1$1_1.NAND2$2_2.B VDD.t392 pfet_03v3 ad=0.2822p pd=2.18u as=0.2822p ps=2.18u w=0.42u l=0.28u
X253 VDD.t247 programmable_telescopic_cascode_0.EN0.t7 transmission_gate$2$1_5.out.t4 VDD.t246 pfet_03v3 ad=0.2822p pd=2.18u as=0.2822p ps=2.18u w=0.42u l=0.28u
X254 transmission_gate$2$1_3.out.t0 PROG_ENA.t2 VSS.t71 VDD.t85 pfet_03v3 ad=0.2822p pd=2.18u as=0.2822p ps=2.18u w=0.42u l=0.28u
X255 a_55661_23626.t9 programmable_folded_cascode_0.programmable_nfet$3_0.transmission_gate$21_1.out.t3 VSS.t49 VSS.t48 nfet_03v3 ad=5.2p pd=20.52u as=12.2p ps=41.22u w=20u l=1u
X256 VSS.t284 CLK.t15 a_32014_79808# VSS.t283 nfet_03v3 ad=0.2646p pd=2.1u as=0.2646p ps=2.1u w=0.42u l=0.28u
X257 VDD.t370 scan_chain_0.D_ff1_3.D_latch1$1_0.D scan_chain_0.D_ff1_3.D_latch1$1_1.Q_bar VDD.t369 pfet_03v3 ad=0.2822p pd=2.18u as=0.2822p ps=2.18u w=0.42u l=0.28u
X258 VDD.t503 programmable_common_source_0.programmable_pfet$5_0.transmission_gate$30_0.out.t7 OUT_CS.t36 VDD.t461 pfet_03v3 ad=5.98p pd=19.7u as=2.392p ps=9.72u w=9.2u l=1u
X259 programmable_folded_cascode_0.programmable_nfet$1_0.g.t26 programmable_folded_cascode_0.programmable_pfet$1_1.transmission_gate$17_1.out.t7 a_45880_2844.t17 VDD.t208 pfet_03v3 ad=7.696p pd=30.12u as=19.24p ps=60.5u w=29.6u l=0.5u
X260 VDD.t672 programmable_telescopic_cascode_0.programmable_pfet$3_1.transmission_gate$23_0.out.t4 programmable_telescopic_cascode_0.programmable_pfet$3_1.d.t42 VDD.t237 pfet_03v3 ad=26p pd=81.3u as=10.4p ps=40.52u w=40u l=0.5u
X261 programmable_5tOTA_0.programmable_pfet$4_1.transmission_gate$27_1.out.t1 transmission_gate$2$1_3.out.t9 VDD.t485 VDD.t484 pfet_03v3 ad=0.2822p pd=2.18u as=0.2822p ps=2.18u w=0.42u l=0.28u
X262 scan_chain_0.D_ff1_5.D_latch1$1_0.inv1$3_0.Y scan_chain_0.D_ff1_5.D_latch1$1_0.D VSS.t330 VSS.t329 nfet_03v3 ad=0.2646p pd=2.1u as=0.2646p ps=2.1u w=0.42u l=0.28u
X263 scan_chain_0.D_ff1_6.D_latch1$1_0.NAND2$2_2.B scan_chain_0.D_ff1_6.D_latch1$1_0.inv1$3_0.Y VDD.t125 VDD.t124 pfet_03v3 ad=0.2822p pd=2.18u as=0.2822p ps=2.18u w=0.42u l=0.28u
X264 INN_TELESCOPIC.t1 transmission_gate$2$1_5.out.t7 programmable_telescopic_cascode_0.programmable_nfet$5_1.transmission_gate$25_1.out VSS.t94 nfet_03v3 ad=0.2646p pd=2.1u as=0.2646p ps=2.1u w=0.42u l=0.28u
X265 a_45880_2844.t12 programmable_folded_cascode_0.programmable_pfet_0.g.t25 VDD.t186 VDD.t185 pfet_03v3 ad=22.62p pd=70.9u as=22.62p ps=70.9u w=34.8u l=1u
X266 scan_chain_0.D_ff1_5.D_latch1$1_0.D scan_chain_0.D_ff1_5.D_latch1$1_1.NAND2$2_0.A VDD.t372 VDD.t371 pfet_03v3 ad=0.2822p pd=2.18u as=0.2822p ps=2.18u w=0.42u l=0.28u
X267 VDD.t657 scan_chain_0.D_ff1_4.inv1$4_0.Y scan_chain_0.D_ff1_4.D_latch1$1_0.NAND2$2_0.A VDD.t656 pfet_03v3 ad=0.2822p pd=2.18u as=0.2822p ps=2.18u w=0.42u l=0.28u
X268 programmable_folded_cascode_0.programmable_nfet$3_0.g.t0 programmable_folded_cascode_0.EN0.t9 programmable_folded_cascode_0.programmable_nfet$3_0.transmission_gate$21_0.out VDD.t206 pfet_03v3 ad=0.2822p pd=2.18u as=0.2822p ps=2.18u w=0.42u l=0.28u
X269 VDD.t504 programmable_common_source_0.programmable_pfet$5_0.transmission_gate$30_0.out.t8 OUT_CS.t37 VDD.t461 pfet_03v3 ad=5.98p pd=19.7u as=2.392p ps=9.72u w=9.2u l=1u
X270 VDD.t505 programmable_common_source_0.programmable_pfet$5_0.transmission_gate$30_0.out.t9 OUT_CS.t38 VDD.t461 pfet_03v3 ad=5.98p pd=19.7u as=2.392p ps=9.72u w=9.2u l=1u
X271 programmable_telescopic_cascode_0.programmable_nfet$6_0.transmission_gate$26_0.out.t1 transmission_gate$2$1_4.out.t10 IBIAS.t12 VSS.t374 nfet_03v3 ad=0.2646p pd=2.1u as=0.2646p ps=2.1u w=0.42u l=0.28u
X272 programmable_telescopic_cascode_0.programmable_pfet$3_0.g.t40 programmable_telescopic_cascode_0.programmable_pfet$2_0.transmission_gate$22_0.out.t4 programmable_telescopic_cascode_0.programmable_pfet$3_0.d.t36 VDD.t622 pfet_03v3 ad=12.22p pd=47.52u as=30.55p ps=95.3u w=47u l=0.5u
X273 INP_FOLDED.t0 programmable_folded_cascode_0.EN0.t10 programmable_folded_cascode_0.programmable_nfet_1.transmission_gate$18_0.out VDD.t207 pfet_03v3 ad=0.2822p pd=2.18u as=0.2822p ps=2.18u w=0.42u l=0.28u
X274 VDD.t532 transmission_gate$2$1_6.out.t12 programmable_folded_cascode_0.EN1.t1 VDD.t531 pfet_03v3 ad=0.2822p pd=2.18u as=0.2822p ps=2.18u w=0.42u l=0.28u
X275 VDD.t302 scan_chain_0.D_ff1_7.inv1$4_0.Y scan_chain_0.D_ff1_7.D_latch1$1_0.NAND2$2_2.B VDD.t301 pfet_03v3 ad=0.2822p pd=2.18u as=0.2822p ps=2.18u w=0.42u l=0.28u
X276 VDD.t25 programmable_telescopic_cascode_0.programmable_pfet$3_1.transmission_gate$23_1.out.t5 programmable_telescopic_cascode_0.programmable_pfet$3_1.d.t2 VDD.t22 pfet_03v3 ad=26p pd=81.3u as=26p ps=81.3u w=40u l=0.5u
X277 OUT_CS.t39 programmable_common_source_0.programmable_pfet$5_0.transmission_gate$30_0.out.t10 VDD.t506 VDD.t465 pfet_03v3 ad=2.392p pd=9.72u as=5.98p ps=19.7u w=9.2u l=1u
X278 VDD.t178 programmable_telescopic_cascode_0.programmable_pfet$3_0.g.t55 programmable_telescopic_cascode_0.programmable_pfet$3_1.d.t34 VDD.t160 pfet_03v3 ad=26p pd=81.3u as=26p ps=81.3u w=40u l=0.5u
X279 a_49197_2844.t16 programmable_folded_cascode_0.programmable_pfet_0.g.t26 VDD.t188 VDD.t187 pfet_03v3 ad=22.62p pd=70.9u as=22.62p ps=70.9u w=34.8u l=1u
X280 a_49197_2844.t37 programmable_folded_cascode_0.programmable_pfet_0.transmission_gate$16_1.out.t7 VDD.t229 VDD.t57 pfet_03v3 ad=9.048p pd=35.32u as=22.62p ps=70.9u w=34.8u l=1u
X281 a_41198_79067# scan_chain_0.D_ff1_2.D_latch1$1_1.NAND2$2_2.B VSS.t318 VSS.t317 nfet_03v3 ad=0.2646p pd=2.1u as=0.2646p ps=2.1u w=0.42u l=0.28u
X282 scan_chain_0.D_ff1_8.D_latch1$1_0.NAND2$2_2.B scan_chain_0.D_ff1_8.D_latch1$1_0.inv1$3_0.Y VDD.t450 VDD.t449 pfet_03v3 ad=0.2822p pd=2.18u as=0.2822p ps=2.18u w=0.42u l=0.28u
X283 programmable_telescopic_cascode_0.programmable_nfet$5_1.d.t19 programmable_telescopic_cascode_0.programmable_nfet$4_0.g.t15 OUT_TELESCOPIC.t30 VSS.t189 nfet_03v3 ad=27.45p pd=91.22u as=27.45p ps=91.22u w=45u l=0.4u
X284 programmable_folded_cascode_0.OUT.t19 programmable_folded_cascode_0.programmable_pfet$1_0.transmission_gate$17_0.out.t3 a_49197_2844.t62 VDD.t647 pfet_03v3 ad=19.24p pd=60.5u as=19.24p ps=60.5u w=29.6u l=0.5u
X285 VDD.t590 programmable_5tOTA_0.programmable_pfet$4_1.transmission_gate$27_1.out.t3 OUT_5T.t16 VDD.t307 pfet_03v3 ad=32.5p pd=0.1013m as=32.5p ps=0.1013m w=50u l=0.5u
X286 OUT_5T.t5 INN_5T.t5 a_91570_47942.t22 VSS.t228 nfet_03v3 ad=6.954p pd=24.02u as=6.954p ps=24.02u w=11.4u l=0.5u
X287 programmable_telescopic_cascode_0.programmable_pfet$3_0.d.t37 programmable_telescopic_cascode_0.programmable_pfet$2_0.transmission_gate$22_0.out.t5 programmable_telescopic_cascode_0.programmable_pfet$3_0.g.t41 VDD.t623 pfet_03v3 ad=30.55p pd=95.3u as=12.22p ps=47.52u w=47u l=0.5u
X288 a_49197_2844.t5 INN_FOLDED.t4 a_55661_23626.t8 VSS.t148 nfet_03v3 ad=18.3p pd=61.22u as=18.3p ps=61.22u w=30u l=0.5u
X289 VSS.t278 scan_chain_0.D_ff1_3.inv1$4_0.Y a_51271_79808# VSS.t277 nfet_03v3 ad=0.2646p pd=2.1u as=0.2646p ps=2.1u w=0.42u l=0.28u
X290 a_5065_79808# scan_chain_0.D_ff1_5.D_latch1$1_0.D scan_chain_0.D_ff1_5.D_latch1$1_0.NAND2$2_0.A VSS.t328 nfet_03v3 ad=0.2646p pd=2.1u as=0.2646p ps=2.1u w=0.42u l=0.28u
X291 programmable_telescopic_cascode_0.programmable_nfet$5_0.transmission_gate$25_0.out programmable_telescopic_cascode_0.EN1.t7 VSS.t476 VSS.t475 nfet_03v3 ad=0.2646p pd=2.1u as=0.2646p ps=2.1u w=0.42u l=0.28u
X292 programmable_telescopic_cascode_0.programmable_pfet$3_0.d.t8 programmable_telescopic_cascode_0.programmable_pfet$3_0.transmission_gate$23_0.out.t5 VDD.t111 VDD.t99 pfet_03v3 ad=10.4p pd=40.52u as=26p ps=81.3u w=40u l=0.5u
X293 programmable_common_source_0.EN0.t4 scan_chain_0.D_ff1_3.D_latch1$1_0.NAND2$2_0.A VDD.t644 VDD.t643 pfet_03v3 ad=0.2822p pd=2.18u as=0.2822p ps=2.18u w=0.42u l=0.28u
X294 programmable_telescopic_cascode_0.programmable_nfet$4_0.s.t7 programmable_telescopic_cascode_0.programmable_nfet$4_0.transmission_gate$24_1.out.t4 programmable_telescopic_cascode_0.programmable_pfet$3_0.g.t16 VSS.t142 nfet_03v3 ad=27.45p pd=91.22u as=27.45p ps=91.22u w=45u l=0.4u
X295 VSS.t124 programmable_common_source_0.programmable_nfet$9_0.transmission_gate$31_1.out OUT_CS.t1 VSS.t123 nfet_03v3 ad=16.531p pd=55.42u as=7.046p ps=27.62u w=27.1u l=1u
X296 VSS.t478 programmable_telescopic_cascode_0.EN1.t8 a_29652_79808# VSS.t477 nfet_03v3 ad=0.2646p pd=2.1u as=0.2646p ps=2.1u w=0.42u l=0.28u
X297 a_55117_79067# scan_chain_0.D_ff1_4.D_latch1$1_1.inv1$3_0.Y scan_chain_0.D_ff1_4.D_latch1$1_1.NAND2$2_2.B VSS.t63 nfet_03v3 ad=0.2646p pd=2.1u as=0.2646p ps=2.1u w=0.42u l=0.28u
X298 a_61069_4063.t1 programmable_folded_cascode_0.programmable_pfet$1_0.g.t8 programmable_folded_cascode_0.programmable_pfet$1_0.g.t9 VDD.t165 pfet_03v3 ad=12.74p pd=40.5u as=12.74p ps=40.5u w=19.6u l=0.5u
X299 programmable_folded_cascode_0.programmable_nfet$3_0.g.t6 transmission_gate$2$1_7.out.t12 programmable_folded_cascode_0.programmable_nfet$3_0.transmission_gate$21_0.out VSS.t184 nfet_03v3 ad=0.2646p pd=2.1u as=0.2646p ps=2.1u w=0.42u l=0.28u
X300 programmable_telescopic_cascode_0.programmable_nfet$4_0.g.t1 transmission_gate$2$1_5.out.t8 programmable_telescopic_cascode_0.programmable_nfet$4_0.transmission_gate$24_1.out.t0 VSS.t95 nfet_03v3 ad=0.2646p pd=2.1u as=0.2646p ps=2.1u w=0.42u l=0.28u
X301 programmable_telescopic_cascode_0.programmable_nfet$6_0.d.t4 programmable_telescopic_cascode_0.programmable_nfet$5_1.transmission_gate$25_1.out programmable_telescopic_cascode_0.programmable_nfet$5_1.d.t2 VSS.t92 nfet_03v3 ad=18.3p pd=61.22u as=18.3p ps=61.22u w=30u l=0.5u
X302 VSS.t29 programmable_5tOTA_0.programmable_nfet$8_0.transmission_gate$29_1.out.t3 a_91570_47942.t0 VSS.t28 nfet_03v3 ad=13.908p pd=46.82u as=5.928p ps=23.32u w=22.8u l=1u
X303 VDD.t135 a_61069_4063.t21 programmable_folded_cascode_0.programmable_nfet$3_0.g.t4 VDD.t133 pfet_03v3 ad=14.95p pd=47.3u as=14.95p ps=47.3u w=23u l=1u
X304 programmable_telescopic_cascode_0.programmable_pfet$3_0.g.t42 programmable_telescopic_cascode_0.programmable_pfet$2_0.transmission_gate$22_0.out.t6 programmable_telescopic_cascode_0.programmable_pfet$3_0.d.t38 VDD.t622 pfet_03v3 ad=12.22p pd=47.52u as=30.55p ps=95.3u w=47u l=0.5u
X305 OUT_5T.t11 programmable_5tOTA_0.programmable_nfet$7_0.transmission_gate$28_1.out a_91570_47942.t28 VSS.t243 nfet_03v3 ad=2.964p pd=11.92u as=6.954p ps=24.02u w=11.4u l=0.5u
X306 VSS.t453 scan_chain_0.D_ff1_0.inv1$4_0.Y a_66673_79808# VSS.t452 nfet_03v3 ad=0.2646p pd=2.1u as=0.2646p ps=2.1u w=0.42u l=0.28u
X307 VDD.t588 programmable_folded_cascode_0.programmable_pfet_0.g.t4 programmable_folded_cascode_0.programmable_pfet_0.g.t5 VDD.t117 pfet_03v3 ad=14.95p pd=47.3u as=14.95p ps=47.3u w=23u l=1u
X308 a_45880_2844.t62 programmable_folded_cascode_0.programmable_pfet_1.transmission_gate$16_0.out.t7 VDD.t618 VDD.t607 pfet_03v3 ad=22.62p pd=70.9u as=22.62p ps=70.9u w=34.8u l=1u
X309 scan_chain_0.D_ff1_6.D_latch1$1_1.Q_bar scan_chain_0.D_ff1_6.D_latch1$1_0.D a_10394_79067# VSS.t533 nfet_03v3 ad=0.2646p pd=2.1u as=0.2646p ps=2.1u w=0.42u l=0.28u
X310 programmable_telescopic_cascode_0.programmable_pfet$3_1.transmission_gate$23_0.out.t1 transmission_gate$2$1_4.out.t11 programmable_telescopic_cascode_0.programmable_pfet$3_0.g.t24 VSS.t373 nfet_03v3 ad=0.2646p pd=2.1u as=0.2646p ps=2.1u w=0.42u l=0.28u
X311 VDD.t339 programmable_folded_cascode_0.programmable_pfet_1.transmission_gate$16_1.out.t9 a_45880_2844.t33 VDD.t329 pfet_03v3 ad=22.62p pd=70.9u as=9.048p ps=35.32u w=34.8u l=1u
X312 programmable_5tOTA_0.programmable_nfet$7_1.transmission_gate$28_0.out programmable_5tOTA_0.ena_bar<0>.t5 INP_5T.t2 VDD.t652 pfet_03v3 ad=0.2822p pd=2.18u as=0.2822p ps=2.18u w=0.42u l=0.28u
X313 a_32014_79067# scan_chain_0.D_ff1_1.D_latch1$1_1.inv1$3_0.Y scan_chain_0.D_ff1_1.D_latch1$1_1.NAND2$2_2.B VSS.t498 nfet_03v3 ad=0.2646p pd=2.1u as=0.2646p ps=2.1u w=0.42u l=0.28u
X314 programmable_5tOTA_0.ena_bar<1>.t0 scan_chain_0.D_ff1_2.D_latch1$1_0.NAND2$2_2.B VDD.t130 VDD.t129 pfet_03v3 ad=0.2822p pd=2.18u as=0.2822p ps=2.18u w=0.42u l=0.28u
X315 a_49197_2844.t51 programmable_folded_cascode_0.programmable_pfet_0.transmission_gate$16_0.out.t5 VDD.t519 VDD.t518 pfet_03v3 ad=22.62p pd=70.9u as=22.62p ps=70.9u w=34.8u l=1u
X316 programmable_folded_cascode_0.programmable_nfet$1_0.g.t0 programmable_folded_cascode_0.programmable_pfet$1_1.transmission_gate$17_0.out.t3 a_45880_2844.t0 VDD.t20 pfet_03v3 ad=19.24p pd=60.5u as=19.24p ps=60.5u w=29.6u l=0.5u
X317 scan_chain_0.D_ff1_8.inv1$4_0.Y CLK.t16 VDD.t395 VDD.t394 pfet_03v3 ad=0.546p pd=2.98u as=0.546p ps=2.98u w=0.84u l=0.28u
X318 VDD.t278 IN_CS.t8 OUT_CS.t7 VDD.t274 pfet_03v3 ad=5.98p pd=19.7u as=5.98p ps=19.7u w=9.2u l=1u
X319 programmable_folded_cascode_0.programmable_nfet$2_0.transmission_gate$20_1.out programmable_folded_cascode_0.EN1.t8 programmable_folded_cascode_0.programmable_nfet$2_0.g.t5 VDD.t679 pfet_03v3 ad=0.2822p pd=2.18u as=0.2822p ps=2.18u w=0.42u l=0.28u
X320 VDD.t43 programmable_telescopic_cascode_0.programmable_pfet$3_1.transmission_gate$23_1.out.t6 programmable_telescopic_cascode_0.programmable_pfet$3_1.d.t3 VDD.t22 pfet_03v3 ad=26p pd=81.3u as=26p ps=81.3u w=40u l=0.5u
X321 VDD.t179 programmable_telescopic_cascode_0.programmable_pfet$3_0.g.t56 programmable_telescopic_cascode_0.programmable_pfet$3_1.d.t33 VDD.t160 pfet_03v3 ad=26p pd=81.3u as=26p ps=81.3u w=40u l=0.5u
X322 scan_chain_0.D_ff1_4.D_latch1$1_1.inv1$3_0.Y programmable_common_source_0.EN0.t10 VSS.t304 VSS.t303 nfet_03v3 ad=0.2646p pd=2.1u as=0.2646p ps=2.1u w=0.42u l=0.28u
X323 programmable_telescopic_cascode_0.programmable_pfet$3_1.d.t43 programmable_telescopic_cascode_0.programmable_pfet$3_1.transmission_gate$23_0.out.t5 VDD.t673 VDD.t239 pfet_03v3 ad=10.4p pd=40.52u as=26p ps=81.3u w=40u l=0.5u
X324 scan_chain_0.D_ff1_8.D_latch1$1_1.Q_bar scan_chain_0.D_ff1_8.D_latch1$1_0.D a_25796_79067# VSS.t357 nfet_03v3 ad=0.2646p pd=2.1u as=0.2646p ps=2.1u w=0.42u l=0.28u
X325 programmable_5tOTA_0.programmable_nfet$7_1.transmission_gate$28_0.out programmable_5tOTA_0.ena_bar<0>.t6 VSS.t497 VSS.t496 nfet_03v3 ad=0.2646p pd=2.1u as=0.2646p ps=2.1u w=0.42u l=0.28u
X326 VSS.t286 CLK.t17 a_24313_79067# VSS.t285 nfet_03v3 ad=0.2646p pd=2.1u as=0.2646p ps=2.1u w=0.42u l=0.28u
X327 programmable_telescopic_cascode_0.programmable_nfet$5_1.d.t9 programmable_telescopic_cascode_0.programmable_nfet$4_1.transmission_gate$24_1.out.t5 OUT_TELESCOPIC.t7 VSS.t145 nfet_03v3 ad=27.45p pd=91.22u as=27.45p ps=91.22u w=45u l=0.4u
X328 programmable_folded_cascode_0.OUT.t4 programmable_folded_cascode_0.programmable_pfet$1_0.g.t33 a_49197_2844.t44 VDD.t362 pfet_03v3 ad=19.24p pd=60.5u as=19.24p ps=60.5u w=29.6u l=0.5u
X329 programmable_telescopic_cascode_0.programmable_nfet$5_1.d.t23 programmable_telescopic_cascode_0.programmable_nfet$4_1.transmission_gate$24_0.out.t6 OUT_TELESCOPIC.t33 VSS.t119 nfet_03v3 ad=27.45p pd=91.22u as=11.7p ps=45.52u w=45u l=0.4u
X330 programmable_telescopic_cascode_0.programmable_pfet$3_0.d.t9 programmable_telescopic_cascode_0.programmable_pfet$3_0.transmission_gate$23_0.out.t6 VDD.t112 VDD.t99 pfet_03v3 ad=10.4p pd=40.52u as=26p ps=81.3u w=40u l=0.5u
X331 OUT_CS.t40 programmable_common_source_0.programmable_pfet$5_0.transmission_gate$30_0.out.t11 VDD.t507 VDD.t465 pfet_03v3 ad=2.392p pd=9.72u as=5.98p ps=19.7u w=9.2u l=1u
X332 programmable_telescopic_cascode_0.programmable_nfet$4_0.g.t5 programmable_telescopic_cascode_0.EN0.t8 programmable_telescopic_cascode_0.programmable_nfet$4_0.transmission_gate$24_1.out.t2 VDD.t248 pfet_03v3 ad=0.2822p pd=2.18u as=0.2822p ps=2.18u w=0.42u l=0.28u
X333 programmable_common_source_0.programmable_pfet$5_0.transmission_gate$30_0.out.t0 programmable_common_source_0.EN1.t7 VDD.t108 VDD.t107 pfet_03v3 ad=0.2822p pd=2.18u as=0.2822p ps=2.18u w=0.42u l=0.28u
X334 VDD.t397 CLK.t18 scan_chain_0.D_ff1_5.D_latch1$1_1.NAND2$2_2.B VDD.t396 pfet_03v3 ad=0.2822p pd=2.18u as=0.2822p ps=2.18u w=0.42u l=0.28u
X335 a_62818_79808# programmable_common_source_0.EN1.t8 scan_chain_0.D_ff1_0.D_latch1$1_1.NAND2$2_0.A VSS.t80 nfet_03v3 ad=0.2646p pd=2.1u as=0.2646p ps=2.1u w=0.42u l=0.28u
X336 programmable_telescopic_cascode_0.programmable_pfet$3_0.d.t32 programmable_telescopic_cascode_0.programmable_pfet$2_0.transmission_gate$22_0.out.t7 programmable_telescopic_cascode_0.programmable_pfet$3_0.g.t36 VDD.t623 pfet_03v3 ad=30.55p pd=95.3u as=12.22p ps=47.52u w=47u l=0.5u
X337 a_49197_2844.t36 programmable_folded_cascode_0.programmable_pfet_0.transmission_gate$16_1.out.t8 VDD.t230 VDD.t57 pfet_03v3 ad=9.048p pd=35.32u as=22.62p ps=70.9u w=34.8u l=1u
X338 a_45880_2844.t5 INP_FOLDED.t4 a_55661_23626.t4 VSS.t17 nfet_03v3 ad=18.3p pd=61.22u as=18.3p ps=61.22u w=30u l=0.5u
X339 scan_chain_0.D_ff1_7.D_latch1$1_1.NAND2$2_0.A transmission_gate$2$1_6.out.t13 VDD.t534 VDD.t533 pfet_03v3 ad=0.2822p pd=2.18u as=0.2822p ps=2.18u w=0.42u l=0.28u
X340 scan_chain_0.D_ff1_1.D_latch1$1_0.inv1$3_0.Y scan_chain_0.D_ff1_1.D_latch1$1_0.D VSS.t253 VSS.t252 nfet_03v3 ad=0.2646p pd=2.1u as=0.2646p ps=2.1u w=0.42u l=0.28u
X341 a_66673_79067# scan_chain_0.D_ff1_0.D_latch1$1_0.inv1$3_0.Y scan_chain_0.D_ff1_0.D_latch1$1_0.NAND2$2_2.B VSS.t258 nfet_03v3 ad=0.2646p pd=2.1u as=0.2646p ps=2.1u w=0.42u l=0.28u
X342 VDD.t544 programmable_telescopic_cascode_0.programmable_pfet$3_0.transmission_gate$23_1.out.t5 programmable_telescopic_cascode_0.programmable_pfet$3_0.d.t25 VDD.t543 pfet_03v3 ad=26p pd=81.3u as=26p ps=81.3u w=40u l=0.5u
X343 OUT_5T.t0 programmable_5tOTA_0.programmable_pfet$4_1.transmission_gate$27_0.out.t3 VDD.t15 VDD.t14 pfet_03v3 ad=13p pd=50.52u as=32.5p ps=0.1013m w=50u l=0.5u
X344 scan_chain_0.D_ff1_1.D_latch1$1_0.D scan_chain_0.D_ff1_1.D_latch1$1_1.NAND2$2_0.A VDD.t69 VDD.t68 pfet_03v3 ad=0.2822p pd=2.18u as=0.2822p ps=2.18u w=0.42u l=0.28u
X345 VSS.t30 programmable_5tOTA_0.programmable_nfet$8_0.transmission_gate$29_1.out.t4 a_91570_47942.t1 VSS.t28 nfet_03v3 ad=13.908p pd=46.82u as=5.928p ps=23.32u w=22.8u l=1u
X346 INN_FOLDED.t0 programmable_folded_cascode_0.EN0.t11 programmable_folded_cascode_0.programmable_nfet_0.transmission_gate$18_0.out VDD.t126 pfet_03v3 ad=0.2822p pd=2.18u as=0.2822p ps=2.18u w=0.42u l=0.28u
X347 VDD.t212 programmable_5tOTA_0.programmable_pfet$4_0.transmission_gate$27_0.out.t4 programmable_5tOTA_0.programmable_pfet$4_0.g.t13 VDD.t210 pfet_03v3 ad=32.5p pd=0.1013m as=13p ps=50.52u w=50u l=0.5u
X348 programmable_folded_cascode_0.programmable_pfet_0.g.t1 programmable_folded_cascode_0.EN0.t12 programmable_folded_cascode_0.programmable_pfet_0.transmission_gate$16_0.out.t0 VDD.t127 pfet_03v3 ad=0.2822p pd=2.18u as=0.2822p ps=2.18u w=0.42u l=0.28u
X349 a_49197_2844.t17 programmable_folded_cascode_0.programmable_pfet_0.g.t27 VDD.t189 VDD.t183 pfet_03v3 ad=22.62p pd=70.9u as=22.62p ps=70.9u w=34.8u l=1u
X350 a_91570_47942.t19 programmable_5tOTA_0.programmable_nfet$8_0.transmission_gate$29_0.out.t4 VSS.t175 VSS.t173 nfet_03v3 ad=13.908p pd=46.82u as=13.908p ps=46.82u w=22.8u l=1u
X351 scan_chain_0.D_ff1_6.D_latch1$1_1.NAND2$2_0.A transmission_gate$2$1_7.out.t13 VDD.t228 VDD.t227 pfet_03v3 ad=0.2822p pd=2.18u as=0.2822p ps=2.18u w=0.42u l=0.28u
X352 programmable_telescopic_cascode_0.programmable_pfet$3_0.d.t16 programmable_telescopic_cascode_0.programmable_pfet$2_0.transmission_gate$22_1.out.t4 programmable_telescopic_cascode_0.programmable_pfet$3_0.g.t21 VDD.t653 pfet_03v3 ad=30.55p pd=95.3u as=30.55p ps=95.3u w=47u l=0.5u
X353 VDD.t250 programmable_telescopic_cascode_0.programmable_pfet$3_1.transmission_gate$23_0.out.t6 programmable_telescopic_cascode_0.programmable_pfet$3_1.d.t27 VDD.t237 pfet_03v3 ad=26p pd=81.3u as=10.4p ps=40.52u w=40u l=0.5u
X354 a_20467_79808# scan_chain_0.D_ff1_7.D_latch1$1_0.D scan_chain_0.D_ff1_7.D_latch1$1_0.NAND2$2_0.A VSS.t271 nfet_03v3 ad=0.2646p pd=2.1u as=0.2646p ps=2.1u w=0.42u l=0.28u
X355 scan_chain_0.D_ff1_0.Q_bar SCAN_OUT.t4 a_68156_79067# VSS.t499 nfet_03v3 ad=0.2646p pd=2.1u as=0.2646p ps=2.1u w=0.42u l=0.28u
X356 VDD.t180 programmable_telescopic_cascode_0.programmable_pfet$3_0.g.t57 programmable_telescopic_cascode_0.programmable_pfet$3_1.d.t32 VDD.t160 pfet_03v3 ad=26p pd=81.3u as=26p ps=81.3u w=40u l=0.5u
X357 VSS.t493 scan_chain_0.D_ff1_4.inv1$4_0.Y a_58972_79067# VSS.t492 nfet_03v3 ad=0.2646p pd=2.1u as=0.2646p ps=2.1u w=0.42u l=0.28u
X358 programmable_telescopic_cascode_0.programmable_pfet$3_1.d.t28 programmable_telescopic_cascode_0.programmable_pfet$3_1.transmission_gate$23_0.out.t7 VDD.t251 VDD.t239 pfet_03v3 ad=10.4p pd=40.52u as=26p ps=81.3u w=40u l=0.5u
X359 a_49197_2844.t18 programmable_folded_cascode_0.programmable_pfet_0.g.t28 VDD.t190 VDD.t183 pfet_03v3 ad=22.62p pd=70.9u as=22.62p ps=70.9u w=34.8u l=1u
X360 a_10395_79808# scan_chain_0.D_ff1_6.D_latch1$1_1.NAND2$2_0.A scan_chain_0.D_ff1_6.D_latch1$1_0.D VSS.t91 nfet_03v3 ad=0.2646p pd=2.1u as=0.2646p ps=2.1u w=0.42u l=0.28u
X361 scan_chain_0.D_ff1_8.D_latch1$1_1.Q_bar scan_chain_0.D_ff1_8.D_latch1$1_1.NAND2$2_2.B VDD.t196 VDD.t195 pfet_03v3 ad=0.2822p pd=2.18u as=0.2822p ps=2.18u w=0.42u l=0.28u
X362 programmable_folded_cascode_0.programmable_nfet$1_0.g.t8 programmable_folded_cascode_0.programmable_pfet$1_0.g.t34 a_45880_2844.t41 VDD.t363 pfet_03v3 ad=19.24p pd=60.5u as=19.24p ps=60.5u w=29.6u l=0.5u
X363 programmable_folded_cascode_0.OUT.t20 programmable_folded_cascode_0.programmable_pfet$1_0.transmission_gate$17_0.out.t4 a_49197_2844.t63 VDD.t647 pfet_03v3 ad=19.24p pd=60.5u as=19.24p ps=60.5u w=29.6u l=0.5u
X364 scan_chain_0.D_ff1_4.inv1$4_0.Y CLK.t19 VSS.t288 VSS.t287 nfet_03v3 ad=0.2646p pd=2.1u as=0.2646p ps=2.1u w=0.42u l=0.28u
X365 VDD.t200 scan_chain_0.D_ff1_2.inv1$4_0.Y scan_chain_0.D_ff1_2.D_latch1$1_0.NAND2$2_2.B VDD.t199 pfet_03v3 ad=0.2822p pd=2.18u as=0.2822p ps=2.18u w=0.42u l=0.28u
X366 programmable_folded_cascode_0.programmable_nfet$2_0.transmission_gate$20_1.out programmable_folded_cascode_0.EN1.t9 VSS.t505 VSS.t504 nfet_03v3 ad=0.2646p pd=2.1u as=0.2646p ps=2.1u w=0.42u l=0.28u
X367 a_91570_47942.t27 programmable_5tOTA_0.programmable_nfet$7_0.transmission_gate$28_1.out OUT_5T.t10 VSS.t242 nfet_03v3 ad=6.954p pd=24.02u as=2.964p ps=11.92u w=11.4u l=0.5u
X368 scan_chain_0.D_ff1_1.D_latch1$1_0.NAND2$2_0.A scan_chain_0.D_ff1_1.D_latch1$1_0.D VDD.t318 VDD.t317 pfet_03v3 ad=0.2822p pd=2.18u as=0.2822p ps=2.18u w=0.42u l=0.28u
X369 VDD.t338 programmable_folded_cascode_0.programmable_pfet_1.transmission_gate$16_1.out.t10 a_45880_2844.t32 VDD.t329 pfet_03v3 ad=22.62p pd=70.9u as=9.048p ps=35.32u w=34.8u l=1u
X370 VSS.t116 programmable_folded_cascode_0.EN0.t13 programmable_folded_cascode_0.programmable_nfet$2_0.transmission_gate$20_0.out VSS.t115 nfet_03v3 ad=0.2646p pd=2.1u as=0.2646p ps=2.1u w=0.42u l=0.28u
X371 programmable_folded_cascode_0.OUT.t12 programmable_folded_cascode_0.programmable_pfet$1_0.transmission_gate$17_1.out.t6 a_49197_2844.t7 VDD.t149 pfet_03v3 ad=7.696p pd=30.12u as=19.24p ps=60.5u w=29.6u l=0.5u
X372 VDD.t279 IN_CS.t9 OUT_CS.t8 VDD.t274 pfet_03v3 ad=5.98p pd=19.7u as=5.98p ps=19.7u w=9.2u l=1u
X373 a_2694_79808# scan_chain_0.D_ff1_5.D_latch1$1_1.NAND2$2_0.A scan_chain_0.D_ff1_5.D_latch1$1_0.D VSS.t268 nfet_03v3 ad=0.2646p pd=2.1u as=0.2646p ps=2.1u w=0.42u l=0.28u
X374 VDD.t316 scan_chain_0.D_ff1_1.D_latch1$1_0.D scan_chain_0.D_ff1_1.D_latch1$1_1.Q_bar VDD.t315 pfet_03v3 ad=0.2822p pd=2.18u as=0.2822p ps=2.18u w=0.42u l=0.28u
X375 transmission_gate$2$1_6.out.t0 scan_chain_0.D_ff1_6.D_latch1$1_0.NAND2$2_0.A VDD.t13 VDD.t12 pfet_03v3 ad=0.2822p pd=2.18u as=0.2822p ps=2.18u w=0.42u l=0.28u
X376 VDD.t659 programmable_5tOTA_0.ena_bar<0>.t7 transmission_gate$2$1_3.out.t4 VDD.t658 pfet_03v3 ad=0.2822p pd=2.18u as=0.2822p ps=2.18u w=0.42u l=0.28u
X377 programmable_telescopic_cascode_0.programmable_pfet$2_0.transmission_gate$22_0.out.t1 transmission_gate$2$1_4.out.t12 programmable_telescopic_cascode_0.programmable_pfet$2_0.g.t9 VSS.t372 nfet_03v3 ad=0.2646p pd=2.1u as=0.2646p ps=2.1u w=0.42u l=0.28u
X378 VSS.t290 CLK.t20 a_47416_79808# VSS.t289 nfet_03v3 ad=0.2646p pd=2.1u as=0.2646p ps=2.1u w=0.42u l=0.28u
X379 programmable_folded_cascode_0.programmable_nfet$2_0.g.t12 programmable_folded_cascode_0.programmable_nfet$2_0.g.t11 VSS.t366 VSS.t365 nfet_03v3 ad=12.505p pd=42.22u as=12.505p ps=42.22u w=20.5u l=1u
X380 programmable_telescopic_cascode_0.programmable_pfet$3_0.d.t15 programmable_telescopic_cascode_0.programmable_pfet$2_0.transmission_gate$22_1.out.t5 programmable_telescopic_cascode_0.programmable_pfet$3_0.g.t20 VDD.t653 pfet_03v3 ad=30.55p pd=95.3u as=30.55p ps=95.3u w=47u l=0.5u
X381 VDD.t587 programmable_folded_cascode_0.programmable_pfet_0.g.t2 programmable_folded_cascode_0.programmable_pfet_0.g.t3 VDD.t117 pfet_03v3 ad=14.95p pd=47.3u as=14.95p ps=47.3u w=23u l=1u
X382 OUT_5T.t19 programmable_5tOTA_0.programmable_nfet$7_0.transmission_gate$28_0.out a_91570_47942.t35 VSS.t443 nfet_03v3 ad=6.954p pd=24.02u as=6.954p ps=24.02u w=11.4u l=0.5u
X383 programmable_telescopic_cascode_0.programmable_nfet$6_0.d.t3 INP_TELESCOPIC.t4 programmable_telescopic_cascode_0.programmable_nfet$4_0.s.t1 VSS.t47 nfet_03v3 ad=18.3p pd=61.22u as=18.3p ps=61.22u w=30u l=0.5u
X384 VSS.t245 scan_chain_0.D_ff1_0.D_latch1$1_1.Q_bar a_64302_79808# VSS.t244 nfet_03v3 ad=0.2646p pd=2.1u as=0.2646p ps=2.1u w=0.42u l=0.28u
X385 transmission_gate$2$1_7.out.t3 scan_chain_0.D_ff1_5.D_latch1$1_0.NAND2$2_0.A VDD.t669 VDD.t668 pfet_03v3 ad=0.2822p pd=2.18u as=0.2822p ps=2.18u w=0.42u l=0.28u
X386 SCAN_OUT.t1 scan_chain_0.D_ff1_0.D_latch1$1_0.NAND2$2_0.A VDD.t667 VDD.t666 pfet_03v3 ad=0.2822p pd=2.18u as=0.2822p ps=2.18u w=0.42u l=0.28u
X387 VDD.t156 programmable_telescopic_cascode_0.programmable_pfet$3_0.g.t58 programmable_telescopic_cascode_0.programmable_pfet$3_0.d.t21 VDD.t155 pfet_03v3 ad=26p pd=81.3u as=26p ps=81.3u w=40u l=0.5u
X388 VDD.t65 scan_chain_0.D_ff1_1.inv1$4_0.Y scan_chain_0.D_ff1_1.D_latch1$1_0.NAND2$2_2.B VDD.t64 pfet_03v3 ad=0.2822p pd=2.18u as=0.2822p ps=2.18u w=0.42u l=0.28u
X389 VDD.t102 programmable_common_source_0.EN1.t9 programmable_common_source_0.EN1.t1 VDD.t101 pfet_03v3 ad=0.2822p pd=2.18u as=0.2822p ps=2.18u w=0.42u l=0.28u
X390 a_49197_2844.t52 programmable_folded_cascode_0.programmable_pfet_0.transmission_gate$16_0.out.t6 VDD.t520 VDD.t173 pfet_03v3 ad=22.62p pd=70.9u as=22.62p ps=70.9u w=34.8u l=1u
X391 programmable_folded_cascode_0.programmable_nfet_0.transmission_gate$18_1.out programmable_folded_cascode_0.EN1.t10 VSS.t507 VSS.t506 nfet_03v3 ad=0.2646p pd=2.1u as=0.2646p ps=2.1u w=0.42u l=0.28u
X392 VDD.t254 programmable_5tOTA_0.programmable_pfet$4_0.g.t16 programmable_5tOTA_0.programmable_pfet$4_0.g.t17 VDD.t253 pfet_03v3 ad=32.5p pd=0.1013m as=32.5p ps=0.1013m w=50u l=0.5u
X393 a_49197_2844.t8 programmable_folded_cascode_0.programmable_pfet$1_0.transmission_gate$17_1.out.t7 programmable_folded_cascode_0.OUT.t11 VDD.t150 pfet_03v3 ad=19.24p pd=60.5u as=7.696p ps=30.12u w=29.6u l=0.5u
X394 a_45880_2844.t63 programmable_folded_cascode_0.programmable_pfet_1.transmission_gate$16_0.out.t8 VDD.t619 VDD.t603 pfet_03v3 ad=22.62p pd=70.9u as=22.62p ps=70.9u w=34.8u l=1u
X395 a_52755_79808# scan_chain_0.D_ff1_3.D_latch1$1_0.NAND2$2_0.A programmable_common_source_0.EN0.t3 VSS.t483 nfet_03v3 ad=0.2646p pd=2.1u as=0.2646p ps=2.1u w=0.42u l=0.28u
X396 a_56600_79067# scan_chain_0.D_ff1_4.D_latch1$1_1.NAND2$2_2.B VSS.t320 VSS.t319 nfet_03v3 ad=0.2646p pd=2.1u as=0.2646p ps=2.1u w=0.42u l=0.28u
X397 VDD.t670 programmable_common_source_0.programmable_pfet$5_0.transmission_gate$30_1.out.t4 OUT_CS.t22 VDD.t256 pfet_03v3 ad=5.98p pd=19.7u as=5.98p ps=19.7u w=9.2u l=1u
X398 VSS.t388 programmable_telescopic_cascode_0.programmable_nfet$6_0.transmission_gate$26_0.out.t5 programmable_telescopic_cascode_0.programmable_nfet$6_0.d.t11 VSS.t97 nfet_03v3 ad=16.531p pd=55.42u as=7.046p ps=27.62u w=27.1u l=1u
X399 a_49197_2844.t35 programmable_folded_cascode_0.programmable_pfet_0.transmission_gate$16_1.out.t9 VDD.t232 VDD.t231 pfet_03v3 ad=9.048p pd=35.32u as=22.62p ps=70.9u w=34.8u l=1u
X400 programmable_telescopic_cascode_0.programmable_nfet$4_0.s.t11 programmable_telescopic_cascode_0.programmable_nfet$4_0.g.t16 programmable_telescopic_cascode_0.programmable_pfet$3_0.g.t28 VSS.t190 nfet_03v3 ad=27.45p pd=91.22u as=27.45p ps=91.22u w=45u l=0.4u
X401 scan_chain_0.D_ff1_5.D_latch1$1_0.NAND2$2_2.B scan_chain_0.D_ff1_5.D_latch1$1_0.inv1$3_0.Y VDD.t621 VDD.t620 pfet_03v3 ad=0.2822p pd=2.18u as=0.2822p ps=2.18u w=0.42u l=0.28u
X402 programmable_telescopic_cascode_0.programmable_pfet$3_1.d.t29 programmable_telescopic_cascode_0.programmable_pfet$3_1.transmission_gate$23_0.out.t8 VDD.t252 VDD.t239 pfet_03v3 ad=10.4p pd=40.52u as=26p ps=81.3u w=40u l=0.5u
X403 a_49197_2844.t53 programmable_folded_cascode_0.programmable_pfet_0.transmission_gate$16_0.out.t7 VDD.t522 VDD.t173 pfet_03v3 ad=22.62p pd=70.9u as=22.62p ps=70.9u w=34.8u l=1u
X404 OUT_TELESCOPIC.t34 programmable_telescopic_cascode_0.programmable_nfet$4_1.transmission_gate$24_0.out.t7 programmable_telescopic_cascode_0.programmable_nfet$5_1.d.t24 VSS.t120 nfet_03v3 ad=11.7p pd=45.52u as=27.45p ps=91.22u w=45u l=0.4u
X405 a_91570_47942.t20 programmable_5tOTA_0.programmable_nfet$8_0.transmission_gate$29_0.out.t5 VSS.t176 VSS.t173 nfet_03v3 ad=13.908p pd=46.82u as=13.908p ps=46.82u w=22.8u l=1u
X406 transmission_gate$2$1_7.ena PROG_ENA.t3 VSS.t73 VSS.t72 nfet_03v3 ad=0.2646p pd=2.1u as=0.2646p ps=2.1u w=0.42u l=0.28u
X407 VDD.t687 programmable_common_source_0.programmable_pfet$5_0.transmission_gate$30_1.out.t5 OUT_CS.t21 VDD.t256 pfet_03v3 ad=5.98p pd=19.7u as=5.98p ps=19.7u w=9.2u l=1u
X408 scan_chain_0.D_ff1_0.D_latch1$1_1.inv1$3_0.Y programmable_common_source_0.EN1.t10 VDD.t104 VDD.t103 pfet_03v3 ad=0.546p pd=2.98u as=0.546p ps=2.98u w=0.84u l=0.28u
X409 programmable_folded_cascode_0.programmable_nfet$1_0.g.t27 programmable_folded_cascode_0.programmable_pfet$1_1.transmission_gate$17_1.out.t8 a_45880_2844.t18 VDD.t209 pfet_03v3 ad=7.696p pd=30.12u as=19.24p ps=60.5u w=29.6u l=0.5u
X410 programmable_5tOTA_0.programmable_pfet$4_0.transmission_gate$27_1.out.t2 transmission_gate$2$1_3.out.t10 VDD.t48 VDD.t47 pfet_03v3 ad=0.2822p pd=2.18u as=0.2822p ps=2.18u w=0.42u l=0.28u
X411 VDD.t688 programmable_common_source_0.programmable_pfet$5_0.transmission_gate$30_1.out.t6 OUT_CS.t20 VDD.t256 pfet_03v3 ad=5.98p pd=19.7u as=5.98p ps=19.7u w=9.2u l=1u
X412 a_21950_79067# scan_chain_0.D_ff1_7.D_latch1$1_0.NAND2$2_2.B VSS.t326 VSS.t325 nfet_03v3 ad=0.2646p pd=2.1u as=0.2646p ps=2.1u w=0.42u l=0.28u
X413 VDD.t695 transmission_gate$2$1_7.out.t14 programmable_folded_cascode_0.EN0.t1 VDD.t694 pfet_03v3 ad=0.2822p pd=2.18u as=0.2822p ps=2.18u w=0.42u l=0.28u
X414 transmission_gate$2$1_4.out.t3 transmission_gate$2$1_7.ena VSS.t350 VSS.t349 nfet_03v3 ad=0.2646p pd=2.1u as=0.2646p ps=2.1u w=0.42u l=0.28u
X415 VSS.t527 programmable_5tOTA_0.ena_bar<1>.t5 a_45054_79808# VSS.t526 nfet_03v3 ad=0.2646p pd=2.1u as=0.2646p ps=2.1u w=0.42u l=0.28u
X416 scan_chain_0.D_ff1_3.D_latch1$1_1.Q_bar scan_chain_0.D_ff1_3.D_latch1$1_0.D a_48899_79067# VSS.t267 nfet_03v3 ad=0.2646p pd=2.1u as=0.2646p ps=2.1u w=0.42u l=0.28u
X417 a_12766_79067# scan_chain_0.D_ff1_6.D_latch1$1_0.inv1$3_0.Y scan_chain_0.D_ff1_6.D_latch1$1_0.NAND2$2_2.B VSS.t114 nfet_03v3 ad=0.2646p pd=2.1u as=0.2646p ps=2.1u w=0.42u l=0.28u
X418 VSS.t50 programmable_folded_cascode_0.programmable_nfet$3_0.transmission_gate$21_1.out.t4 a_55661_23626.t10 VSS.t39 nfet_03v3 ad=12.2p pd=41.22u as=5.2p ps=20.52u w=20u l=1u
X419 VSS.t118 programmable_folded_cascode_0.EN0.t14 programmable_folded_cascode_0.programmable_nfet$3_0.transmission_gate$21_0.out VSS.t117 nfet_03v3 ad=0.2646p pd=2.1u as=0.2646p ps=2.1u w=0.42u l=0.28u
X420 programmable_common_source_0.programmable_pfet$5_0.transmission_gate$30_0.out.t1 programmable_common_source_0.EN1.t5 IN_CS.t1 VDD.t168 pfet_03v3 ad=0.2822p pd=2.18u as=0.2822p ps=2.18u w=0.42u l=0.28u
X421 VDD.t96 programmable_telescopic_cascode_0.programmable_pfet$3_0.transmission_gate$23_0.out.t7 programmable_telescopic_cascode_0.programmable_pfet$3_0.d.t2 VDD.t95 pfet_03v3 ad=26p pd=81.3u as=10.4p ps=40.52u w=40u l=0.5u
X422 programmable_telescopic_cascode_0.programmable_nfet$4_0.s.t21 programmable_telescopic_cascode_0.programmable_nfet$4_0.transmission_gate$24_0.out.t7 programmable_telescopic_cascode_0.programmable_pfet$3_0.g.t45 VSS.t428 nfet_03v3 ad=27.45p pd=91.22u as=11.7p ps=45.52u w=45u l=0.4u
X423 transmission_gate$2$1_2.out.t3 transmission_gate$2$1_7.ena VSS.t348 VSS.t347 nfet_03v3 ad=0.2646p pd=2.1u as=0.2646p ps=2.1u w=0.42u l=0.28u
X424 programmable_folded_cascode_0.EN1.t2 transmission_gate$2$1_6.out.t14 a_14249_79067# VSS.t407 nfet_03v3 ad=0.2646p pd=2.1u as=0.2646p ps=2.1u w=0.42u l=0.28u
X425 a_37352_79067# scan_chain_0.D_ff1_1.D_latch1$1_0.NAND2$2_2.B VSS.t16 VSS.t15 nfet_03v3 ad=0.2646p pd=2.1u as=0.2646p ps=2.1u w=0.42u l=0.28u
X426 programmable_5tOTA_0.programmable_pfet$4_1.transmission_gate$27_1.out.t2 programmable_5tOTA_0.ena_bar<0>.t8 programmable_5tOTA_0.programmable_pfet$4_0.g.t27 VDD.t660 pfet_03v3 ad=0.2822p pd=2.18u as=0.2822p ps=2.18u w=0.42u l=0.28u
X427 VDD.t337 programmable_folded_cascode_0.programmable_pfet_1.transmission_gate$16_1.out.t11 a_45880_2844.t31 VDD.t336 pfet_03v3 ad=22.62p pd=70.9u as=9.048p ps=35.32u w=34.8u l=1u
X428 a_45880_2844.t19 programmable_folded_cascode_0.programmable_pfet$1_1.transmission_gate$17_1.out.t9 programmable_folded_cascode_0.programmable_nfet$1_0.g.t28 VDD.t122 pfet_03v3 ad=19.24p pd=60.5u as=7.696p ps=30.12u w=29.6u l=0.5u
X429 programmable_telescopic_cascode_0.programmable_pfet$3_0.g.t46 programmable_telescopic_cascode_0.programmable_nfet$4_0.transmission_gate$24_0.out.t8 programmable_telescopic_cascode_0.programmable_nfet$4_0.s.t20 VSS.t161 nfet_03v3 ad=11.7p pd=45.52u as=27.45p ps=91.22u w=45u l=0.4u
X430 VDD.t628 CLK.t21 scan_chain_0.D_ff1_1.D_latch1$1_1.NAND2$2_0.A VDD.t627 pfet_03v3 ad=0.2822p pd=2.18u as=0.2822p ps=2.18u w=0.42u l=0.28u
X431 a_28168_79067# scan_chain_0.D_ff1_8.D_latch1$1_0.inv1$3_0.Y scan_chain_0.D_ff1_8.D_latch1$1_0.NAND2$2_2.B VSS.t355 nfet_03v3 ad=0.2646p pd=2.1u as=0.2646p ps=2.1u w=0.42u l=0.28u
X432 a_61069_4063.t0 programmable_folded_cascode_0.programmable_pfet$1_0.g.t6 programmable_folded_cascode_0.programmable_pfet$1_0.g.t7 VDD.t165 pfet_03v3 ad=12.74p pd=40.5u as=12.74p ps=40.5u w=19.6u l=0.5u
X433 programmable_telescopic_cascode_0.programmable_pfet$3_0.d.t14 programmable_telescopic_cascode_0.programmable_pfet$2_0.transmission_gate$22_1.out.t6 programmable_telescopic_cascode_0.programmable_pfet$3_0.g.t19 VDD.t653 pfet_03v3 ad=30.55p pd=95.3u as=30.55p ps=95.3u w=47u l=0.5u
X434 programmable_5tOTA_0.programmable_nfet$7_0.transmission_gate$28_0.out programmable_5tOTA_0.ena_bar<0>.t9 INN_5T.t3 VDD.t661 pfet_03v3 ad=0.2822p pd=2.18u as=0.2822p ps=2.18u w=0.42u l=0.28u
X435 scan_chain_0.D_ff1_5.D_latch1$1_1.NAND2$2_0.A SCAN_IN.t0 VDD.t714 VDD.t713 pfet_03v3 ad=0.2822p pd=2.18u as=0.2822p ps=2.18u w=0.42u l=0.28u
X436 VDD.t508 programmable_common_source_0.programmable_pfet$5_0.transmission_gate$30_0.out.t12 OUT_CS.t41 VDD.t461 pfet_03v3 ad=5.98p pd=19.7u as=2.392p ps=9.72u w=9.2u l=1u
X437 a_91570_47942.t8 programmable_5tOTA_0.programmable_nfet$8_0.transmission_gate$29_1.out.t5 VSS.t102 VSS.t101 nfet_03v3 ad=5.928p pd=23.32u as=13.908p ps=46.82u w=22.8u l=1u
X438 programmable_telescopic_cascode_0.programmable_nfet$5_1.d.t18 programmable_telescopic_cascode_0.programmable_nfet$4_0.g.t17 OUT_TELESCOPIC.t29 VSS.t189 nfet_03v3 ad=27.45p pd=91.22u as=27.45p ps=91.22u w=45u l=0.4u
X439 VDD.t630 CLK.t22 scan_chain_0.D_ff1_8.D_latch1$1_1.NAND2$2_2.B VDD.t629 pfet_03v3 ad=0.2822p pd=2.18u as=0.2822p ps=2.18u w=0.42u l=0.28u
X440 a_49197_2844.t19 programmable_folded_cascode_0.programmable_pfet_0.g.t29 VDD.t191 VDD.t183 pfet_03v3 ad=22.62p pd=70.9u as=22.62p ps=70.9u w=34.8u l=1u
X441 a_16612_79808# transmission_gate$2$1_6.out.t15 scan_chain_0.D_ff1_7.D_latch1$1_1.NAND2$2_0.A VSS.t408 nfet_03v3 ad=0.2646p pd=2.1u as=0.2646p ps=2.1u w=0.42u l=0.28u
X442 transmission_gate$2$1_4.out.t0 PROG_ENA.t4 VSS.t74 VDD.t86 pfet_03v3 ad=0.2822p pd=2.18u as=0.2822p ps=2.18u w=0.42u l=0.28u
X443 scan_chain_0.D_ff1_7.inv1$4_0.Y CLK.t23 VSS.t464 VSS.t463 nfet_03v3 ad=0.2646p pd=2.1u as=0.2646p ps=2.1u w=0.42u l=0.28u
X444 scan_chain_0.D_ff1_0.D_latch1$1_1.NAND2$2_2.B scan_chain_0.D_ff1_0.D_latch1$1_1.inv1$3_0.Y VDD.t33 VDD.t32 pfet_03v3 ad=0.2822p pd=2.18u as=0.2822p ps=2.18u w=0.42u l=0.28u
X445 scan_chain_0.D_ff1_3.inv1$4_0.Y CLK.t24 VSS.t466 VSS.t465 nfet_03v3 ad=0.2646p pd=2.1u as=0.2646p ps=2.1u w=0.42u l=0.28u
X446 a_55661_23626.t22 programmable_folded_cascode_0.programmable_nfet_1.transmission_gate$18_1.out a_45880_2844.t65 VSS.t459 nfet_03v3 ad=18.3p pd=61.22u as=7.8p ps=30.52u w=30u l=0.5u
X447 a_33498_79808# scan_chain_0.D_ff1_1.D_latch1$1_1.NAND2$2_0.A scan_chain_0.D_ff1_1.D_latch1$1_0.D VSS.t61 nfet_03v3 ad=0.2646p pd=2.1u as=0.2646p ps=2.1u w=0.42u l=0.28u
X448 programmable_telescopic_cascode_0.programmable_pfet$2_0.transmission_gate$22_0.out.t0 programmable_telescopic_cascode_0.EN1.t9 programmable_telescopic_cascode_0.programmable_pfet$2_0.g.t5 VDD.t637 pfet_03v3 ad=0.2822p pd=2.18u as=0.2822p ps=2.18u w=0.42u l=0.28u
X449 VDD.t386 scan_chain_0.D_ff1_3.inv1$4_0.Y scan_chain_0.D_ff1_3.D_latch1$1_0.NAND2$2_0.A VDD.t385 pfet_03v3 ad=0.2822p pd=2.18u as=0.2822p ps=2.18u w=0.42u l=0.28u
X450 a_49197_2844.t49 programmable_folded_cascode_0.programmable_nfet_0.transmission_gate$18_0.out a_55661_23626.t19 VSS.t362 nfet_03v3 ad=18.3p pd=61.22u as=18.3p ps=61.22u w=30u l=0.5u
X451 a_8911_79808# transmission_gate$2$1_7.out.t15 scan_chain_0.D_ff1_6.D_latch1$1_1.NAND2$2_0.A VSS.t515 nfet_03v3 ad=0.2646p pd=2.1u as=0.2646p ps=2.1u w=0.42u l=0.28u
X452 programmable_folded_cascode_0.programmable_nfet$1_0.g.t1 programmable_folded_cascode_0.programmable_pfet$1_1.transmission_gate$17_0.out.t4 a_45880_2844.t1 VDD.t21 pfet_03v3 ad=19.24p pd=60.5u as=19.24p ps=60.5u w=29.6u l=0.5u
X453 programmable_folded_cascode_0.OUT.t3 programmable_folded_cascode_0.programmable_pfet$1_0.g.t35 a_49197_2844.t45 VDD.t364 pfet_03v3 ad=19.24p pd=60.5u as=19.24p ps=60.5u w=29.6u l=0.5u
X454 INP_TELESCOPIC.t0 transmission_gate$2$1_5.out.t9 programmable_telescopic_cascode_0.programmable_nfet$5_0.transmission_gate$25_1.out VSS.t96 nfet_03v3 ad=0.2646p pd=2.1u as=0.2646p ps=2.1u w=0.42u l=0.28u
X455 programmable_telescopic_cascode_0.programmable_pfet$3_0.d.t0 programmable_telescopic_cascode_0.programmable_pfet$2_0.g.t11 programmable_telescopic_cascode_0.programmable_pfet$3_0.g.t3 VDD.t46 pfet_03v3 ad=30.55p pd=95.3u as=30.55p ps=95.3u w=47u l=0.5u
X456 VDD.t233 programmable_folded_cascode_0.programmable_pfet_0.transmission_gate$16_1.out.t10 a_49197_2844.t34 VDD.t60 pfet_03v3 ad=22.62p pd=70.9u as=9.048p ps=35.32u w=34.8u l=1u
X457 VDD.t639 programmable_telescopic_cascode_0.EN1.t10 transmission_gate$2$1_4.out.t4 VDD.t638 pfet_03v3 ad=0.2822p pd=2.18u as=0.2822p ps=2.18u w=0.42u l=0.28u
X458 VDD.t408 scan_chain_0.D_ff1_2.D_latch1$1_1.Q_bar scan_chain_0.D_ff1_2.D_latch1$1_0.D VDD.t407 pfet_03v3 ad=0.2822p pd=2.18u as=0.2822p ps=2.18u w=0.42u l=0.28u
X459 VDD.t430 scan_chain_0.D_ff1_4.D_latch1$1_0.D scan_chain_0.D_ff1_4.D_latch1$1_1.Q_bar VDD.t429 pfet_03v3 ad=0.2822p pd=2.18u as=0.2822p ps=2.18u w=0.42u l=0.28u
X460 VDD.t1 transmission_gate$2$1_5.out.t10 programmable_telescopic_cascode_0.programmable_pfet$2_0.transmission_gate$22_1.out.t0 VDD.t0 pfet_03v3 ad=0.2822p pd=2.18u as=0.2822p ps=2.18u w=0.42u l=0.28u
X461 VSS.t468 CLK.t25 a_39715_79808# VSS.t467 nfet_03v3 ad=0.2646p pd=2.1u as=0.2646p ps=2.1u w=0.42u l=0.28u
X462 scan_chain_0.D_ff1_3.D_latch1$1_0.D scan_chain_0.D_ff1_3.D_latch1$1_1.NAND2$2_0.A VDD.t497 VDD.t496 pfet_03v3 ad=0.2822p pd=2.18u as=0.2822p ps=2.18u w=0.42u l=0.28u
X463 programmable_telescopic_cascode_0.programmable_nfet$4_0.g.t6 programmable_telescopic_cascode_0.EN0.t9 programmable_telescopic_cascode_0.programmable_nfet$4_1.transmission_gate$24_1.out.t2 VDD.t249 pfet_03v3 ad=0.2822p pd=2.18u as=0.2822p ps=2.18u w=0.42u l=0.28u
X464 programmable_5tOTA_0.programmable_pfet$4_0.g.t14 programmable_5tOTA_0.programmable_pfet$4_0.transmission_gate$27_0.out.t5 VDD.t214 VDD.t213 pfet_03v3 ad=13p pd=50.52u as=32.5p ps=0.1013m w=50u l=0.5u
X465 OUT_5T.t4 INN_5T.t6 a_91570_47942.t21 VSS.t228 nfet_03v3 ad=6.954p pd=24.02u as=6.954p ps=24.02u w=11.4u l=0.5u
X466 scan_chain_0.D_ff1_7.D_latch1$1_0.NAND2$2_2.B scan_chain_0.D_ff1_7.D_latch1$1_0.inv1$3_0.Y VDD.t54 VDD.t53 pfet_03v3 ad=0.2822p pd=2.18u as=0.2822p ps=2.18u w=0.42u l=0.28u
X467 programmable_folded_cascode_0.programmable_pfet_0.transmission_gate$16_1.out.t1 transmission_gate$2$1_6.out.t16 programmable_folded_cascode_0.programmable_pfet_0.g.t16 VSS.t409 nfet_03v3 ad=0.2646p pd=2.1u as=0.2646p ps=2.1u w=0.42u l=0.28u
X468 a_55661_23626.t11 programmable_folded_cascode_0.programmable_nfet$3_0.transmission_gate$21_1.out.t5 VSS.t51 VSS.t48 nfet_03v3 ad=5.2p pd=20.52u as=12.2p ps=41.22u w=20u l=1u
X469 VDD.t613 scan_chain_0.D_ff1_0.inv1$4_0.Y scan_chain_0.D_ff1_0.D_latch1$1_0.NAND2$2_0.A VDD.t612 pfet_03v3 ad=0.2822p pd=2.18u as=0.2822p ps=2.18u w=0.42u l=0.28u
X470 VDD.t545 programmable_telescopic_cascode_0.programmable_pfet$3_0.transmission_gate$23_1.out.t6 programmable_telescopic_cascode_0.programmable_pfet$3_0.d.t26 VDD.t543 pfet_03v3 ad=26p pd=81.3u as=26p ps=81.3u w=40u l=0.5u
X471 a_35869_79808# scan_chain_0.D_ff1_1.D_latch1$1_0.D scan_chain_0.D_ff1_1.D_latch1$1_0.NAND2$2_0.A VSS.t251 nfet_03v3 ad=0.2646p pd=2.1u as=0.2646p ps=2.1u w=0.42u l=0.28u
X472 a_49197_2844.t33 programmable_folded_cascode_0.programmable_pfet_0.transmission_gate$16_1.out.t11 VDD.t58 VDD.t57 pfet_03v3 ad=9.048p pd=35.32u as=22.62p ps=70.9u w=34.8u l=1u
X473 scan_chain_0.D_ff1_6.D_latch1$1_1.Q_bar scan_chain_0.D_ff1_6.D_latch1$1_1.NAND2$2_2.B VDD.t444 VDD.t443 pfet_03v3 ad=0.2822p pd=2.18u as=0.2822p ps=2.18u w=0.42u l=0.28u
X474 programmable_telescopic_cascode_0.programmable_nfet$4_0.s.t10 programmable_telescopic_cascode_0.programmable_nfet$4_0.g.t18 programmable_telescopic_cascode_0.programmable_pfet$3_0.g.t27 VSS.t190 nfet_03v3 ad=27.45p pd=91.22u as=27.45p ps=91.22u w=45u l=0.4u
X475 programmable_telescopic_cascode_0.programmable_nfet$5_1.d.t25 programmable_telescopic_cascode_0.programmable_nfet$4_1.transmission_gate$24_0.out.t8 OUT_TELESCOPIC.t35 VSS.t119 nfet_03v3 ad=27.45p pd=91.22u as=11.7p ps=45.52u w=45u l=0.4u
X476 OUT_CS.t0 programmable_common_source_0.programmable_nfet$9_0.transmission_gate$31_0.out VSS.t65 VSS.t64 nfet_03v3 ad=16.531p pd=55.42u as=16.531p ps=55.42u w=27.1u l=1u
X477 VDD.t3 transmission_gate$2$1_5.out.t11 programmable_telescopic_cascode_0.EN0.t1 VDD.t2 pfet_03v3 ad=0.2822p pd=2.18u as=0.2822p ps=2.18u w=0.42u l=0.28u
X478 a_49197_2844.t9 programmable_folded_cascode_0.programmable_pfet$1_0.transmission_gate$17_1.out.t8 programmable_folded_cascode_0.OUT.t10 VDD.t150 pfet_03v3 ad=19.24p pd=60.5u as=7.696p ps=30.12u w=29.6u l=0.5u
X479 VSS.t32 programmable_telescopic_cascode_0.EN0.t10 programmable_telescopic_cascode_0.programmable_nfet$5_0.transmission_gate$25_1.out VSS.t31 nfet_03v3 ad=0.2646p pd=2.1u as=0.2646p ps=2.1u w=0.42u l=0.28u
X480 programmable_5tOTA_0.programmable_nfet$8_0.transmission_gate$29_0.out.t0 programmable_5tOTA_0.ena_bar<0>.t10 VSS.t54 VSS.t53 nfet_03v3 ad=0.2646p pd=2.1u as=0.2646p ps=2.1u w=0.42u l=0.28u
X481 a_14250_79808# scan_chain_0.D_ff1_6.D_latch1$1_0.NAND2$2_0.A transmission_gate$2$1_6.out.t1 VSS.t7 nfet_03v3 ad=0.2646p pd=2.1u as=0.2646p ps=2.1u w=0.42u l=0.28u
X482 VDD.t697 transmission_gate$2$1_7.out.t16 programmable_folded_cascode_0.programmable_pfet$1_1.transmission_gate$17_0.out.t2 VDD.t696 pfet_03v3 ad=0.2822p pd=2.18u as=0.2822p ps=2.18u w=0.42u l=0.28u
X483 programmable_5tOTA_0.programmable_pfet$4_0.g.t0 programmable_5tOTA_0.programmable_nfet$7_1.transmission_gate$28_1.out a_91570_47942.t6 VSS.t45 nfet_03v3 ad=2.964p pd=11.92u as=6.954p ps=24.02u w=11.4u l=0.5u
X484 a_49197_2844.t32 programmable_folded_cascode_0.programmable_pfet_0.transmission_gate$16_1.out.t12 VDD.t59 VDD.t57 pfet_03v3 ad=9.048p pd=35.32u as=22.62p ps=70.9u w=34.8u l=1u
X485 programmable_folded_cascode_0.programmable_nfet$1_0.g.t15 transmission_gate$2$1_7.out.t17 programmable_folded_cascode_0.programmable_nfet$1_0.transmission_gate$19_0.out VSS.t516 nfet_03v3 ad=0.2646p pd=2.1u as=0.2646p ps=2.1u w=0.42u l=0.28u
X486 a_49197_2844.t20 programmable_folded_cascode_0.programmable_pfet_0.g.t30 VDD.t192 VDD.t183 pfet_03v3 ad=22.62p pd=70.9u as=22.62p ps=70.9u w=34.8u l=1u
X487 scan_chain_0.D_ff1_5.D_latch1$1_1.Q_bar scan_chain_0.D_ff1_5.D_latch1$1_1.NAND2$2_2.B VDD.t356 VDD.t355 pfet_03v3 ad=0.2822p pd=2.18u as=0.2822p ps=2.18u w=0.42u l=0.28u
X488 VDD.t655 scan_chain_0.D_ff1_4.inv1$4_0.Y scan_chain_0.D_ff1_4.D_latch1$1_0.NAND2$2_2.B VDD.t654 pfet_03v3 ad=0.2822p pd=2.18u as=0.2822p ps=2.18u w=0.42u l=0.28u
X489 programmable_common_source_0.programmable_nfet$9_0.transmission_gate$31_0.out programmable_common_source_0.EN0.t3 VSS.t25 VSS.t24 nfet_03v3 ad=0.2646p pd=2.1u as=0.2646p ps=2.1u w=0.42u l=0.28u
X490 a_49197_2844.t54 programmable_folded_cascode_0.programmable_pfet_0.transmission_gate$16_0.out.t8 VDD.t523 VDD.t173 pfet_03v3 ad=22.62p pd=70.9u as=22.62p ps=70.9u w=34.8u l=1u
X491 programmable_folded_cascode_0.programmable_nfet$1_0.g.t2 programmable_folded_cascode_0.programmable_pfet$1_1.transmission_gate$17_0.out.t5 a_45880_2844.t2 VDD.t20 pfet_03v3 ad=19.24p pd=60.5u as=19.24p ps=60.5u w=29.6u l=0.5u
X492 programmable_telescopic_cascode_0.programmable_pfet$3_0.d.t1 programmable_telescopic_cascode_0.programmable_pfet$2_0.g.t12 programmable_telescopic_cascode_0.programmable_pfet$3_0.g.t4 VDD.t46 pfet_03v3 ad=30.55p pd=95.3u as=30.55p ps=95.3u w=47u l=0.5u
X493 a_6549_79808# scan_chain_0.D_ff1_5.D_latch1$1_0.NAND2$2_0.A transmission_gate$2$1_7.out.t4 VSS.t501 nfet_03v3 ad=0.2646p pd=2.1u as=0.2646p ps=2.1u w=0.42u l=0.28u
X494 programmable_telescopic_cascode_0.programmable_nfet$6_0.d.t0 programmable_telescopic_cascode_0.programmable_nfet$5_0.transmission_gate$25_1.out programmable_telescopic_cascode_0.programmable_nfet$4_0.s.t0 VSS.t8 nfet_03v3 ad=18.3p pd=61.22u as=18.3p ps=61.22u w=30u l=0.5u
X495 a_68157_79808# scan_chain_0.D_ff1_0.D_latch1$1_0.NAND2$2_0.A SCAN_OUT.t2 VSS.t500 nfet_03v3 ad=0.2646p pd=2.1u as=0.2646p ps=2.1u w=0.42u l=0.28u
X496 VSS.t212 scan_chain_0.D_ff1_7.D_latch1$1_1.Q_bar a_18096_79808# VSS.t211 nfet_03v3 ad=0.2646p pd=2.1u as=0.2646p ps=2.1u w=0.42u l=0.28u
X497 transmission_gate$2$1_4.out.t2 scan_chain_0.D_ff1_8.D_latch1$1_0.NAND2$2_0.A VDD.t406 VDD.t405 pfet_03v3 ad=0.2822p pd=2.18u as=0.2822p ps=2.18u w=0.42u l=0.28u
X498 programmable_folded_cascode_0.programmable_pfet$1_1.transmission_gate$17_1.out.t2 transmission_gate$2$1_6.out.t17 VDD.t536 VDD.t535 pfet_03v3 ad=0.2822p pd=2.18u as=0.2822p ps=2.18u w=0.42u l=0.28u
X499 programmable_folded_cascode_0.OUT.t2 programmable_folded_cascode_0.programmable_pfet$1_0.g.t36 a_49197_2844.t46 VDD.t362 pfet_03v3 ad=19.24p pd=60.5u as=19.24p ps=60.5u w=29.6u l=0.5u
X500 programmable_folded_cascode_0.OUT.t9 programmable_folded_cascode_0.programmable_pfet$1_0.transmission_gate$17_1.out.t9 a_49197_2844.t10 VDD.t151 pfet_03v3 ad=7.696p pd=30.12u as=19.24p ps=60.5u w=29.6u l=0.5u
X501 VDD.t335 programmable_folded_cascode_0.programmable_pfet_1.transmission_gate$16_1.out.t12 a_45880_2844.t30 VDD.t329 pfet_03v3 ad=22.62p pd=70.9u as=9.048p ps=35.32u w=34.8u l=1u
X502 VDD.t61 programmable_folded_cascode_0.programmable_pfet_0.transmission_gate$16_1.out.t13 a_49197_2844.t31 VDD.t60 pfet_03v3 ad=22.62p pd=70.9u as=9.048p ps=35.32u w=34.8u l=1u
X503 VDD.t17 programmable_5tOTA_0.programmable_pfet$4_1.transmission_gate$27_0.out.t4 OUT_5T.t1 VDD.t16 pfet_03v3 ad=32.5p pd=0.1013m as=13p ps=50.52u w=50u l=0.5u
X504 programmable_common_source_0.EN0.t2 scan_chain_0.D_ff1_3.D_latch1$1_0.NAND2$2_2.B VDD.t646 VDD.t645 pfet_03v3 ad=0.2822p pd=2.18u as=0.2822p ps=2.18u w=0.42u l=0.28u
X505 programmable_telescopic_cascode_0.programmable_pfet$2_0.g.t3 transmission_gate$2$1_5.out.t12 programmable_telescopic_cascode_0.programmable_pfet$2_0.transmission_gate$22_1.out.t1 VSS.t4 nfet_03v3 ad=0.2646p pd=2.1u as=0.2646p ps=2.1u w=0.42u l=0.28u
X506 VDD.t334 programmable_folded_cascode_0.programmable_pfet_1.transmission_gate$16_1.out.t13 a_45880_2844.t29 VDD.t329 pfet_03v3 ad=22.62p pd=70.9u as=9.048p ps=35.32u w=34.8u l=1u
X507 programmable_folded_cascode_0.programmable_nfet$2_0.g.t16 programmable_folded_cascode_0.programmable_nfet$1_1.transmission_gate$19_1.out programmable_folded_cascode_0.programmable_nfet$1_0.g.t32 VSS.t482 nfet_03v3 ad=6.405p pd=22.22u as=2.73p ps=11.02u w=10.5u l=0.5u
X508 VDD.t546 programmable_telescopic_cascode_0.programmable_pfet$3_0.transmission_gate$23_1.out.t7 programmable_telescopic_cascode_0.programmable_pfet$3_0.d.t27 VDD.t543 pfet_03v3 ad=26p pd=81.3u as=26p ps=81.3u w=40u l=0.5u
X509 programmable_folded_cascode_0.programmable_pfet_0.transmission_gate$16_1.out.t2 transmission_gate$2$1_6.out.t18 VDD.t538 VDD.t537 pfet_03v3 ad=0.2822p pd=2.18u as=0.2822p ps=2.18u w=0.42u l=0.28u
X510 VDD.t97 programmable_telescopic_cascode_0.programmable_pfet$3_0.transmission_gate$23_0.out.t8 programmable_telescopic_cascode_0.programmable_pfet$3_0.d.t3 VDD.t95 pfet_03v3 ad=26p pd=81.3u as=10.4p ps=40.52u w=40u l=0.5u
X511 VDD.t157 programmable_telescopic_cascode_0.programmable_pfet$3_0.g.t59 programmable_telescopic_cascode_0.programmable_pfet$3_0.d.t20 VDD.t155 pfet_03v3 ad=26p pd=81.3u as=26p ps=81.3u w=40u l=0.5u
X512 programmable_telescopic_cascode_0.programmable_pfet$3_1.d.t19 programmable_telescopic_cascode_0.programmable_pfet$2_0.g.t13 OUT_TELESCOPIC.t12 VDD.t216 pfet_03v3 ad=30.55p pd=95.3u as=30.55p ps=95.3u w=47u l=0.5u
X513 programmable_folded_cascode_0.programmable_nfet_0.transmission_gate$18_1.out transmission_gate$2$1_6.out.t19 INN_FOLDED.t2 VSS.t410 nfet_03v3 ad=0.2646p pd=2.1u as=0.2646p ps=2.1u w=0.42u l=0.28u
X514 a_49197_2844.t1 programmable_folded_cascode_0.programmable_nfet_0.transmission_gate$18_1.out a_55661_23626.t1 VSS.t12 nfet_03v3 ad=7.8p pd=30.52u as=18.3p ps=61.22u w=30u l=0.5u
X515 VSS.t194 programmable_telescopic_cascode_0.programmable_nfet$6_0.transmission_gate$26_1.out programmable_telescopic_cascode_0.programmable_nfet$6_0.d.t8 VSS.t192 nfet_03v3 ad=16.531p pd=55.42u as=16.531p ps=55.42u w=27.1u l=1u
X516 scan_chain_0.D_ff1_1.inv1$4_0.Y CLK.t26 VDD.t632 VDD.t631 pfet_03v3 ad=0.546p pd=2.98u as=0.546p ps=2.98u w=0.84u l=0.28u
X517 programmable_telescopic_cascode_0.programmable_nfet$5_1.d.t0 programmable_telescopic_cascode_0.programmable_nfet$5_1.transmission_gate$25_0.out programmable_telescopic_cascode_0.programmable_nfet$6_0.d.t1 VSS.t42 nfet_03v3 ad=7.8p pd=30.52u as=18.3p ps=61.22u w=30u l=0.5u
X518 programmable_5tOTA_0.programmable_nfet$7_1.transmission_gate$28_0.out transmission_gate$2$1_3.out.t11 INP_5T.t3 VSS.t312 nfet_03v3 ad=0.2646p pd=2.1u as=0.2646p ps=2.1u w=0.42u l=0.28u
X519 OUT_TELESCOPIC.t36 programmable_telescopic_cascode_0.programmable_nfet$4_1.transmission_gate$24_0.out.t9 programmable_telescopic_cascode_0.programmable_nfet$5_1.d.t26 VSS.t120 nfet_03v3 ad=11.7p pd=45.52u as=27.45p ps=91.22u w=45u l=0.4u
X520 scan_chain_0.D_ff1_1.D_latch1$1_1.Q_bar scan_chain_0.D_ff1_1.D_latch1$1_0.D a_33497_79067# VSS.t250 nfet_03v3 ad=0.2646p pd=2.1u as=0.2646p ps=2.1u w=0.42u l=0.28u
X521 scan_chain_0.D_ff1_0.D_latch1$1_1.inv1$3_0.Y programmable_common_source_0.EN1.t11 VSS.t82 VSS.t81 nfet_03v3 ad=0.2646p pd=2.1u as=0.2646p ps=2.1u w=0.42u l=0.28u
X522 a_49197_2844.t55 programmable_folded_cascode_0.programmable_pfet_0.transmission_gate$16_0.out.t9 VDD.t524 VDD.t173 pfet_03v3 ad=22.62p pd=70.9u as=22.62p ps=70.9u w=34.8u l=1u
X523 VSS.t470 CLK.t27 a_32014_79067# VSS.t469 nfet_03v3 ad=0.2646p pd=2.1u as=0.2646p ps=2.1u w=0.42u l=0.28u
X524 INN_TELESCOPIC.t0 programmable_telescopic_cascode_0.EN0.t11 programmable_telescopic_cascode_0.programmable_nfet$5_1.transmission_gate$25_1.out VDD.t40 pfet_03v3 ad=0.2822p pd=2.18u as=0.2822p ps=2.18u w=0.42u l=0.28u
X525 scan_chain_0.D_ff1_6.D_latch1$1_1.inv1$3_0.Y transmission_gate$2$1_7.out.t18 VDD.t699 VDD.t698 pfet_03v3 ad=0.546p pd=2.98u as=0.546p ps=2.98u w=0.84u l=0.28u
X526 OUT_5T.t9 programmable_5tOTA_0.programmable_nfet$7_0.transmission_gate$28_1.out a_91570_47942.t26 VSS.t243 nfet_03v3 ad=2.964p pd=11.92u as=6.954p ps=24.02u w=11.4u l=0.5u
X527 programmable_telescopic_cascode_0.programmable_pfet$3_1.transmission_gate$23_0.out.t2 transmission_gate$2$1_4.out.t13 VDD.t460 VDD.t459 pfet_03v3 ad=0.2822p pd=2.18u as=0.2822p ps=2.18u w=0.42u l=0.28u
X528 programmable_folded_cascode_0.programmable_nfet$1_0.g.t6 programmable_folded_cascode_0.programmable_nfet$1_0.g.t5 programmable_folded_cascode_0.programmable_nfet$2_0.g.t2 VSS.t146 nfet_03v3 ad=6.405p pd=22.22u as=6.405p ps=22.22u w=10.5u l=0.5u
X529 a_49197_2844.t21 programmable_folded_cascode_0.programmable_pfet_0.g.t31 VDD.t194 VDD.t193 pfet_03v3 ad=22.62p pd=70.9u as=22.62p ps=70.9u w=34.8u l=1u
X530 VSS.t144 programmable_telescopic_cascode_0.programmable_pfet$2_0.g.t0 programmable_telescopic_cascode_0.programmable_pfet$2_0.g.t1 VSS.t143 nfet_03v3 ad=0.915p pd=4.22u as=0.915p ps=4.22u w=1.5u l=0.5u
X531 VSS.t34 programmable_telescopic_cascode_0.EN0.t12 programmable_telescopic_cascode_0.programmable_nfet$4_1.transmission_gate$24_1.out.t0 VSS.t33 nfet_03v3 ad=0.2646p pd=2.1u as=0.2646p ps=2.1u w=0.42u l=0.28u
X532 VDD.t242 programmable_telescopic_cascode_0.programmable_pfet$3_1.transmission_gate$23_0.out.t9 programmable_telescopic_cascode_0.programmable_pfet$3_1.d.t24 VDD.t237 pfet_03v3 ad=26p pd=81.3u as=10.4p ps=40.52u w=40u l=0.5u
X533 VDD.t220 a_61069_4063.t16 a_61069_4063.t17 VDD.t131 pfet_03v3 ad=14.95p pd=47.3u as=14.95p ps=47.3u w=23u l=1u
X534 VDD.t5 transmission_gate$2$1_5.out.t13 programmable_telescopic_cascode_0.programmable_pfet$2_1.transmission_gate$22_1.out.t1 VDD.t4 pfet_03v3 ad=0.2822p pd=2.18u as=0.2822p ps=2.18u w=0.42u l=0.28u
X535 a_45880_2844.t28 programmable_folded_cascode_0.programmable_pfet_1.transmission_gate$16_1.out.t14 VDD.t333 VDD.t325 pfet_03v3 ad=9.048p pd=35.32u as=22.62p ps=70.9u w=34.8u l=1u
X536 a_91570_47942.t5 programmable_5tOTA_0.programmable_nfet$7_1.transmission_gate$28_1.out programmable_5tOTA_0.programmable_pfet$4_0.g.t5 VSS.t46 nfet_03v3 ad=6.954p pd=24.02u as=2.964p ps=11.92u w=11.4u l=0.5u
X537 scan_chain_0.D_ff1_2.D_latch1$1_0.inv1$3_0.Y scan_chain_0.D_ff1_2.D_latch1$1_0.D VDD.t567 VDD.t566 pfet_03v3 ad=0.546p pd=2.98u as=0.546p ps=2.98u w=0.84u l=0.28u
X538 VDD.t509 programmable_common_source_0.programmable_pfet$5_0.transmission_gate$30_0.out.t13 OUT_CS.t42 VDD.t461 pfet_03v3 ad=5.98p pd=19.7u as=2.392p ps=9.72u w=9.2u l=1u
X539 OUT_CS.t3 IBIAS.t16 VSS.t170 VSS.t169 nfet_03v3 ad=16.531p pd=55.42u as=16.531p ps=55.42u w=27.1u l=1u
X540 programmable_telescopic_cascode_0.programmable_pfet$3_1.d.t12 programmable_telescopic_cascode_0.programmable_pfet$2_1.transmission_gate$22_0.out.t6 OUT_TELESCOPIC.t41 VDD.t477 pfet_03v3 ad=30.55p pd=95.3u as=12.22p ps=47.52u w=47u l=0.5u
X541 programmable_telescopic_cascode_0.programmable_nfet$4_0.s.t2 programmable_telescopic_cascode_0.programmable_nfet$4_0.transmission_gate$24_1.out.t5 programmable_telescopic_cascode_0.programmable_pfet$3_0.g.t5 VSS.t142 nfet_03v3 ad=27.45p pd=91.22u as=27.45p ps=91.22u w=45u l=0.4u
X542 programmable_folded_cascode_0.OUT.t8 programmable_folded_cascode_0.programmable_pfet$1_0.transmission_gate$17_1.out.t10 a_49197_2844.t11 VDD.t149 pfet_03v3 ad=7.696p pd=30.12u as=19.24p ps=60.5u w=29.6u l=0.5u
X543 programmable_telescopic_cascode_0.programmable_pfet$3_1.d.t20 programmable_telescopic_cascode_0.programmable_pfet$2_0.g.t14 OUT_TELESCOPIC.t13 VDD.t216 pfet_03v3 ad=30.55p pd=95.3u as=30.55p ps=95.3u w=47u l=0.5u
X544 a_1210_79808# SCAN_IN.t1 scan_chain_0.D_ff1_5.D_latch1$1_1.NAND2$2_0.A VSS.t530 nfet_03v3 ad=0.2646p pd=2.1u as=0.2646p ps=2.1u w=0.42u l=0.28u
X545 programmable_common_source_0.EN1.t0 programmable_common_source_0.EN1.t12 a_60455_79067# VSS.t83 nfet_03v3 ad=0.2646p pd=2.1u as=0.2646p ps=2.1u w=0.42u l=0.28u
X546 transmission_gate$2$1_2.out.t0 PROG_ENA.t5 VSS.t75 VDD.t87 pfet_03v3 ad=0.2822p pd=2.18u as=0.2822p ps=2.18u w=0.42u l=0.28u
X547 scan_chain_0.D_ff1_8.D_latch1$1_1.NAND2$2_0.A transmission_gate$2$1_5.out.t14 VDD.t7 VDD.t6 pfet_03v3 ad=0.2822p pd=2.18u as=0.2822p ps=2.18u w=0.42u l=0.28u
X548 VDD.t387 programmable_5tOTA_0.programmable_pfet$4_0.g.t31 OUT_5T.t13 VDD.t309 pfet_03v3 ad=32.5p pd=0.1013m as=32.5p ps=0.1013m w=50u l=0.5u
X549 a_91570_47942.t4 programmable_5tOTA_0.programmable_nfet$7_1.transmission_gate$28_1.out programmable_5tOTA_0.programmable_pfet$4_0.g.t4 VSS.t46 nfet_03v3 ad=6.954p pd=24.02u as=2.964p ps=11.92u w=11.4u l=0.5u
X550 VDD.t634 CLK.t28 scan_chain_0.D_ff1_3.D_latch1$1_1.NAND2$2_0.A VDD.t633 pfet_03v3 ad=0.2822p pd=2.18u as=0.2822p ps=2.18u w=0.42u l=0.28u
X551 a_5065_79067# scan_chain_0.D_ff1_5.D_latch1$1_0.inv1$3_0.Y scan_chain_0.D_ff1_5.D_latch1$1_0.NAND2$2_2.B VSS.t454 nfet_03v3 ad=0.2646p pd=2.1u as=0.2646p ps=2.1u w=0.42u l=0.28u
X552 VSS.t276 scan_chain_0.D_ff1_3.inv1$4_0.Y a_51271_79067# VSS.t275 nfet_03v3 ad=0.2646p pd=2.1u as=0.2646p ps=2.1u w=0.42u l=0.28u
X553 scan_chain_0.D_ff1_2.D_latch1$1_0.D scan_chain_0.D_ff1_2.D_latch1$1_1.NAND2$2_0.A VDD.t9 VDD.t8 pfet_03v3 ad=0.2822p pd=2.18u as=0.2822p ps=2.18u w=0.42u l=0.28u
X554 VDD.t547 programmable_telescopic_cascode_0.programmable_pfet$3_0.transmission_gate$23_1.out.t8 programmable_telescopic_cascode_0.programmable_pfet$3_0.d.t28 VDD.t543 pfet_03v3 ad=26p pd=81.3u as=26p ps=81.3u w=40u l=0.5u
X555 VDD.t312 scan_chain_0.D_ff1_0.D_latch1$1_1.Q_bar scan_chain_0.D_ff1_0.D_latch1$1_0.D VDD.t311 pfet_03v3 ad=0.2822p pd=2.18u as=0.2822p ps=2.18u w=0.42u l=0.28u
X556 scan_chain_0.D_ff1_4.D_latch1$1_0.inv1$3_0.Y scan_chain_0.D_ff1_4.D_latch1$1_0.D VDD.t428 VDD.t427 pfet_03v3 ad=0.546p pd=2.98u as=0.546p ps=2.98u w=0.84u l=0.28u
X557 VDD.t158 programmable_telescopic_cascode_0.programmable_pfet$3_0.g.t60 programmable_telescopic_cascode_0.programmable_pfet$3_0.d.t19 VDD.t155 pfet_03v3 ad=26p pd=81.3u as=26p ps=81.3u w=40u l=0.5u
X558 OUT_TELESCOPIC.t42 programmable_telescopic_cascode_0.programmable_pfet$2_1.transmission_gate$22_0.out.t7 programmable_telescopic_cascode_0.programmable_pfet$3_1.d.t11 VDD.t139 pfet_03v3 ad=12.22p pd=47.52u as=30.55p ps=95.3u w=47u l=0.5u
X559 programmable_folded_cascode_0.programmable_nfet$2_0.g.t0 programmable_folded_cascode_0.EN0.t15 programmable_folded_cascode_0.programmable_nfet$2_1.transmission_gate$20_0.out VDD.t128 pfet_03v3 ad=0.2822p pd=2.18u as=0.2822p ps=2.18u w=0.42u l=0.28u
X560 programmable_telescopic_cascode_0.programmable_nfet$5_1.d.t17 programmable_telescopic_cascode_0.programmable_nfet$4_0.g.t19 OUT_TELESCOPIC.t28 VSS.t189 nfet_03v3 ad=27.45p pd=91.22u as=27.45p ps=91.22u w=45u l=0.4u
X561 a_49197_2844.t60 programmable_folded_cascode_0.programmable_pfet_0.g.t32 VDD.t592 VDD.t183 pfet_03v3 ad=22.62p pd=70.9u as=22.62p ps=70.9u w=34.8u l=1u
X562 programmable_folded_cascode_0.EN0.t2 transmission_gate$2$1_7.out.t19 a_6548_79067# VSS.t517 nfet_03v3 ad=0.2646p pd=2.1u as=0.2646p ps=2.1u w=0.42u l=0.28u
X563 scan_chain_0.D_ff1_7.D_latch1$1_1.NAND2$2_2.B scan_chain_0.D_ff1_7.D_latch1$1_1.inv1$3_0.Y VDD.t559 VDD.t558 pfet_03v3 ad=0.2822p pd=2.18u as=0.2822p ps=2.18u w=0.42u l=0.28u
X564 programmable_5tOTA_0.programmable_pfet$4_0.g.t22 programmable_5tOTA_0.programmable_nfet$7_1.transmission_gate$28_0.out a_91570_47942.t30 VSS.t334 nfet_03v3 ad=6.954p pd=24.02u as=6.954p ps=24.02u w=11.4u l=0.5u
X565 VSS.t451 scan_chain_0.D_ff1_0.inv1$4_0.Y a_66673_79067# VSS.t450 nfet_03v3 ad=0.2646p pd=2.1u as=0.2646p ps=2.1u w=0.42u l=0.28u
X566 a_58284_41264.t4 programmable_folded_cascode_0.programmable_nfet$2_0.g.t17 VSS.t430 VSS.t429 nfet_03v3 ad=12.505p pd=42.22u as=12.505p ps=42.22u w=20.5u l=1u
X567 scan_chain_0.D_ff1_1.D_latch1$1_1.Q_bar scan_chain_0.D_ff1_1.D_latch1$1_1.NAND2$2_2.B VDD.t75 VDD.t74 pfet_03v3 ad=0.2822p pd=2.18u as=0.2822p ps=2.18u w=0.42u l=0.28u
X568 programmable_telescopic_cascode_0.programmable_pfet$3_1.d.t10 programmable_telescopic_cascode_0.programmable_pfet$2_1.transmission_gate$22_0.out.t8 OUT_TELESCOPIC.t24 VDD.t477 pfet_03v3 ad=30.55p pd=95.3u as=12.22p ps=47.52u w=47u l=0.5u
X569 scan_chain_0.D_ff1_0.inv1$4_0.Y CLK.t29 VSS.t472 VSS.t471 nfet_03v3 ad=0.2646p pd=2.1u as=0.2646p ps=2.1u w=0.42u l=0.28u
X570 programmable_telescopic_cascode_0.programmable_nfet$4_0.s.t19 programmable_telescopic_cascode_0.programmable_nfet$4_0.transmission_gate$24_0.out.t9 programmable_telescopic_cascode_0.programmable_pfet$3_0.g.t47 VSS.t428 nfet_03v3 ad=27.45p pd=91.22u as=11.7p ps=45.52u w=45u l=0.4u
X571 a_49197_2844.t30 programmable_folded_cascode_0.programmable_pfet_0.transmission_gate$16_1.out.t14 VDD.t62 VDD.t57 pfet_03v3 ad=9.048p pd=35.32u as=22.62p ps=70.9u w=34.8u l=1u
X572 scan_chain_0.D_ff1_6.D_latch1$1_1.NAND2$2_2.B scan_chain_0.D_ff1_6.D_latch1$1_1.inv1$3_0.Y VDD.t11 VDD.t10 pfet_03v3 ad=0.2822p pd=2.18u as=0.2822p ps=2.18u w=0.42u l=0.28u
X573 programmable_5tOTA_0.programmable_pfet$4_0.transmission_gate$27_1.out.t0 programmable_5tOTA_0.ena_bar<0>.t11 programmable_5tOTA_0.programmable_pfet$4_0.g.t6 VDD.t63 pfet_03v3 ad=0.2822p pd=2.18u as=0.2822p ps=2.18u w=0.42u l=0.28u
X574 a_48900_79808# scan_chain_0.D_ff1_3.D_latch1$1_1.NAND2$2_0.A scan_chain_0.D_ff1_3.D_latch1$1_0.D VSS.t400 nfet_03v3 ad=0.2646p pd=2.1u as=0.2646p ps=2.1u w=0.42u l=0.28u
X575 scan_chain_0.D_ff1_2.D_latch1$1_0.NAND2$2_0.A scan_chain_0.D_ff1_2.D_latch1$1_0.D VDD.t565 VDD.t564 pfet_03v3 ad=0.2822p pd=2.18u as=0.2822p ps=2.18u w=0.42u l=0.28u
X576 programmable_telescopic_cascode_0.programmable_pfet$3_0.g.t48 programmable_telescopic_cascode_0.programmable_nfet$4_0.transmission_gate$24_0.out.t10 programmable_telescopic_cascode_0.programmable_nfet$4_0.s.t18 VSS.t161 nfet_03v3 ad=11.7p pd=45.52u as=27.45p ps=91.22u w=45u l=0.4u
X577 VDD.t257 programmable_common_source_0.programmable_pfet$5_0.transmission_gate$30_1.out.t7 OUT_CS.t19 VDD.t256 pfet_03v3 ad=5.98p pd=19.7u as=5.98p ps=19.7u w=9.2u l=1u
X578 programmable_common_source_0.EN1.t2 scan_chain_0.D_ff1_4.D_latch1$1_0.NAND2$2_0.A VDD.t77 VDD.t76 pfet_03v3 ad=0.2822p pd=2.18u as=0.2822p ps=2.18u w=0.42u l=0.28u
X579 programmable_telescopic_cascode_0.programmable_nfet$5_1.d.t10 programmable_telescopic_cascode_0.programmable_nfet$4_1.transmission_gate$24_1.out.t6 OUT_TELESCOPIC.t8 VSS.t145 nfet_03v3 ad=27.45p pd=91.22u as=27.45p ps=91.22u w=45u l=0.4u
X580 programmable_telescopic_cascode_0.programmable_nfet$6_0.transmission_gate$26_0.out.t2 programmable_telescopic_cascode_0.EN1.t11 IBIAS.t8 VDD.t640 pfet_03v3 ad=0.2822p pd=2.18u as=0.2822p ps=2.18u w=0.42u l=0.28u
X581 a_45880_2844.t49 programmable_folded_cascode_0.programmable_pfet_0.g.t33 VDD.t594 VDD.t593 pfet_03v3 ad=22.62p pd=70.9u as=22.62p ps=70.9u w=34.8u l=1u
X582 VDD.t707 programmable_5tOTA_0.ena_bar<1>.t6 transmission_gate$2$1_2.out.t4 VDD.t706 pfet_03v3 ad=0.2822p pd=2.18u as=0.2822p ps=2.18u w=0.42u l=0.28u
X583 programmable_folded_cascode_0.programmable_nfet$2_0.g.t13 programmable_folded_cascode_0.programmable_nfet$2_1.transmission_gate$20_0.out VSS.t247 VSS.t246 nfet_03v3 ad=12.505p pd=42.22u as=12.505p ps=42.22u w=20.5u l=1u
X584 programmable_folded_cascode_0.programmable_pfet$1_1.transmission_gate$17_1.out.t0 programmable_folded_cascode_0.EN1.t11 programmable_folded_cascode_0.programmable_pfet$1_0.g.t24 VDD.t680 pfet_03v3 ad=0.2822p pd=2.18u as=0.2822p ps=2.18u w=0.42u l=0.28u
X585 VSS.t474 CLK.t30 a_55117_79808# VSS.t473 nfet_03v3 ad=0.2646p pd=2.1u as=0.2646p ps=2.1u w=0.42u l=0.28u
X586 OUT_TELESCOPIC.t25 programmable_telescopic_cascode_0.programmable_pfet$2_1.transmission_gate$22_0.out.t9 programmable_telescopic_cascode_0.programmable_pfet$3_1.d.t9 VDD.t139 pfet_03v3 ad=12.22p pd=47.52u as=30.55p ps=95.3u w=47u l=0.5u
X587 scan_chain_0.D_ff1_1.D_latch1$1_0.NAND2$2_2.B scan_chain_0.D_ff1_1.D_latch1$1_0.inv1$3_0.Y VDD.t434 VDD.t433 pfet_03v3 ad=0.2822p pd=2.18u as=0.2822p ps=2.18u w=0.42u l=0.28u
X588 VSS.t333 scan_chain_0.D_ff1_5.D_latch1$1_1.Q_bar a_2694_79808# VSS.t332 nfet_03v3 ad=0.2646p pd=2.1u as=0.2646p ps=2.1u w=0.42u l=0.28u
X589 VDD.t462 programmable_common_source_0.programmable_pfet$5_0.transmission_gate$30_0.out.t14 OUT_CS.t24 VDD.t461 pfet_03v3 ad=5.98p pd=19.7u as=2.392p ps=9.72u w=9.2u l=1u
X590 VDD.t382 programmable_telescopic_cascode_0.programmable_nfet$4_0.g.t20 programmable_telescopic_cascode_0.programmable_pfet$2_0.g.t10 VDD.t381 pfet_03v3 ad=45.5p pd=0.1413m as=45.5p ps=0.1413m w=70u l=0.5u
X591 programmable_folded_cascode_0.EN1.t0 scan_chain_0.D_ff1_6.D_latch1$1_0.NAND2$2_2.B VDD.t418 VDD.t417 pfet_03v3 ad=0.2822p pd=2.18u as=0.2822p ps=2.18u w=0.42u l=0.28u
X592 programmable_folded_cascode_0.OUT.t21 programmable_folded_cascode_0.programmable_pfet$1_0.transmission_gate$17_0.out.t5 a_49197_2844.t64 VDD.t648 pfet_03v3 ad=19.24p pd=60.5u as=19.24p ps=60.5u w=29.6u l=0.5u
X593 VDD.t463 programmable_common_source_0.programmable_pfet$5_0.transmission_gate$30_0.out.t15 OUT_CS.t25 VDD.t461 pfet_03v3 ad=5.98p pd=19.7u as=2.392p ps=9.72u w=9.2u l=1u
X594 VDD.t56 transmission_gate$2$1_3.out.t12 programmable_5tOTA_0.ena_bar<0>.t1 VDD.t55 pfet_03v3 ad=0.2822p pd=2.18u as=0.2822p ps=2.18u w=0.42u l=0.28u
X595 programmable_folded_cascode_0.programmable_pfet_0.transmission_gate$16_1.out.t0 programmable_folded_cascode_0.EN1.t12 programmable_folded_cascode_0.programmable_pfet_0.g.t14 VDD.t681 pfet_03v3 ad=0.2822p pd=2.18u as=0.2822p ps=2.18u w=0.42u l=0.28u
X596 programmable_folded_cascode_0.programmable_nfet$2_1.transmission_gate$20_1.out programmable_folded_cascode_0.EN1.t13 VSS.t509 VSS.t508 nfet_03v3 ad=0.2646p pd=2.1u as=0.2646p ps=2.1u w=0.42u l=0.28u
X597 VSS.t445 programmable_folded_cascode_0.EN0.t16 programmable_folded_cascode_0.programmable_nfet$2_1.transmission_gate$20_0.out VSS.t444 nfet_03v3 ad=0.2646p pd=2.1u as=0.2646p ps=2.1u w=0.42u l=0.28u
X598 VDD.t159 programmable_telescopic_cascode_0.programmable_pfet$3_0.g.t61 programmable_telescopic_cascode_0.programmable_pfet$3_0.d.t18 VDD.t155 pfet_03v3 ad=26p pd=81.3u as=26p ps=81.3u w=40u l=0.5u
X599 VDD.t332 programmable_folded_cascode_0.programmable_pfet_1.transmission_gate$16_1.out.t15 a_45880_2844.t27 VDD.t329 pfet_03v3 ad=22.62p pd=70.9u as=9.048p ps=35.32u w=34.8u l=1u
X600 a_29652_79808# scan_chain_0.D_ff1_8.D_latch1$1_0.NAND2$2_0.A transmission_gate$2$1_4.out.t1 VSS.t297 nfet_03v3 ad=0.2646p pd=2.1u as=0.2646p ps=2.1u w=0.42u l=0.28u
X601 a_49197_2844.t56 programmable_folded_cascode_0.programmable_pfet_0.transmission_gate$16_0.out.t10 VDD.t525 VDD.t173 pfet_03v3 ad=22.62p pd=70.9u as=22.62p ps=70.9u w=34.8u l=1u
X602 VSS.t295 scan_chain_0.D_ff1_6.inv1$4_0.Y a_12766_79808# VSS.t294 nfet_03v3 ad=0.2646p pd=2.1u as=0.2646p ps=2.1u w=0.42u l=0.28u
X603 a_64301_79067# scan_chain_0.D_ff1_0.D_latch1$1_1.NAND2$2_2.B VSS.t262 VSS.t261 nfet_03v3 ad=0.2646p pd=2.1u as=0.2646p ps=2.1u w=0.42u l=0.28u
X604 a_45880_2844.t9 programmable_folded_cascode_0.programmable_pfet$1_1.transmission_gate$17_1.out.t10 programmable_folded_cascode_0.programmable_nfet$1_0.g.t12 VDD.t122 pfet_03v3 ad=19.24p pd=60.5u as=7.696p ps=30.12u w=29.6u l=0.5u
X605 VDD.t464 programmable_common_source_0.programmable_pfet$5_0.transmission_gate$30_0.out.t16 OUT_CS.t26 VDD.t461 pfet_03v3 ad=5.98p pd=19.7u as=2.392p ps=9.72u w=9.2u l=1u
X606 a_62818_79067# scan_chain_0.D_ff1_0.D_latch1$1_1.inv1$3_0.Y scan_chain_0.D_ff1_0.D_latch1$1_1.NAND2$2_2.B VSS.t23 nfet_03v3 ad=0.2646p pd=2.1u as=0.2646p ps=2.1u w=0.42u l=0.28u
X607 programmable_folded_cascode_0.EN0.t0 scan_chain_0.D_ff1_5.D_latch1$1_0.NAND2$2_2.B VDD.t145 VDD.t144 pfet_03v3 ad=0.2822p pd=2.18u as=0.2822p ps=2.18u w=0.42u l=0.28u
X608 programmable_telescopic_cascode_0.programmable_pfet$2_0.transmission_gate$22_0.out.t2 transmission_gate$2$1_4.out.t14 VDD.t530 VDD.t529 pfet_03v3 ad=0.2822p pd=2.18u as=0.2822p ps=2.18u w=0.42u l=0.28u
X609 programmable_telescopic_cascode_0.programmable_pfet$3_0.g.t37 programmable_telescopic_cascode_0.programmable_pfet$2_0.transmission_gate$22_0.out.t8 programmable_telescopic_cascode_0.programmable_pfet$3_0.d.t33 VDD.t622 pfet_03v3 ad=12.22p pd=47.52u as=30.55p ps=95.3u w=47u l=0.5u
X610 programmable_folded_cascode_0.programmable_nfet$1_1.transmission_gate$19_1.out programmable_folded_cascode_0.EN1.t14 programmable_folded_cascode_0.programmable_nfet$1_0.g.t18 VDD.t682 pfet_03v3 ad=0.2822p pd=2.18u as=0.2822p ps=2.18u w=0.42u l=0.28u
X611 a_49197_2844.t29 programmable_folded_cascode_0.programmable_pfet_0.transmission_gate$16_1.out.t15 VDD.t89 VDD.t57 pfet_03v3 ad=9.048p pd=35.32u as=22.62p ps=70.9u w=34.8u l=1u
X612 scan_chain_0.D_ff1_0.Q_bar scan_chain_0.D_ff1_0.D_latch1$1_0.NAND2$2_2.B VDD.t499 VDD.t498 pfet_03v3 ad=0.2822p pd=2.18u as=0.2822p ps=2.18u w=0.42u l=0.28u
X613 VSS.t130 scan_chain_0.D_ff1_5.inv1$4_0.Y a_5065_79808# VSS.t129 nfet_03v3 ad=0.2646p pd=2.1u as=0.2646p ps=2.1u w=0.42u l=0.28u
X614 OUT_5T.t18 programmable_5tOTA_0.programmable_nfet$7_0.transmission_gate$28_0.out a_91570_47942.t34 VSS.t443 nfet_03v3 ad=6.954p pd=24.02u as=6.954p ps=24.02u w=11.4u l=0.5u
X615 programmable_telescopic_cascode_0.programmable_pfet$3_1.transmission_gate$23_0.out.t0 programmable_telescopic_cascode_0.EN1.t12 programmable_telescopic_cascode_0.programmable_pfet$3_0.g.t11 VDD.t641 pfet_03v3 ad=0.2822p pd=2.18u as=0.2822p ps=2.18u w=0.42u l=0.28u
X616 a_45880_2844.t50 programmable_folded_cascode_0.programmable_pfet_0.g.t34 VDD.t595 VDD.t593 pfet_03v3 ad=22.62p pd=70.9u as=22.62p ps=70.9u w=34.8u l=1u
X617 IBIAS.t7 programmable_5tOTA_0.ena_bar<1>.t7 programmable_5tOTA_0.programmable_nfet$8_0.transmission_gate$29_1.out.t1 VDD.t708 pfet_03v3 ad=0.2822p pd=2.18u as=0.2822p ps=2.18u w=0.42u l=0.28u
X618 VSS.t36 programmable_telescopic_cascode_0.EN0.t13 programmable_telescopic_cascode_0.programmable_nfet$5_1.transmission_gate$25_1.out VSS.t35 nfet_03v3 ad=0.2646p pd=2.1u as=0.2646p ps=2.1u w=0.42u l=0.28u
X619 programmable_telescopic_cascode_0.programmable_nfet$5_1.transmission_gate$25_0.out programmable_telescopic_cascode_0.EN1.t13 VSS.t480 VSS.t479 nfet_03v3 ad=0.2646p pd=2.1u as=0.2646p ps=2.1u w=0.42u l=0.28u
X620 VSS.t27 programmable_common_source_0.EN0.t4 a_52755_79808# VSS.t26 nfet_03v3 ad=0.2646p pd=2.1u as=0.2646p ps=2.1u w=0.42u l=0.28u
X621 scan_chain_0.D_ff1_4.D_latch1$1_1.Q_bar scan_chain_0.D_ff1_4.D_latch1$1_0.D a_56600_79067# VSS.t324 nfet_03v3 ad=0.2646p pd=2.1u as=0.2646p ps=2.1u w=0.42u l=0.28u
X622 programmable_telescopic_cascode_0.programmable_nfet$5_0.transmission_gate$25_0.out transmission_gate$2$1_4.out.t15 INP_TELESCOPIC.t3 VSS.t371 nfet_03v3 ad=0.2646p pd=2.1u as=0.2646p ps=2.1u w=0.42u l=0.28u
X623 a_45880_2844.t54 programmable_folded_cascode_0.programmable_pfet_1.transmission_gate$16_0.out.t9 VDD.t604 VDD.t603 pfet_03v3 ad=22.62p pd=70.9u as=22.62p ps=70.9u w=34.8u l=1u
X624 a_20467_79067# scan_chain_0.D_ff1_7.D_latch1$1_0.inv1$3_0.Y scan_chain_0.D_ff1_7.D_latch1$1_0.NAND2$2_2.B VSS.t52 nfet_03v3 ad=0.2646p pd=2.1u as=0.2646p ps=2.1u w=0.42u l=0.28u
X625 VSS.t40 programmable_folded_cascode_0.programmable_nfet$3_0.transmission_gate$21_1.out.t6 a_55661_23626.t6 VSS.t39 nfet_03v3 ad=12.2p pd=41.22u as=5.2p ps=20.52u w=20u l=1u
X626 scan_chain_0.D_ff1_7.D_latch1$1_1.inv1$3_0.Y transmission_gate$2$1_6.out.t20 VDD.t684 VDD.t683 pfet_03v3 ad=0.546p pd=2.98u as=0.546p ps=2.98u w=0.84u l=0.28u
X627 programmable_telescopic_cascode_0.programmable_pfet$3_1.d.t8 programmable_telescopic_cascode_0.programmable_pfet$2_1.transmission_gate$22_0.out.t10 OUT_TELESCOPIC.t37 VDD.t477 pfet_03v3 ad=30.55p pd=95.3u as=12.22p ps=47.52u w=47u l=0.5u
X628 a_45880_2844.t55 programmable_folded_cascode_0.programmable_pfet_1.transmission_gate$16_0.out.t10 VDD.t606 VDD.t605 pfet_03v3 ad=22.62p pd=70.9u as=22.62p ps=70.9u w=34.8u l=1u
X629 VSS.t447 programmable_folded_cascode_0.EN0.t17 programmable_folded_cascode_0.programmable_nfet$1_1.transmission_gate$19_0.out VSS.t446 nfet_03v3 ad=0.2646p pd=2.1u as=0.2646p ps=2.1u w=0.42u l=0.28u
X630 INP_5T.t0 programmable_5tOTA_0.ena_bar<1>.t8 programmable_5tOTA_0.programmable_nfet$7_1.transmission_gate$28_1.out VDD.t709 pfet_03v3 ad=0.2822p pd=2.18u as=0.2822p ps=2.18u w=0.42u l=0.28u
X631 programmable_folded_cascode_0.programmable_pfet$1_0.g.t27 programmable_folded_cascode_0.EN0.t18 programmable_folded_cascode_0.programmable_pfet$1_1.transmission_gate$17_0.out.t0 VDD.t601 pfet_03v3 ad=0.2822p pd=2.18u as=0.2822p ps=2.18u w=0.42u l=0.28u
X632 programmable_telescopic_cascode_0.programmable_pfet$3_0.g.t38 programmable_telescopic_cascode_0.programmable_pfet$2_0.transmission_gate$22_0.out.t9 programmable_telescopic_cascode_0.programmable_pfet$3_0.d.t34 VDD.t622 pfet_03v3 ad=12.22p pd=47.52u as=30.55p ps=95.3u w=47u l=0.5u
X633 programmable_common_source_0.programmable_pfet$5_0.transmission_gate$30_0.out.t2 programmable_common_source_0.EN1.t13 IN_CS.t2 VSS.t147 nfet_03v3 ad=0.2646p pd=2.1u as=0.2646p ps=2.1u w=0.42u l=0.28u
X634 programmable_telescopic_cascode_0.EN0.t0 transmission_gate$2$1_5.out.t15 a_21950_79067# VSS.t0 nfet_03v3 ad=0.2646p pd=2.1u as=0.2646p ps=2.1u w=0.42u l=0.28u
X635 programmable_folded_cascode_0.programmable_nfet$1_0.g.t3 programmable_folded_cascode_0.programmable_pfet$1_1.transmission_gate$17_0.out.t6 a_45880_2844.t3 VDD.t21 pfet_03v3 ad=19.24p pd=60.5u as=19.24p ps=60.5u w=29.6u l=0.5u
X636 a_91570_47942.t17 IBIAS.t17 VSS.t171 VSS.t110 nfet_03v3 ad=13.908p pd=46.82u as=13.908p ps=46.82u w=22.8u l=1u
X637 VDD.t331 programmable_folded_cascode_0.programmable_pfet_1.transmission_gate$16_1.out.t16 a_45880_2844.t26 VDD.t329 pfet_03v3 ad=22.62p pd=70.9u as=9.048p ps=35.32u w=34.8u l=1u
X638 VDD.t636 CLK.t31 scan_chain_0.D_ff1_2.D_latch1$1_1.NAND2$2_0.A VDD.t635 pfet_03v3 ad=0.2822p pd=2.18u as=0.2822p ps=2.18u w=0.42u l=0.28u
X639 programmable_folded_cascode_0.programmable_nfet$2_0.g.t1 programmable_folded_cascode_0.EN0.t19 programmable_folded_cascode_0.programmable_nfet$2_0.transmission_gate$20_0.out VDD.t602 pfet_03v3 ad=0.2822p pd=2.18u as=0.2822p ps=2.18u w=0.42u l=0.28u
X640 programmable_5tOTA_0.programmable_pfet$4_0.g.t8 INP_5T.t5 a_91570_47942.t14 VSS.t139 nfet_03v3 ad=6.954p pd=24.02u as=6.954p ps=24.02u w=11.4u l=0.5u
X641 programmable_folded_cascode_0.programmable_nfet$1_0.g.t29 programmable_folded_cascode_0.programmable_nfet$1_1.transmission_gate$19_0.out programmable_folded_cascode_0.programmable_nfet$2_0.g.t14 VSS.t291 nfet_03v3 ad=6.405p pd=22.22u as=6.405p ps=22.22u w=10.5u l=0.5u
X642 VDD.t483 programmable_telescopic_cascode_0.programmable_nfet$4_0.g.t9 programmable_telescopic_cascode_0.programmable_nfet$4_0.g.t10 VDD.t482 pfet_03v3 ad=45.5p pd=0.1413m as=45.5p ps=0.1413m w=70u l=0.5u
X643 scan_chain_0.D_ff1_6.inv1$4_0.Y CLK.t32 VSS.t196 VSS.t195 nfet_03v3 ad=0.2646p pd=2.1u as=0.2646p ps=2.1u w=0.42u l=0.28u
X644 programmable_telescopic_cascode_0.programmable_nfet$4_0.s.t9 programmable_telescopic_cascode_0.programmable_nfet$4_0.g.t21 programmable_telescopic_cascode_0.programmable_pfet$3_0.g.t26 VSS.t190 nfet_03v3 ad=27.45p pd=91.22u as=27.45p ps=91.22u w=45u l=0.4u
X645 programmable_telescopic_cascode_0.programmable_nfet$5_1.d.t3 programmable_telescopic_cascode_0.programmable_nfet$4_1.transmission_gate$24_0.out.t10 OUT_TELESCOPIC.t0 VSS.t119 nfet_03v3 ad=27.45p pd=91.22u as=11.7p ps=45.52u w=45u l=0.4u
X646 scan_chain_0.D_ff1_3.D_latch1$1_1.NAND2$2_0.A transmission_gate$2$1_2.out.t10 VDD.t551 VDD.t550 pfet_03v3 ad=0.2822p pd=2.18u as=0.2822p ps=2.18u w=0.42u l=0.28u
X647 scan_chain_0.D_ff1_6.D_latch1$1_1.inv1$3_0.Y transmission_gate$2$1_7.out.t20 VSS.t519 VSS.t518 nfet_03v3 ad=0.2646p pd=2.1u as=0.2646p ps=2.1u w=0.42u l=0.28u
X648 VSS.t198 CLK.t33 a_47416_79067# VSS.t197 nfet_03v3 ad=0.2646p pd=2.1u as=0.2646p ps=2.1u w=0.42u l=0.28u
X649 VDD.t701 transmission_gate$2$1_7.out.t21 programmable_folded_cascode_0.programmable_pfet$1_0.transmission_gate$17_0.out.t2 VDD.t700 pfet_03v3 ad=0.2822p pd=2.18u as=0.2822p ps=2.18u w=0.42u l=0.28u
X650 scan_chain_0.D_ff1_5.inv1$4_0.Y CLK.t34 VSS.t200 VSS.t199 nfet_03v3 ad=0.2646p pd=2.1u as=0.2646p ps=2.1u w=0.42u l=0.28u
X651 programmable_folded_cascode_0.programmable_nfet$3_0.transmission_gate$21_1.out.t0 programmable_folded_cascode_0.EN1.t15 VSS.t381 VSS.t380 nfet_03v3 ad=0.2646p pd=2.1u as=0.2646p ps=2.1u w=0.42u l=0.28u
X652 INN_FOLDED.t3 transmission_gate$2$1_7.out.t22 programmable_folded_cascode_0.programmable_nfet_0.transmission_gate$18_0.out VSS.t520 nfet_03v3 ad=0.2646p pd=2.1u as=0.2646p ps=2.1u w=0.42u l=0.28u
X653 programmable_5tOTA_0.programmable_pfet$4_0.g.t9 INP_5T.t6 a_91570_47942.t15 VSS.t139 nfet_03v3 ad=6.954p pd=24.02u as=6.954p ps=24.02u w=11.4u l=0.5u
X654 VDD.t263 CLK.t35 scan_chain_0.D_ff1_1.D_latch1$1_1.NAND2$2_2.B VDD.t262 pfet_03v3 ad=0.2822p pd=2.18u as=0.2822p ps=2.18u w=0.42u l=0.28u
X655 INP_5T.t1 transmission_gate$2$1_2.out.t11 programmable_5tOTA_0.programmable_nfet$7_1.transmission_gate$28_1.out VSS.t424 nfet_03v3 ad=0.2646p pd=2.1u as=0.2646p ps=2.1u w=0.42u l=0.28u
X656 a_24313_79808# transmission_gate$2$1_5.out.t16 scan_chain_0.D_ff1_8.D_latch1$1_1.NAND2$2_0.A VSS.t1 nfet_03v3 ad=0.2646p pd=2.1u as=0.2646p ps=2.1u w=0.42u l=0.28u
X657 scan_chain_0.D_ff1_2.D_latch1$1_0.inv1$3_0.Y scan_chain_0.D_ff1_2.D_latch1$1_0.D VSS.t436 VSS.t435 nfet_03v3 ad=0.2646p pd=2.1u as=0.2646p ps=2.1u w=0.42u l=0.28u
X658 scan_chain_0.D_ff1_5.D_latch1$1_1.NAND2$2_2.B scan_chain_0.D_ff1_5.D_latch1$1_1.inv1$3_0.Y VDD.t164 VDD.t163 pfet_03v3 ad=0.2822p pd=2.18u as=0.2822p ps=2.18u w=0.42u l=0.28u
X659 a_41199_79808# scan_chain_0.D_ff1_2.D_latch1$1_1.NAND2$2_0.A scan_chain_0.D_ff1_2.D_latch1$1_0.D VSS.t5 nfet_03v3 ad=0.2646p pd=2.1u as=0.2646p ps=2.1u w=0.42u l=0.28u
X660 programmable_telescopic_cascode_0.programmable_pfet$2_1.transmission_gate$22_0.out.t2 transmission_gate$2$1_4.out.t16 VDD.t39 VDD.t38 pfet_03v3 ad=0.2822p pd=2.18u as=0.2822p ps=2.18u w=0.42u l=0.28u
X661 VDD.t243 programmable_telescopic_cascode_0.programmable_pfet$3_1.transmission_gate$23_0.out.t10 programmable_telescopic_cascode_0.programmable_pfet$3_1.d.t25 VDD.t237 pfet_03v3 ad=26p pd=81.3u as=10.4p ps=40.52u w=40u l=0.5u
X662 VDD.t90 programmable_folded_cascode_0.programmable_pfet_0.transmission_gate$16_1.out.t16 a_49197_2844.t28 VDD.t78 pfet_03v3 ad=22.62p pd=70.9u as=9.048p ps=35.32u w=34.8u l=1u
X663 programmable_folded_cascode_0.programmable_nfet$1_0.g.t7 programmable_folded_cascode_0.programmable_pfet$1_0.g.t37 a_45880_2844.t42 VDD.t361 pfet_03v3 ad=19.24p pd=60.5u as=19.24p ps=60.5u w=29.6u l=0.5u
X664 VSS.t449 programmable_folded_cascode_0.EN0.t20 programmable_folded_cascode_0.programmable_nfet_1.transmission_gate$18_0.out VSS.t448 nfet_03v3 ad=0.2646p pd=2.1u as=0.2646p ps=2.1u w=0.42u l=0.28u
X665 programmable_folded_cascode_0.programmable_pfet$1_0.transmission_gate$17_1.out.t2 transmission_gate$2$1_6.out.t21 VDD.t686 VDD.t685 pfet_03v3 ad=0.2822p pd=2.18u as=0.2822p ps=2.18u w=0.42u l=0.28u
X666 VDD.t273 scan_chain_0.D_ff1_7.D_latch1$1_1.Q_bar scan_chain_0.D_ff1_7.D_latch1$1_0.D VDD.t272 pfet_03v3 ad=0.2822p pd=2.18u as=0.2822p ps=2.18u w=0.42u l=0.28u
X667 scan_chain_0.D_ff1_2.D_latch1$1_1.NAND2$2_0.A transmission_gate$2$1_3.out.t13 VDD.t182 VDD.t181 pfet_03v3 ad=0.2822p pd=2.18u as=0.2822p ps=2.18u w=0.42u l=0.28u
X668 programmable_telescopic_cascode_0.programmable_pfet$2_1.transmission_gate$22_0.out.t1 transmission_gate$2$1_4.out.t17 programmable_telescopic_cascode_0.programmable_pfet$2_0.g.t8 VSS.t370 nfet_03v3 ad=0.2646p pd=2.1u as=0.2646p ps=2.1u w=0.42u l=0.28u
X669 VSS.t202 CLK.t36 a_16612_79808# VSS.t201 nfet_03v3 ad=0.2646p pd=2.1u as=0.2646p ps=2.1u w=0.42u l=0.28u
X670 scan_chain_0.D_ff1_4.D_latch1$1_0.inv1$3_0.Y scan_chain_0.D_ff1_4.D_latch1$1_0.D VSS.t323 VSS.t322 nfet_03v3 ad=0.2646p pd=2.1u as=0.2646p ps=2.1u w=0.42u l=0.28u
X671 programmable_telescopic_cascode_0.programmable_pfet$3_0.g.t0 transmission_gate$2$1_5.out.t17 programmable_telescopic_cascode_0.programmable_pfet$3_1.transmission_gate$23_1.out.t0 VSS.t2 nfet_03v3 ad=0.2646p pd=2.1u as=0.2646p ps=2.1u w=0.42u l=0.28u
X672 scan_chain_0.D_ff1_4.D_latch1$1_0.D scan_chain_0.D_ff1_4.D_latch1$1_1.NAND2$2_0.A VDD.t452 VDD.t451 pfet_03v3 ad=0.2822p pd=2.18u as=0.2822p ps=2.18u w=0.42u l=0.28u
X673 VDD.t384 scan_chain_0.D_ff1_3.inv1$4_0.Y scan_chain_0.D_ff1_3.D_latch1$1_0.NAND2$2_2.B VDD.t383 pfet_03v3 ad=0.2822p pd=2.18u as=0.2822p ps=2.18u w=0.42u l=0.28u
X674 VDD.t258 programmable_common_source_0.programmable_pfet$5_0.transmission_gate$30_1.out.t8 OUT_CS.t18 VDD.t256 pfet_03v3 ad=5.98p pd=19.7u as=5.98p ps=19.7u w=9.2u l=1u
X675 programmable_5tOTA_0.programmable_nfet$8_0.transmission_gate$29_0.out.t1 transmission_gate$2$1_3.out.t14 IBIAS.t11 VSS.t311 nfet_03v3 ad=0.2646p pd=2.1u as=0.2646p ps=2.1u w=0.42u l=0.28u
X676 a_43570_79808# scan_chain_0.D_ff1_2.D_latch1$1_0.D scan_chain_0.D_ff1_2.D_latch1$1_0.NAND2$2_0.A VSS.t434 nfet_03v3 ad=0.2646p pd=2.1u as=0.2646p ps=2.1u w=0.42u l=0.28u
X677 VSS.t204 CLK.t37 a_8911_79808# VSS.t203 nfet_03v3 ad=0.2646p pd=2.1u as=0.2646p ps=2.1u w=0.42u l=0.28u
X678 VDD.t563 scan_chain_0.D_ff1_2.D_latch1$1_0.D scan_chain_0.D_ff1_2.D_latch1$1_1.Q_bar VDD.t562 pfet_03v3 ad=0.2822p pd=2.18u as=0.2822p ps=2.18u w=0.42u l=0.28u
X679 programmable_folded_cascode_0.programmable_nfet$1_0.transmission_gate$19_1.out programmable_folded_cascode_0.EN1.t16 programmable_folded_cascode_0.programmable_nfet$1_0.g.t17 VDD.t478 pfet_03v3 ad=0.2822p pd=2.18u as=0.2822p ps=2.18u w=0.42u l=0.28u
X680 a_60456_79808# scan_chain_0.D_ff1_4.D_latch1$1_0.NAND2$2_0.A programmable_common_source_0.EN1.t1 VSS.t68 nfet_03v3 ad=0.2646p pd=2.1u as=0.2646p ps=2.1u w=0.42u l=0.28u
X681 VDD.t424 transmission_gate$2$1_4.out.t18 programmable_telescopic_cascode_0.EN1.t2 VDD.t423 pfet_03v3 ad=0.2822p pd=2.18u as=0.2822p ps=2.18u w=0.42u l=0.28u
X682 a_49197_2844.t27 programmable_folded_cascode_0.programmable_pfet_0.transmission_gate$16_1.out.t17 VDD.t91 VDD.t57 pfet_03v3 ad=9.048p pd=35.32u as=22.62p ps=70.9u w=34.8u l=1u
X683 VSS.t529 programmable_5tOTA_0.ena_bar<1>.t9 programmable_5tOTA_0.programmable_nfet$7_0.transmission_gate$28_1.out VSS.t528 nfet_03v3 ad=0.2646p pd=2.1u as=0.2646p ps=2.1u w=0.42u l=0.28u
X684 transmission_gate$2$1_5.out.t2 scan_chain_0.D_ff1_7.D_latch1$1_0.NAND2$2_0.A VDD.t306 VDD.t305 pfet_03v3 ad=0.2822p pd=2.18u as=0.2822p ps=2.18u w=0.42u l=0.28u
X685 VSS.t217 scan_chain_0.D_ff1_6.D_latch1$1_1.Q_bar a_10395_79808# VSS.t216 nfet_03v3 ad=0.2646p pd=2.1u as=0.2646p ps=2.1u w=0.42u l=0.28u
X686 scan_chain_0.D_ff1_3.D_latch1$1_1.Q_bar scan_chain_0.D_ff1_3.D_latch1$1_1.NAND2$2_2.B VDD.t489 VDD.t488 pfet_03v3 ad=0.2822p pd=2.18u as=0.2822p ps=2.18u w=0.42u l=0.28u
X687 programmable_telescopic_cascode_0.programmable_pfet$3_0.g.t33 programmable_telescopic_cascode_0.programmable_pfet$2_0.transmission_gate$22_0.out.t10 programmable_telescopic_cascode_0.programmable_pfet$3_0.d.t29 VDD.t622 pfet_03v3 ad=12.22p pd=47.52u as=30.55p ps=95.3u w=47u l=0.5u
X688 programmable_telescopic_cascode_0.programmable_nfet$4_0.s.t3 programmable_telescopic_cascode_0.programmable_nfet$4_0.transmission_gate$24_1.out.t6 programmable_telescopic_cascode_0.programmable_pfet$3_0.g.t6 VSS.t142 nfet_03v3 ad=27.45p pd=91.22u as=27.45p ps=91.22u w=45u l=0.4u
X689 VDD.t611 scan_chain_0.D_ff1_0.inv1$4_0.Y scan_chain_0.D_ff1_0.D_latch1$1_0.NAND2$2_2.B VDD.t610 pfet_03v3 ad=0.2822p pd=2.18u as=0.2822p ps=2.18u w=0.42u l=0.28u
X690 scan_chain_0.D_ff1_4.D_latch1$1_0.NAND2$2_0.A scan_chain_0.D_ff1_4.D_latch1$1_0.D VDD.t426 VDD.t425 pfet_03v3 ad=0.2822p pd=2.18u as=0.2822p ps=2.18u w=0.42u l=0.28u
X691 VSS.t58 scan_chain_0.D_ff1_1.inv1$4_0.Y a_35869_79808# VSS.t57 nfet_03v3 ad=0.2646p pd=2.1u as=0.2646p ps=2.1u w=0.42u l=0.28u
X692 programmable_telescopic_cascode_0.programmable_nfet$5_0.transmission_gate$25_0.out programmable_telescopic_cascode_0.EN1.t14 INP_TELESCOPIC.t1 VDD.t642 pfet_03v3 ad=0.2822p pd=2.18u as=0.2822p ps=2.18u w=0.42u l=0.28u
X693 VDD.t98 programmable_telescopic_cascode_0.programmable_pfet$3_0.transmission_gate$23_0.out.t9 programmable_telescopic_cascode_0.programmable_pfet$3_0.d.t4 VDD.t95 pfet_03v3 ad=26p pd=81.3u as=10.4p ps=40.52u w=40u l=0.5u
X694 VDD.t308 programmable_5tOTA_0.programmable_pfet$4_1.transmission_gate$27_1.out.t4 OUT_5T.t15 VDD.t307 pfet_03v3 ad=32.5p pd=0.1013m as=32.5p ps=0.1013m w=50u l=0.5u
X695 OUT_CS.t27 programmable_common_source_0.programmable_pfet$5_0.transmission_gate$30_0.out.t17 VDD.t466 VDD.t465 pfet_03v3 ad=2.392p pd=9.72u as=5.98p ps=19.7u w=9.2u l=1u
X696 transmission_gate$2$1_3.out.t1 scan_chain_0.D_ff1_1.D_latch1$1_0.NAND2$2_0.A VDD.t404 VDD.t403 pfet_03v3 ad=0.2822p pd=2.18u as=0.2822p ps=2.18u w=0.42u l=0.28u
X697 programmable_5tOTA_0.programmable_pfet$4_0.g.t15 programmable_5tOTA_0.programmable_pfet$4_0.transmission_gate$27_0.out.t6 VDD.t215 VDD.t213 pfet_03v3 ad=13p pd=50.52u as=32.5p ps=0.1013m w=50u l=0.5u
X698 VSS.t397 scan_chain_0.D_ff1_8.D_latch1$1_1.Q_bar a_25797_79808# VSS.t396 nfet_03v3 ad=0.2646p pd=2.1u as=0.2646p ps=2.1u w=0.42u l=0.28u
X699 VDD.t244 programmable_telescopic_cascode_0.programmable_pfet$3_1.transmission_gate$23_0.out.t11 programmable_telescopic_cascode_0.programmable_pfet$3_1.d.t26 VDD.t237 pfet_03v3 ad=26p pd=81.3u as=10.4p ps=40.52u w=40u l=0.5u
X700 a_55661_23626.t0 programmable_folded_cascode_0.programmable_nfet_0.transmission_gate$18_1.out a_49197_2844.t0 VSS.t11 nfet_03v3 ad=18.3p pd=61.22u as=7.8p ps=30.52u w=30u l=0.5u
X701 programmable_telescopic_cascode_0.programmable_pfet$3_0.g.t2 programmable_telescopic_cascode_0.EN0.t14 programmable_telescopic_cascode_0.programmable_pfet$3_1.transmission_gate$23_1.out.t2 VDD.t41 pfet_03v3 ad=0.2822p pd=2.18u as=0.2822p ps=2.18u w=0.42u l=0.28u
X702 OUT_CS.t28 programmable_common_source_0.programmable_pfet$5_0.transmission_gate$30_0.out.t18 VDD.t467 VDD.t465 pfet_03v3 ad=2.392p pd=9.72u as=5.98p ps=19.7u w=9.2u l=1u
X703 programmable_telescopic_cascode_0.programmable_pfet$3_1.d.t39 programmable_telescopic_cascode_0.programmable_pfet$2_1.transmission_gate$22_1.out.t6 OUT_TELESCOPIC.t22 VDD.t472 pfet_03v3 ad=30.55p pd=95.3u as=30.55p ps=95.3u w=47u l=0.5u
X704 OUT_CS.t29 programmable_common_source_0.programmable_pfet$5_0.transmission_gate$30_0.out.t19 VDD.t468 VDD.t465 pfet_03v3 ad=2.392p pd=9.72u as=5.98p ps=19.7u w=9.2u l=1u
X705 VSS.t462 programmable_folded_cascode_0.EN0.t21 a_6549_79808# VSS.t461 nfet_03v3 ad=0.2646p pd=2.1u as=0.2646p ps=2.1u w=0.42u l=0.28u
X706 VDD.t330 programmable_folded_cascode_0.programmable_pfet_1.transmission_gate$16_1.out.t17 a_45880_2844.t25 VDD.t329 pfet_03v3 ad=22.62p pd=70.9u as=9.048p ps=35.32u w=34.8u l=1u
X707 a_18095_79067# scan_chain_0.D_ff1_7.D_latch1$1_1.NAND2$2_2.B VSS.t210 VSS.t209 nfet_03v3 ad=0.2646p pd=2.1u as=0.2646p ps=2.1u w=0.42u l=0.28u
X708 programmable_telescopic_cascode_0.EN1.t0 scan_chain_0.D_ff1_8.D_latch1$1_0.NAND2$2_2.B VDD.t380 VDD.t379 pfet_03v3 ad=0.2822p pd=2.18u as=0.2822p ps=2.18u w=0.42u l=0.28u
X709 a_16612_79067# scan_chain_0.D_ff1_7.D_latch1$1_1.inv1$3_0.Y scan_chain_0.D_ff1_7.D_latch1$1_1.NAND2$2_2.B VSS.t431 nfet_03v3 ad=0.2646p pd=2.1u as=0.2646p ps=2.1u w=0.42u l=0.28u
X710 OUT_5T.t8 programmable_5tOTA_0.programmable_nfet$7_0.transmission_gate$28_1.out a_91570_47942.t25 VSS.t243 nfet_03v3 ad=2.964p pd=11.92u as=6.954p ps=24.02u w=11.4u l=0.5u
X711 programmable_telescopic_cascode_0.programmable_nfet$5_1.d.t4 programmable_telescopic_cascode_0.programmable_nfet$4_1.transmission_gate$24_0.out.t11 OUT_TELESCOPIC.t1 VSS.t119 nfet_03v3 ad=27.45p pd=91.22u as=11.7p ps=45.52u w=45u l=0.4u
X712 a_55661_23626.t21 programmable_folded_cascode_0.programmable_nfet_1.transmission_gate$18_1.out a_45880_2844.t64 VSS.t458 nfet_03v3 ad=18.3p pd=61.22u as=7.8p ps=30.52u w=30u l=0.5u
X713 VSS.t230 scan_chain_0.D_ff1_8.inv1$4_0.Y a_28168_79808# VSS.t229 nfet_03v3 ad=0.2646p pd=2.1u as=0.2646p ps=2.1u w=0.42u l=0.28u
X714 programmable_telescopic_cascode_0.programmable_nfet$5_1.d.t12 programmable_telescopic_cascode_0.programmable_nfet$4_1.transmission_gate$24_1.out.t7 OUT_TELESCOPIC.t15 VSS.t145 nfet_03v3 ad=27.45p pd=91.22u as=27.45p ps=91.22u w=45u l=0.4u
X715 VDD.t92 programmable_folded_cascode_0.programmable_pfet_0.transmission_gate$16_1.out.t18 a_49197_2844.t26 VDD.t78 pfet_03v3 ad=22.62p pd=70.9u as=9.048p ps=35.32u w=34.8u l=1u
X716 programmable_folded_cascode_0.programmable_nfet$2_0.g.t9 programmable_folded_cascode_0.programmable_nfet$2_1.transmission_gate$20_1.out VSS.t239 VSS.t238 nfet_03v3 ad=5.33p pd=21.02u as=12.505p ps=42.22u w=20.5u l=1u
X717 a_8911_79067# scan_chain_0.D_ff1_6.D_latch1$1_1.inv1$3_0.Y scan_chain_0.D_ff1_6.D_latch1$1_1.NAND2$2_2.B VSS.t6 nfet_03v3 ad=0.2646p pd=2.1u as=0.2646p ps=2.1u w=0.42u l=0.28u
X718 scan_chain_0.D_ff1_2.inv1$4_0.Y CLK.t38 VDD.t265 VDD.t264 pfet_03v3 ad=0.546p pd=2.98u as=0.546p ps=2.98u w=0.84u l=0.28u
X719 INP_TELESCOPIC.t2 programmable_telescopic_cascode_0.EN0.t15 programmable_telescopic_cascode_0.programmable_nfet$5_0.transmission_gate$25_1.out VDD.t234 pfet_03v3 ad=0.2822p pd=2.18u as=0.2822p ps=2.18u w=0.42u l=0.28u
X720 programmable_folded_cascode_0.OUT.t22 programmable_folded_cascode_0.programmable_pfet$1_0.transmission_gate$17_0.out.t6 a_49197_2844.t65 VDD.t647 pfet_03v3 ad=19.24p pd=60.5u as=19.24p ps=60.5u w=29.6u l=0.5u
X721 programmable_telescopic_cascode_0.programmable_nfet$6_0.d.t9 INN_TELESCOPIC.t4 programmable_telescopic_cascode_0.programmable_nfet$5_1.d.t27 VSS.t418 nfet_03v3 ad=18.3p pd=61.22u as=18.3p ps=61.22u w=30u l=0.5u
X722 VDD.t259 programmable_common_source_0.programmable_pfet$5_0.transmission_gate$30_1.out.t9 OUT_CS.t17 VDD.t256 pfet_03v3 ad=5.98p pd=19.7u as=5.98p ps=19.7u w=9.2u l=1u
X723 a_91570_47942.t9 programmable_5tOTA_0.programmable_nfet$8_0.transmission_gate$29_1.out.t6 VSS.t103 VSS.t101 nfet_03v3 ad=5.928p pd=23.32u as=13.908p ps=46.82u w=22.8u l=1u
X724 VDD.t260 programmable_common_source_0.programmable_pfet$5_0.transmission_gate$30_1.out.t10 OUT_CS.t16 VDD.t256 pfet_03v3 ad=5.98p pd=19.7u as=5.98p ps=19.7u w=9.2u l=1u
X725 VSS.t206 CLK.t39 a_39715_79067# VSS.t205 nfet_03v3 ad=0.2646p pd=2.1u as=0.2646p ps=2.1u w=0.42u l=0.28u
X726 VSS.t186 programmable_telescopic_cascode_0.EN0.t16 programmable_telescopic_cascode_0.programmable_nfet$4_0.transmission_gate$24_1.out.t1 VSS.t185 nfet_03v3 ad=0.2646p pd=2.1u as=0.2646p ps=2.1u w=0.42u l=0.28u
X727 programmable_telescopic_cascode_0.programmable_nfet$4_0.transmission_gate$24_0.out.t0 programmable_telescopic_cascode_0.EN1.t15 VSS.t86 VSS.t85 nfet_03v3 ad=0.2646p pd=2.1u as=0.2646p ps=2.1u w=0.42u l=0.28u
X728 programmable_folded_cascode_0.programmable_nfet$1_1.transmission_gate$19_1.out programmable_folded_cascode_0.EN1.t17 VSS.t383 VSS.t382 nfet_03v3 ad=0.2646p pd=2.1u as=0.2646p ps=2.1u w=0.42u l=0.28u
X729 programmable_telescopic_cascode_0.programmable_pfet$3_1.d.t40 programmable_telescopic_cascode_0.programmable_pfet$2_1.transmission_gate$22_1.out.t7 OUT_TELESCOPIC.t23 VDD.t472 pfet_03v3 ad=30.55p pd=95.3u as=30.55p ps=95.3u w=47u l=0.5u
X730 a_45053_79067# scan_chain_0.D_ff1_2.D_latch1$1_0.NAND2$2_2.B VSS.t122 VSS.t121 nfet_03v3 ad=0.2646p pd=2.1u as=0.2646p ps=2.1u w=0.42u l=0.28u
X731 programmable_common_source_0.EN0.t2 transmission_gate$2$1_7.ena VSS.t346 VSS.t345 nfet_03v3 ad=0.2646p pd=2.1u as=0.2646p ps=2.1u w=0.42u l=0.28u
X732 programmable_telescopic_cascode_0.programmable_nfet$4_0.s.t17 programmable_telescopic_cascode_0.programmable_nfet$4_0.transmission_gate$24_0.out.t11 programmable_telescopic_cascode_0.programmable_pfet$3_0.g.t49 VSS.t428 nfet_03v3 ad=27.45p pd=91.22u as=11.7p ps=45.52u w=45u l=0.4u
X733 VDD.t280 IN_CS.t10 OUT_CS.t9 VDD.t274 pfet_03v3 ad=5.98p pd=19.7u as=5.98p ps=19.7u w=9.2u l=1u
X734 VSS.t487 scan_chain_0.D_ff1_0.Q_bar a_68157_79808# VSS.t486 nfet_03v3 ad=0.2646p pd=2.1u as=0.2646p ps=2.1u w=0.42u l=0.28u
X735 transmission_gate$2$1_6.out.t3 transmission_gate$2$1_7.ena VSS.t344 VSS.t343 nfet_03v3 ad=0.2646p pd=2.1u as=0.2646p ps=2.1u w=0.42u l=0.28u
X736 a_45880_2844.t24 programmable_folded_cascode_0.programmable_pfet_1.transmission_gate$16_1.out.t18 VDD.t328 VDD.t321 pfet_03v3 ad=9.048p pd=35.32u as=22.62p ps=70.9u w=34.8u l=1u
X737 scan_chain_0.D_ff1_7.D_latch1$1_1.inv1$3_0.Y transmission_gate$2$1_6.out.t22 VSS.t511 VSS.t510 nfet_03v3 ad=0.2646p pd=2.1u as=0.2646p ps=2.1u w=0.42u l=0.28u
X738 a_35869_79067# scan_chain_0.D_ff1_1.D_latch1$1_0.inv1$3_0.Y scan_chain_0.D_ff1_1.D_latch1$1_0.NAND2$2_2.B VSS.t327 nfet_03v3 ad=0.2646p pd=2.1u as=0.2646p ps=2.1u w=0.42u l=0.28u
X739 a_49197_2844.t48 programmable_folded_cascode_0.programmable_nfet_0.transmission_gate$18_0.out a_55661_23626.t18 VSS.t361 nfet_03v3 ad=18.3p pd=61.22u as=18.3p ps=61.22u w=30u l=0.5u
X740 programmable_telescopic_cascode_0.programmable_pfet$3_0.g.t50 programmable_telescopic_cascode_0.programmable_nfet$4_0.transmission_gate$24_0.out.t12 programmable_telescopic_cascode_0.programmable_nfet$4_0.s.t16 VSS.t161 nfet_03v3 ad=11.7p pd=45.52u as=27.45p ps=91.22u w=45u l=0.4u
X741 IN_CS.t3 programmable_common_source_0.EN0.t5 programmable_common_source_0.programmable_pfet$5_0.transmission_gate$30_1.out.t0 VDD.t34 pfet_03v3 ad=0.2822p pd=2.18u as=0.2822p ps=2.18u w=0.42u l=0.28u
X742 VDD.t261 programmable_common_source_0.programmable_pfet$5_0.transmission_gate$30_1.out.t11 OUT_CS.t15 VDD.t256 pfet_03v3 ad=5.98p pd=19.7u as=5.98p ps=19.7u w=9.2u l=1u
X743 IBIAS.t0 transmission_gate$2$1_5.out.t18 programmable_telescopic_cascode_0.programmable_nfet$6_0.transmission_gate$26_1.out VSS.t3 nfet_03v3 ad=0.2646p pd=2.1u as=0.2646p ps=2.1u w=0.42u l=0.28u
X744 programmable_telescopic_cascode_0.programmable_pfet$2_1.transmission_gate$22_0.out.t0 programmable_telescopic_cascode_0.EN1.t16 programmable_telescopic_cascode_0.programmable_pfet$2_0.g.t4 VDD.t113 pfet_03v3 ad=0.2822p pd=2.18u as=0.2822p ps=2.18u w=0.42u l=0.28u
X745 VDD.t238 programmable_telescopic_cascode_0.programmable_pfet$3_1.transmission_gate$23_0.out.t12 programmable_telescopic_cascode_0.programmable_pfet$3_1.d.t21 VDD.t237 pfet_03v3 ad=26p pd=81.3u as=10.4p ps=40.52u w=40u l=0.5u
X746 scan_chain_0.D_ff1_7.D_latch1$1_0.inv1$3_0.Y scan_chain_0.D_ff1_7.D_latch1$1_0.D VDD.t376 VDD.t375 pfet_03v3 ad=0.546p pd=2.98u as=0.546p ps=2.98u w=0.84u l=0.28u
X747 scan_chain_0.D_ff1_3.D_latch1$1_0.inv1$3_0.Y scan_chain_0.D_ff1_3.D_latch1$1_0.D VDD.t368 VDD.t367 pfet_03v3 ad=0.546p pd=2.98u as=0.546p ps=2.98u w=0.84u l=0.28u
X748 VDD.t281 IN_CS.t11 OUT_CS.t10 VDD.t274 pfet_03v3 ad=5.98p pd=19.7u as=5.98p ps=19.7u w=9.2u l=1u
X749 VDD.t447 IN_CS.t12 OUT_CS.t12 VDD.t274 pfet_03v3 ad=5.98p pd=19.7u as=5.98p ps=19.7u w=9.2u l=1u
X750 a_47416_79808# transmission_gate$2$1_2.out.t12 scan_chain_0.D_ff1_3.D_latch1$1_1.NAND2$2_0.A VSS.t425 nfet_03v3 ad=0.2646p pd=2.1u as=0.2646p ps=2.1u w=0.42u l=0.28u
X751 transmission_gate$2$1_7.out.t1 transmission_gate$2$1_7.ena VSS.t342 VSS.t341 nfet_03v3 ad=0.2646p pd=2.1u as=0.2646p ps=2.1u w=0.42u l=0.28u
X752 programmable_folded_cascode_0.programmable_pfet$1_0.transmission_gate$17_1.out.t0 programmable_folded_cascode_0.EN1.t18 programmable_folded_cascode_0.programmable_pfet$1_0.g.t23 VDD.t479 pfet_03v3 ad=0.2822p pd=2.18u as=0.2822p ps=2.18u w=0.42u l=0.28u
X753 programmable_5tOTA_0.programmable_pfet$4_0.g.t28 programmable_5tOTA_0.ena_bar<1>.t10 programmable_5tOTA_0.programmable_pfet$4_1.transmission_gate$27_0.out.t0 VDD.t710 pfet_03v3 ad=0.2822p pd=2.18u as=0.2822p ps=2.18u w=0.42u l=0.28u
X754 programmable_5tOTA_0.ena_bar<0>.t2 transmission_gate$2$1_3.out.t15 a_37352_79067# VSS.t310 nfet_03v3 ad=0.2646p pd=2.1u as=0.2646p ps=2.1u w=0.42u l=0.28u
X755 programmable_folded_cascode_0.programmable_nfet$1_1.transmission_gate$19_1.out transmission_gate$2$1_6.out.t23 programmable_folded_cascode_0.programmable_nfet$1_0.g.t20 VSS.t512 nfet_03v3 ad=0.2646p pd=2.1u as=0.2646p ps=2.1u w=0.42u l=0.28u
X756 VDD.t267 CLK.t40 scan_chain_0.D_ff1_4.D_latch1$1_1.NAND2$2_0.A VDD.t266 pfet_03v3 ad=0.2822p pd=2.18u as=0.2822p ps=2.18u w=0.42u l=0.28u
X757 VDD.t44 programmable_telescopic_cascode_0.programmable_pfet$3_1.transmission_gate$23_1.out.t7 programmable_telescopic_cascode_0.programmable_pfet$3_1.d.t4 VDD.t22 pfet_03v3 ad=26p pd=81.3u as=26p ps=81.3u w=40u l=0.5u
X758 scan_chain_0.D_ff1_7.D_latch1$1_0.D scan_chain_0.D_ff1_7.D_latch1$1_1.NAND2$2_0.A VDD.t198 VDD.t197 pfet_03v3 ad=0.2822p pd=2.18u as=0.2822p ps=2.18u w=0.42u l=0.28u
X759 INN_5T.t0 programmable_5tOTA_0.ena_bar<1>.t11 programmable_5tOTA_0.programmable_nfet$7_0.transmission_gate$28_1.out VDD.t711 pfet_03v3 ad=0.2822p pd=2.18u as=0.2822p ps=2.18u w=0.42u l=0.28u
X760 scan_chain_0.D_ff1_8.inv1$4_0.Y CLK.t41 VSS.t208 VSS.t207 nfet_03v3 ad=0.2646p pd=2.1u as=0.2646p ps=2.1u w=0.42u l=0.28u
X761 programmable_telescopic_cascode_0.programmable_nfet$4_0.s.t8 programmable_telescopic_cascode_0.programmable_nfet$4_0.g.t22 programmable_telescopic_cascode_0.programmable_pfet$3_0.g.t25 VSS.t190 nfet_03v3 ad=27.45p pd=91.22u as=27.45p ps=91.22u w=45u l=0.4u
X762 VDD.t442 scan_chain_0.D_ff1_5.D_latch1$1_1.Q_bar scan_chain_0.D_ff1_5.D_latch1$1_0.D VDD.t441 pfet_03v3 ad=0.2822p pd=2.18u as=0.2822p ps=2.18u w=0.42u l=0.28u
X763 programmable_telescopic_cascode_0.programmable_nfet$6_0.d.t14 programmable_telescopic_cascode_0.programmable_nfet$5_0.transmission_gate$25_0.out programmable_telescopic_cascode_0.programmable_nfet$4_0.s.t26 VSS.t490 nfet_03v3 ad=18.3p pd=61.22u as=7.8p ps=30.52u w=30u l=0.5u
X764 VDD.t469 programmable_common_source_0.programmable_pfet$5_0.transmission_gate$30_0.out.t20 OUT_CS.t30 VDD.t461 pfet_03v3 ad=5.98p pd=19.7u as=2.392p ps=9.72u w=9.2u l=1u
X765 a_58284_41264.t5 programmable_folded_cascode_0.programmable_nfet$1_0.transmission_gate$19_1.out programmable_folded_cascode_0.OUT.t17 VSS.t363 nfet_03v3 ad=6.405p pd=22.22u as=2.73p ps=11.02u w=10.5u l=0.5u
X766 IN_CS.t0 programmable_common_source_0.EN0.t11 programmable_common_source_0.programmable_pfet$5_0.transmission_gate$30_1.out.t1 VSS.t305 nfet_03v3 ad=0.2646p pd=2.1u as=0.2646p ps=2.1u w=0.42u l=0.28u
X767 programmable_5tOTA_0.programmable_nfet$7_0.transmission_gate$28_0.out programmable_5tOTA_0.ena_bar<0>.t12 VSS.t56 VSS.t55 nfet_03v3 ad=0.2646p pd=2.1u as=0.2646p ps=2.1u w=0.42u l=0.28u
X768 programmable_telescopic_cascode_0.programmable_nfet$4_1.transmission_gate$24_0.out.t0 programmable_telescopic_cascode_0.EN1.t17 VSS.t88 VSS.t87 nfet_03v3 ad=0.2646p pd=2.1u as=0.2646p ps=2.1u w=0.42u l=0.28u
X769 VSS.t172 IBIAS.t18 programmable_telescopic_cascode_0.programmable_nfet$6_0.d.t6 VSS.t167 nfet_03v3 ad=16.531p pd=55.42u as=16.531p ps=55.42u w=27.1u l=1u
X770 scan_chain_0.D_ff1_8.D_latch1$1_1.NAND2$2_2.B scan_chain_0.D_ff1_8.D_latch1$1_1.inv1$3_0.Y VDD.t52 VDD.t51 pfet_03v3 ad=0.2822p pd=2.18u as=0.2822p ps=2.18u w=0.42u l=0.28u
X771 a_58284_41264.t7 programmable_folded_cascode_0.programmable_nfet$2_0.transmission_gate$20_0.out VSS.t391 VSS.t390 nfet_03v3 ad=12.505p pd=42.22u as=12.505p ps=42.22u w=20.5u l=1u
X772 programmable_folded_cascode_0.OUT.t23 programmable_folded_cascode_0.programmable_pfet$1_0.transmission_gate$17_0.out.t7 a_49197_2844.t66 VDD.t648 pfet_03v3 ad=19.24p pd=60.5u as=19.24p ps=60.5u w=29.6u l=0.5u
X773 VDD.t269 CLK.t42 scan_chain_0.D_ff1_3.D_latch1$1_1.NAND2$2_2.B VDD.t268 pfet_03v3 ad=0.2822p pd=2.18u as=0.2822p ps=2.18u w=0.42u l=0.28u
X774 programmable_telescopic_cascode_0.programmable_pfet$3_0.transmission_gate$23_0.out.t2 transmission_gate$2$1_4.out.t19 VDD.t513 VDD.t512 pfet_03v3 ad=0.2822p pd=2.18u as=0.2822p ps=2.18u w=0.42u l=0.28u
X775 programmable_telescopic_cascode_0.programmable_pfet$3_0.d.t5 programmable_telescopic_cascode_0.programmable_pfet$3_0.transmission_gate$23_0.out.t10 VDD.t100 VDD.t99 pfet_03v3 ad=10.4p pd=40.52u as=26p ps=81.3u w=40u l=0.5u
X776 VDD.t400 scan_chain_0.D_ff1_6.inv1$4_0.Y scan_chain_0.D_ff1_6.D_latch1$1_0.NAND2$2_0.A VDD.t399 pfet_03v3 ad=0.2822p pd=2.18u as=0.2822p ps=2.18u w=0.42u l=0.28u
X777 a_39715_79808# transmission_gate$2$1_3.out.t16 scan_chain_0.D_ff1_2.D_latch1$1_1.NAND2$2_0.A VSS.t309 nfet_03v3 ad=0.2646p pd=2.1u as=0.2646p ps=2.1u w=0.42u l=0.28u
X778 scan_chain_0.D_ff1_2.D_latch1$1_1.Q_bar scan_chain_0.D_ff1_2.D_latch1$1_1.NAND2$2_2.B VDD.t420 VDD.t419 pfet_03v3 ad=0.2822p pd=2.18u as=0.2822p ps=2.18u w=0.42u l=0.28u
X779 IBIAS.t10 programmable_telescopic_cascode_0.EN0.t17 programmable_telescopic_cascode_0.programmable_nfet$6_0.transmission_gate$26_1.out VDD.t235 pfet_03v3 ad=0.2822p pd=2.18u as=0.2822p ps=2.18u w=0.42u l=0.28u
X780 VDD.t352 scan_chain_0.D_ff1_0.D_latch1$1_0.D scan_chain_0.D_ff1_0.D_latch1$1_1.Q_bar VDD.t351 pfet_03v3 ad=0.2822p pd=2.18u as=0.2822p ps=2.18u w=0.42u l=0.28u
X781 OUT_TELESCOPIC.t2 programmable_telescopic_cascode_0.programmable_nfet$4_1.transmission_gate$24_0.out.t12 programmable_telescopic_cascode_0.programmable_nfet$5_1.d.t5 VSS.t120 nfet_03v3 ad=11.7p pd=45.52u as=27.45p ps=91.22u w=45u l=0.4u
X782 scan_chain_0.D_ff1_3.D_latch1$1_0.NAND2$2_0.A scan_chain_0.D_ff1_3.D_latch1$1_0.D VDD.t366 VDD.t365 pfet_03v3 ad=0.2822p pd=2.18u as=0.2822p ps=2.18u w=0.42u l=0.28u
X783 programmable_telescopic_cascode_0.programmable_pfet$2_0.g.t7 programmable_telescopic_cascode_0.EN0.t18 programmable_telescopic_cascode_0.programmable_pfet$2_0.transmission_gate$22_1.out.t2 VDD.t236 pfet_03v3 ad=0.2822p pd=2.18u as=0.2822p ps=2.18u w=0.42u l=0.28u
X784 programmable_telescopic_cascode_0.programmable_pfet$3_0.transmission_gate$23_0.out.t1 transmission_gate$2$1_4.out.t20 programmable_telescopic_cascode_0.programmable_pfet$3_0.g.t23 VSS.t369 nfet_03v3 ad=0.2646p pd=2.1u as=0.2646p ps=2.1u w=0.42u l=0.28u
X785 VSS.t107 IBIAS.t19 programmable_folded_cascode_0.programmable_pfet$1_0.g.t20 VSS.t106 nfet_03v3 ad=16.531p pd=55.42u as=16.531p ps=55.42u w=27.1u l=1u
X786 a_56601_79808# scan_chain_0.D_ff1_4.D_latch1$1_1.NAND2$2_0.A scan_chain_0.D_ff1_4.D_latch1$1_0.D VSS.t356 nfet_03v3 ad=0.2646p pd=2.1u as=0.2646p ps=2.1u w=0.42u l=0.28u
X787 a_45880_2844.t51 programmable_folded_cascode_0.programmable_pfet_0.g.t35 VDD.t596 VDD.t185 pfet_03v3 ad=22.62p pd=70.9u as=22.62p ps=70.9u w=34.8u l=1u
X788 VDD.t141 scan_chain_0.D_ff1_5.inv1$4_0.Y scan_chain_0.D_ff1_5.D_latch1$1_0.NAND2$2_0.A VDD.t140 pfet_03v3 ad=0.2822p pd=2.18u as=0.2822p ps=2.18u w=0.42u l=0.28u
X789 programmable_folded_cascode_0.OUT.t0 programmable_folded_cascode_0.programmable_nfet$1_0.g.t33 a_58284_41264.t0 VSS.t537 nfet_03v3 ad=6.405p pd=22.22u as=6.405p ps=22.22u w=10.5u l=0.5u
X790 programmable_common_source_0.programmable_nfet$9_0.transmission_gate$31_0.out programmable_common_source_0.EN0.t6 IBIAS.t1 VDD.t35 pfet_03v3 ad=0.2822p pd=2.18u as=0.2822p ps=2.18u w=0.42u l=0.28u
X791 a_91570_47942.t10 programmable_5tOTA_0.programmable_nfet$8_0.transmission_gate$29_1.out.t7 VSS.t104 VSS.t101 nfet_03v3 ad=5.928p pd=23.32u as=13.908p ps=46.82u w=22.8u l=1u
X792 VDD.t94 programmable_folded_cascode_0.programmable_pfet_0.transmission_gate$16_1.out.t19 a_49197_2844.t25 VDD.t93 pfet_03v3 ad=22.62p pd=70.9u as=9.048p ps=35.32u w=34.8u l=1u
X793 programmable_5tOTA_0.programmable_pfet$4_0.transmission_gate$27_1.out.t1 transmission_gate$2$1_3.out.t17 programmable_5tOTA_0.programmable_pfet$4_0.g.t20 VSS.t308 nfet_03v3 ad=0.2646p pd=2.1u as=0.2646p ps=2.1u w=0.42u l=0.28u
X794 VDD.t29 transmission_gate$2$1_5.out.t19 programmable_telescopic_cascode_0.programmable_pfet$3_1.transmission_gate$23_1.out.t1 VDD.t28 pfet_03v3 ad=0.2822p pd=2.18u as=0.2822p ps=2.18u w=0.42u l=0.28u
X795 VDD.t37 programmable_common_source_0.EN0.t7 programmable_common_source_0.EN0.t0 VDD.t36 pfet_03v3 ad=0.2822p pd=2.18u as=0.2822p ps=2.18u w=0.42u l=0.28u
X796 VSS.t219 CLK.t43 a_62818_79808# VSS.t218 nfet_03v3 ad=0.2646p pd=2.1u as=0.2646p ps=2.1u w=0.42u l=0.28u
X797 scan_chain_0.D_ff1_5.D_latch1$1_1.inv1$3_0.Y SCAN_IN.t2 VDD.t715 VDD.t516 pfet_03v3 ad=0.546p pd=2.98u as=0.546p ps=2.98u w=0.84u l=0.28u
X798 a_45880_2844.t8 programmable_folded_cascode_0.programmable_nfet_1.transmission_gate$18_0.out a_55661_23626.t15 VSS.t90 nfet_03v3 ad=18.3p pd=61.22u as=18.3p ps=61.22u w=30u l=0.5u
X799 a_21951_79808# scan_chain_0.D_ff1_7.D_latch1$1_0.NAND2$2_0.A transmission_gate$2$1_5.out.t1 VSS.t237 nfet_03v3 ad=0.2646p pd=2.1u as=0.2646p ps=2.1u w=0.42u l=0.28u
X800 a_25796_79067# scan_chain_0.D_ff1_8.D_latch1$1_1.NAND2$2_2.B VSS.t151 VSS.t150 nfet_03v3 ad=0.2646p pd=2.1u as=0.2646p ps=2.1u w=0.42u l=0.28u
X801 scan_chain_0.D_ff1_2.D_latch1$1_0.NAND2$2_2.B scan_chain_0.D_ff1_2.D_latch1$1_0.inv1$3_0.Y VDD.t511 VDD.t510 pfet_03v3 ad=0.2822p pd=2.18u as=0.2822p ps=2.18u w=0.42u l=0.28u
X802 programmable_telescopic_cascode_0.programmable_pfet$3_0.d.t11 programmable_telescopic_cascode_0.programmable_pfet$2_0.g.t15 programmable_telescopic_cascode_0.programmable_pfet$3_0.g.t13 VDD.t46 pfet_03v3 ad=30.55p pd=95.3u as=30.55p ps=95.3u w=47u l=0.5u
X803 VSS.t338 scan_chain_0.D_ff1_3.D_latch1$1_1.Q_bar a_48900_79808# VSS.t337 nfet_03v3 ad=0.2646p pd=2.1u as=0.2646p ps=2.1u w=0.42u l=0.28u
X804 programmable_folded_cascode_0.programmable_pfet$1_0.g.t28 programmable_folded_cascode_0.EN0.t22 programmable_folded_cascode_0.programmable_pfet$1_0.transmission_gate$17_0.out.t0 VDD.t626 pfet_03v3 ad=0.2822p pd=2.18u as=0.2822p ps=2.18u w=0.42u l=0.28u
X805 programmable_common_source_0.EN1.t2 scan_chain_0.D_ff1_4.D_latch1$1_0.NAND2$2_2.B VDD.t495 VDD.t494 pfet_03v3 ad=0.2822p pd=2.18u as=0.2822p ps=2.18u w=0.42u l=0.28u
X806 VDD.t136 a_61069_4063.t22 programmable_folded_cascode_0.programmable_nfet$3_0.g.t3 VDD.t133 pfet_03v3 ad=14.95p pd=47.3u as=14.95p ps=47.3u w=23u l=1u
X807 a_58972_79808# scan_chain_0.D_ff1_4.D_latch1$1_0.D scan_chain_0.D_ff1_4.D_latch1$1_0.NAND2$2_0.A VSS.t321 nfet_03v3 ad=0.2646p pd=2.1u as=0.2646p ps=2.1u w=0.42u l=0.28u
X808 OUT_5T.t17 programmable_5tOTA_0.programmable_nfet$7_0.transmission_gate$28_0.out a_91570_47942.t33 VSS.t443 nfet_03v3 ad=6.954p pd=24.02u as=6.954p ps=24.02u w=11.4u l=0.5u
X809 VDD.t161 programmable_telescopic_cascode_0.programmable_pfet$3_0.g.t62 programmable_telescopic_cascode_0.programmable_pfet$3_1.d.t31 VDD.t160 pfet_03v3 ad=26p pd=81.3u as=26p ps=81.3u w=40u l=0.5u
X810 programmable_telescopic_cascode_0.programmable_pfet$2_0.g.t2 transmission_gate$2$1_5.out.t20 programmable_telescopic_cascode_0.programmable_pfet$2_1.transmission_gate$22_1.out.t0 VSS.t19 nfet_03v3 ad=0.2646p pd=2.1u as=0.2646p ps=2.1u w=0.42u l=0.28u
X811 a_45880_2844.t23 programmable_folded_cascode_0.programmable_pfet_1.transmission_gate$16_1.out.t19 VDD.t327 VDD.t321 pfet_03v3 ad=9.048p pd=35.32u as=22.62p ps=70.9u w=34.8u l=1u
X812 VDD.t553 transmission_gate$2$1_2.out.t13 programmable_5tOTA_0.ena_bar<1>.t2 VDD.t552 pfet_03v3 ad=0.2822p pd=2.18u as=0.2822p ps=2.18u w=0.42u l=0.28u
X813 programmable_folded_cascode_0.programmable_pfet_1.transmission_gate$16_1.out.t2 transmission_gate$2$1_6.out.t24 programmable_folded_cascode_0.programmable_pfet_0.g.t18 VSS.t513 nfet_03v3 ad=0.2646p pd=2.1u as=0.2646p ps=2.1u w=0.42u l=0.28u
X814 programmable_folded_cascode_0.programmable_nfet$2_0.transmission_gate$20_1.out transmission_gate$2$1_6.out.t25 programmable_folded_cascode_0.programmable_nfet$2_0.g.t7 VSS.t514 nfet_03v3 ad=0.2646p pd=2.1u as=0.2646p ps=2.1u w=0.42u l=0.28u
X815 VSS.t385 programmable_folded_cascode_0.EN1.t19 a_14250_79808# VSS.t384 nfet_03v3 ad=0.2646p pd=2.1u as=0.2646p ps=2.1u w=0.42u l=0.28u
X816 a_37353_79808# scan_chain_0.D_ff1_1.D_latch1$1_0.NAND2$2_0.A transmission_gate$2$1_3.out.t2 VSS.t296 nfet_03v3 ad=0.2646p pd=2.1u as=0.2646p ps=2.1u w=0.42u l=0.28u
X817 programmable_telescopic_cascode_0.programmable_nfet$6_0.d.t10 programmable_telescopic_cascode_0.programmable_nfet$6_0.transmission_gate$26_0.out.t6 VSS.t389 VSS.t99 nfet_03v3 ad=7.046p pd=27.62u as=16.531p ps=55.42u w=27.1u l=1u
X818 a_45880_2844.t10 programmable_folded_cascode_0.programmable_pfet$1_1.transmission_gate$17_1.out.t11 programmable_folded_cascode_0.programmable_nfet$1_0.g.t13 VDD.t123 pfet_03v3 ad=19.24p pd=60.5u as=7.696p ps=30.12u w=29.6u l=0.5u
X819 VSS.t234 scan_chain_0.D_ff1_7.inv1$4_0.Y a_20467_79808# VSS.t233 nfet_03v3 ad=0.2646p pd=2.1u as=0.2646p ps=2.1u w=0.42u l=0.28u
X820 VSS.t163 IBIAS.t4 IBIAS.t5 VSS.t162 nfet_03v3 ad=16.531p pd=55.42u as=16.531p ps=55.42u w=27.1u l=1u
X821 a_1210_79067# scan_chain_0.D_ff1_5.D_latch1$1_1.inv1$3_0.Y scan_chain_0.D_ff1_5.D_latch1$1_1.NAND2$2_2.B VSS.t136 nfet_03v3 ad=0.2646p pd=2.1u as=0.2646p ps=2.1u w=0.42u l=0.28u
X822 programmable_telescopic_cascode_0.programmable_nfet$4_0.s.t15 programmable_telescopic_cascode_0.programmable_nfet$4_0.transmission_gate$24_0.out.t13 programmable_telescopic_cascode_0.programmable_pfet$3_0.g.t51 VSS.t428 nfet_03v3 ad=27.45p pd=91.22u as=11.7p ps=45.52u w=45u l=0.4u
X823 programmable_telescopic_cascode_0.programmable_nfet$5_1.d.t16 programmable_telescopic_cascode_0.programmable_nfet$4_0.g.t23 OUT_TELESCOPIC.t27 VSS.t189 nfet_03v3 ad=27.45p pd=91.22u as=27.45p ps=91.22u w=45u l=0.4u
X824 VDD.t172 programmable_5tOTA_0.programmable_pfet$4_0.transmission_gate$27_1.out.t4 programmable_5tOTA_0.programmable_pfet$4_0.g.t11 VDD.t170 pfet_03v3 ad=32.5p pd=0.1013m as=32.5p ps=0.1013m w=50u l=0.5u
X825 programmable_telescopic_cascode_0.programmable_pfet$3_0.g.t9 programmable_telescopic_cascode_0.programmable_nfet$4_0.transmission_gate$24_0.out.t14 programmable_telescopic_cascode_0.programmable_nfet$4_0.s.t14 VSS.t161 nfet_03v3 ad=11.7p pd=45.52u as=27.45p ps=91.22u w=45u l=0.4u
X826 VDD.t470 programmable_common_source_0.programmable_pfet$5_0.transmission_gate$30_0.out.t21 OUT_CS.t31 VDD.t461 pfet_03v3 ad=5.98p pd=19.7u as=2.392p ps=9.72u w=9.2u l=1u
X827 VDD.t690 programmable_telescopic_cascode_0.programmable_pfet$3_0.transmission_gate$23_0.out.t11 programmable_telescopic_cascode_0.programmable_pfet$3_0.d.t39 VDD.t95 pfet_03v3 ad=26p pd=81.3u as=10.4p ps=40.52u w=40u l=0.5u
X828 a_45880_2844.t56 programmable_folded_cascode_0.programmable_pfet_1.transmission_gate$16_0.out.t11 VDD.t608 VDD.t607 pfet_03v3 ad=22.62p pd=70.9u as=22.62p ps=70.9u w=34.8u l=1u
X829 programmable_folded_cascode_0.programmable_pfet$1_0.g.t22 transmission_gate$2$1_7.out.t23 programmable_folded_cascode_0.programmable_pfet$1_0.transmission_gate$17_0.out.t1 VSS.t521 nfet_03v3 ad=0.2646p pd=2.1u as=0.2646p ps=2.1u w=0.42u l=0.28u
X830 programmable_telescopic_cascode_0.programmable_pfet$3_0.d.t12 programmable_telescopic_cascode_0.programmable_pfet$2_0.g.t16 programmable_telescopic_cascode_0.programmable_pfet$3_0.g.t14 VDD.t46 pfet_03v3 ad=30.55p pd=95.3u as=30.55p ps=95.3u w=47u l=0.5u
X831 scan_chain_0.D_ff1_8.D_latch1$1_1.inv1$3_0.Y transmission_gate$2$1_5.out.t21 VDD.t31 VDD.t30 pfet_03v3 ad=0.546p pd=2.98u as=0.546p ps=2.98u w=0.84u l=0.28u
X832 a_55661_23626.t13 programmable_folded_cascode_0.programmable_nfet$3_0.g.t12 VSS.t79 VSS.t77 nfet_03v3 ad=12.2p pd=41.22u as=12.2p ps=41.22u w=20u l=1u
X833 VDD.t555 transmission_gate$2$1_2.out.t14 programmable_5tOTA_0.programmable_pfet$4_1.transmission_gate$27_0.out.t2 VDD.t554 pfet_03v3 ad=0.2822p pd=2.18u as=0.2822p ps=2.18u w=0.42u l=0.28u
X834 programmable_telescopic_cascode_0.EN1.t1 transmission_gate$2$1_4.out.t21 a_29651_79067# VSS.t368 nfet_03v3 ad=0.2646p pd=2.1u as=0.2646p ps=2.1u w=0.42u l=0.28u
X835 scan_chain_0.D_ff1_2.D_latch1$1_1.Q_bar scan_chain_0.D_ff1_2.D_latch1$1_0.D a_41198_79067# VSS.t433 nfet_03v3 ad=0.2646p pd=2.1u as=0.2646p ps=2.1u w=0.42u l=0.28u
X836 a_45880_2844.t22 programmable_folded_cascode_0.programmable_pfet_1.transmission_gate$16_1.out.t20 VDD.t326 VDD.t325 pfet_03v3 ad=9.048p pd=35.32u as=22.62p ps=70.9u w=34.8u l=1u
X837 VDD.t219 a_61069_4063.t14 a_61069_4063.t15 VDD.t131 pfet_03v3 ad=14.95p pd=47.3u as=14.95p ps=47.3u w=23u l=1u
X838 VDD.t285 CLK.t44 scan_chain_0.D_ff1_7.D_latch1$1_1.NAND2$2_0.A VDD.t284 pfet_03v3 ad=0.2822p pd=2.18u as=0.2822p ps=2.18u w=0.42u l=0.28u
X839 a_45880_2844.t52 programmable_folded_cascode_0.programmable_pfet_0.g.t36 VDD.t597 VDD.t185 pfet_03v3 ad=22.62p pd=70.9u as=22.62p ps=70.9u w=34.8u l=1u
X840 programmable_telescopic_cascode_0.programmable_pfet$3_1.d.t22 programmable_telescopic_cascode_0.programmable_pfet$3_1.transmission_gate$23_0.out.t13 VDD.t240 VDD.t239 pfet_03v3 ad=10.4p pd=40.52u as=26p ps=81.3u w=40u l=0.5u
X841 scan_chain_0.D_ff1_4.inv1$4_0.Y CLK.t45 VDD.t287 VDD.t286 pfet_03v3 ad=0.546p pd=2.98u as=0.546p ps=2.98u w=0.84u l=0.28u
X842 a_49197_2844.t12 programmable_folded_cascode_0.programmable_pfet$1_0.transmission_gate$17_1.out.t11 programmable_folded_cascode_0.OUT.t7 VDD.t150 pfet_03v3 ad=19.24p pd=60.5u as=7.696p ps=30.12u w=29.6u l=0.5u
X843 scan_chain_0.D_ff1_4.D_latch1$1_1.NAND2$2_0.A programmable_common_source_0.EN0.t12 VDD.t414 VDD.t413 pfet_03v3 ad=0.2822p pd=2.18u as=0.2822p ps=2.18u w=0.42u l=0.28u
X844 programmable_telescopic_cascode_0.programmable_pfet$3_0.d.t30 programmable_telescopic_cascode_0.programmable_pfet$2_0.transmission_gate$22_0.out.t11 programmable_telescopic_cascode_0.programmable_pfet$3_0.g.t34 VDD.t623 pfet_03v3 ad=30.55p pd=95.3u as=12.22p ps=47.52u w=47u l=0.5u
X845 VDD.t218 a_61069_4063.t12 a_61069_4063.t13 VDD.t131 pfet_03v3 ad=14.95p pd=47.3u as=14.95p ps=47.3u w=23u l=1u
X846 programmable_telescopic_cascode_0.programmable_pfet$3_1.d.t17 programmable_telescopic_cascode_0.programmable_pfet$2_0.g.t17 OUT_TELESCOPIC.t10 VDD.t216 pfet_03v3 ad=30.55p pd=95.3u as=30.55p ps=95.3u w=47u l=0.5u
X847 VDD.t289 CLK.t46 scan_chain_0.D_ff1_6.D_latch1$1_1.NAND2$2_0.A VDD.t288 pfet_03v3 ad=0.2822p pd=2.18u as=0.2822p ps=2.18u w=0.42u l=0.28u
X848 VDD.t45 programmable_telescopic_cascode_0.programmable_pfet$3_1.transmission_gate$23_1.out.t8 programmable_telescopic_cascode_0.programmable_pfet$3_1.d.t5 VDD.t22 pfet_03v3 ad=26p pd=81.3u as=26p ps=81.3u w=40u l=0.5u
X849 VSS.t221 CLK.t47 a_55117_79067# VSS.t220 nfet_03v3 ad=0.2646p pd=2.1u as=0.2646p ps=2.1u w=0.42u l=0.28u
X850 programmable_telescopic_cascode_0.programmable_pfet$3_0.transmission_gate$23_0.out.t0 programmable_telescopic_cascode_0.EN1.t18 programmable_telescopic_cascode_0.programmable_pfet$3_0.g.t10 VDD.t114 pfet_03v3 ad=0.2822p pd=2.18u as=0.2822p ps=2.18u w=0.42u l=0.28u
X851 programmable_common_source_0.EN0.t1 PROG_ENA.t6 VSS.t76 VDD.t88 pfet_03v3 ad=0.2822p pd=2.18u as=0.2822p ps=2.18u w=0.42u l=0.28u
X852 OUT_5T.t2 programmable_5tOTA_0.programmable_pfet$4_1.transmission_gate$27_0.out.t5 VDD.t166 VDD.t14 pfet_03v3 ad=13p pd=50.52u as=32.5p ps=0.1013m w=50u l=0.5u
X853 programmable_telescopic_cascode_0.programmable_nfet$4_0.s.t4 programmable_telescopic_cascode_0.programmable_nfet$4_0.transmission_gate$24_1.out.t7 programmable_telescopic_cascode_0.programmable_pfet$3_0.g.t7 VSS.t142 nfet_03v3 ad=27.45p pd=91.22u as=27.45p ps=91.22u w=45u l=0.4u
X854 VDD.t283 scan_chain_0.D_ff1_6.D_latch1$1_1.Q_bar scan_chain_0.D_ff1_6.D_latch1$1_0.D VDD.t282 pfet_03v3 ad=0.2822p pd=2.18u as=0.2822p ps=2.18u w=0.42u l=0.28u
X855 VDD.t291 CLK.t48 scan_chain_0.D_ff1_2.D_latch1$1_1.NAND2$2_2.B VDD.t290 pfet_03v3 ad=0.2822p pd=2.18u as=0.2822p ps=2.18u w=0.42u l=0.28u
X856 scan_chain_0.D_ff1_1.D_latch1$1_1.NAND2$2_0.A transmission_gate$2$1_4.out.t22 VDD.t474 VDD.t473 pfet_03v3 ad=0.2822p pd=2.18u as=0.2822p ps=2.18u w=0.42u l=0.28u
X857 transmission_gate$2$1_6.out.t4 PROG_ENA.t7 VSS.t404 VDD.t514 pfet_03v3 ad=0.2822p pd=2.18u as=0.2822p ps=2.18u w=0.42u l=0.28u
X858 scan_chain_0.D_ff1_7.D_latch1$1_0.inv1$3_0.Y scan_chain_0.D_ff1_7.D_latch1$1_0.D VSS.t270 VSS.t269 nfet_03v3 ad=0.2646p pd=2.1u as=0.2646p ps=2.1u w=0.42u l=0.28u
X859 scan_chain_0.D_ff1_3.D_latch1$1_1.NAND2$2_2.B scan_chain_0.D_ff1_3.D_latch1$1_1.inv1$3_0.Y VDD.t487 VDD.t486 pfet_03v3 ad=0.2822p pd=2.18u as=0.2822p ps=2.18u w=0.42u l=0.28u
X860 VDD.t691 programmable_telescopic_cascode_0.programmable_pfet$3_0.transmission_gate$23_0.out.t12 programmable_telescopic_cascode_0.programmable_pfet$3_0.d.t40 VDD.t95 pfet_03v3 ad=26p pd=81.3u as=10.4p ps=40.52u w=40u l=0.5u
X861 VDD.t79 programmable_folded_cascode_0.programmable_pfet_0.transmission_gate$16_1.out.t20 a_49197_2844.t24 VDD.t78 pfet_03v3 ad=22.62p pd=70.9u as=9.048p ps=35.32u w=34.8u l=1u
X862 a_45880_2844.t21 programmable_folded_cascode_0.programmable_pfet_1.transmission_gate$16_1.out.t21 VDD.t324 VDD.t323 pfet_03v3 ad=9.048p pd=35.32u as=22.62p ps=70.9u w=34.8u l=1u
X863 scan_chain_0.D_ff1_3.D_latch1$1_0.inv1$3_0.Y scan_chain_0.D_ff1_3.D_latch1$1_0.D VSS.t266 VSS.t265 nfet_03v3 ad=0.2646p pd=2.1u as=0.2646p ps=2.1u w=0.42u l=0.28u
X864 programmable_telescopic_cascode_0.programmable_pfet$3_0.d.t41 programmable_telescopic_cascode_0.programmable_pfet$3_0.transmission_gate$23_0.out.t13 VDD.t692 VDD.t99 pfet_03v3 ad=10.4p pd=40.52u as=26p ps=81.3u w=40u l=0.5u
X865 programmable_folded_cascode_0.programmable_nfet$1_0.g.t31 programmable_folded_cascode_0.programmable_nfet$1_1.transmission_gate$19_1.out programmable_folded_cascode_0.programmable_nfet$2_0.g.t15 VSS.t481 nfet_03v3 ad=2.73p pd=11.02u as=6.405p ps=22.22u w=10.5u l=0.5u
X866 a_18096_79808# scan_chain_0.D_ff1_7.D_latch1$1_1.NAND2$2_0.A scan_chain_0.D_ff1_7.D_latch1$1_0.D VSS.t152 nfet_03v3 ad=0.2646p pd=2.1u as=0.2646p ps=2.1u w=0.42u l=0.28u
X867 scan_chain_0.D_ff1_0.D_latch1$1_0.inv1$3_0.Y scan_chain_0.D_ff1_0.D_latch1$1_0.D VDD.t350 VDD.t349 pfet_03v3 ad=0.546p pd=2.98u as=0.546p ps=2.98u w=0.84u l=0.28u
X868 VDD.t137 a_61069_4063.t23 programmable_folded_cascode_0.programmable_nfet$3_0.g.t2 VDD.t133 pfet_03v3 ad=14.95p pd=47.3u as=14.95p ps=47.3u w=23u l=1u
X869 VSS.t293 scan_chain_0.D_ff1_6.inv1$4_0.Y a_12766_79067# VSS.t292 nfet_03v3 ad=0.2646p pd=2.1u as=0.2646p ps=2.1u w=0.42u l=0.28u
X870 transmission_gate$2$1_7.out.t2 PROG_ENA.t8 VSS.t405 VDD.t515 pfet_03v3 ad=0.2822p pd=2.18u as=0.2822p ps=2.18u w=0.42u l=0.28u
X871 VSS.t223 CLK.t49 a_1210_79808# VSS.t222 nfet_03v3 ad=0.2646p pd=2.1u as=0.2646p ps=2.1u w=0.42u l=0.28u
X872 VDD.t80 programmable_folded_cascode_0.programmable_pfet_0.transmission_gate$16_1.out.t21 a_49197_2844.t23 VDD.t78 pfet_03v3 ad=22.62p pd=70.9u as=9.048p ps=35.32u w=34.8u l=1u
X873 VDD.t138 a_61069_4063.t24 programmable_folded_cascode_0.programmable_nfet$3_0.g.t1 VDD.t133 pfet_03v3 ad=14.95p pd=47.3u as=14.95p ps=47.3u w=23u l=1u
X874 programmable_folded_cascode_0.programmable_nfet$3_0.transmission_gate$21_1.out.t1 programmable_folded_cascode_0.EN1.t20 programmable_folded_cascode_0.programmable_nfet$3_0.g.t7 VDD.t480 pfet_03v3 ad=0.2822p pd=2.18u as=0.2822p ps=2.18u w=0.42u l=0.28u
X875 programmable_telescopic_cascode_0.programmable_pfet$3_0.d.t31 programmable_telescopic_cascode_0.programmable_pfet$2_0.transmission_gate$22_0.out.t12 programmable_telescopic_cascode_0.programmable_pfet$3_0.g.t35 VDD.t623 pfet_03v3 ad=30.55p pd=95.3u as=12.22p ps=47.52u w=47u l=0.5u
X876 VDD.t493 scan_chain_0.D_ff1_8.D_latch1$1_1.Q_bar scan_chain_0.D_ff1_8.D_latch1$1_0.D VDD.t492 pfet_03v3 ad=0.2822p pd=2.18u as=0.2822p ps=2.18u w=0.42u l=0.28u
X877 OUT_CS.t32 programmable_common_source_0.programmable_pfet$5_0.transmission_gate$30_0.out.t22 VDD.t471 VDD.t465 pfet_03v3 ad=2.392p pd=9.72u as=5.98p ps=19.7u w=9.2u l=1u
X878 programmable_folded_cascode_0.programmable_nfet_1.transmission_gate$18_1.out programmable_folded_cascode_0.EN1.t21 INP_FOLDED.t2 VDD.t481 pfet_03v3 ad=0.2822p pd=2.18u as=0.2822p ps=2.18u w=0.42u l=0.28u
X879 a_91570_47942.t24 programmable_5tOTA_0.programmable_nfet$7_0.transmission_gate$28_1.out OUT_5T.t7 VSS.t242 nfet_03v3 ad=6.954p pd=24.02u as=2.964p ps=11.92u w=11.4u l=0.5u
X880 IBIAS.t6 programmable_common_source_0.EN1.t6 programmable_common_source_0.programmable_nfet$9_0.transmission_gate$31_1.out VDD.t169 pfet_03v3 ad=0.2822p pd=2.18u as=0.2822p ps=2.18u w=0.42u l=0.28u
X881 programmable_telescopic_cascode_0.programmable_pfet$3_1.d.t18 programmable_telescopic_cascode_0.programmable_pfet$2_0.g.t18 OUT_TELESCOPIC.t11 VDD.t216 pfet_03v3 ad=30.55p pd=95.3u as=30.55p ps=95.3u w=47u l=0.5u
X882 VSS.t128 scan_chain_0.D_ff1_5.inv1$4_0.Y a_5065_79067# VSS.t127 nfet_03v3 ad=0.2646p pd=2.1u as=0.2646p ps=2.1u w=0.42u l=0.28u
X883 programmable_telescopic_cascode_0.programmable_pfet$3_0.d.t10 programmable_telescopic_cascode_0.programmable_pfet$2_0.g.t19 programmable_telescopic_cascode_0.programmable_pfet$3_0.g.t12 VDD.t46 pfet_03v3 ad=30.55p pd=95.3u as=30.55p ps=95.3u w=47u l=0.5u
X884 a_49197_2844.t61 programmable_folded_cascode_0.programmable_pfet_0.g.t37 VDD.t598 VDD.t193 pfet_03v3 ad=22.62p pd=70.9u as=22.62p ps=70.9u w=34.8u l=1u
X885 scan_chain_0.D_ff1_0.D_latch1$1_0.D scan_chain_0.D_ff1_0.D_latch1$1_1.NAND2$2_0.A VDD.t561 VDD.t560 pfet_03v3 ad=0.2822p pd=2.18u as=0.2822p ps=2.18u w=0.42u l=0.28u
X886 a_45880_2844.t11 programmable_folded_cascode_0.programmable_pfet$1_1.transmission_gate$17_1.out.t12 programmable_folded_cascode_0.programmable_nfet$1_0.g.t14 VDD.t122 pfet_03v3 ad=19.24p pd=60.5u as=7.696p ps=30.12u w=29.6u l=0.5u
X887 VSS.t109 IBIAS.t20 programmable_folded_cascode_0.programmable_pfet_0.g.t0 VSS.t108 nfet_03v3 ad=16.531p pd=55.42u as=16.531p ps=55.42u w=27.1u l=1u
X888 a_49197_2844.t4 INN_FOLDED.t5 a_55661_23626.t7 VSS.t149 nfet_03v3 ad=18.3p pd=61.22u as=18.3p ps=61.22u w=30u l=0.5u
X889 VSS.t193 programmable_telescopic_cascode_0.programmable_nfet$6_0.transmission_gate$26_1.out programmable_telescopic_cascode_0.programmable_nfet$6_0.d.t7 VSS.t192 nfet_03v3 ad=16.531p pd=55.42u as=16.531p ps=55.42u w=27.1u l=1u
X890 a_45880_2844.t57 programmable_folded_cascode_0.programmable_pfet_1.transmission_gate$16_0.out.t12 VDD.t609 VDD.t607 pfet_03v3 ad=22.62p pd=70.9u as=22.62p ps=70.9u w=34.8u l=1u
X891 programmable_telescopic_cascode_0.programmable_nfet$5_1.d.t6 programmable_telescopic_cascode_0.programmable_nfet$4_1.transmission_gate$24_0.out.t13 OUT_TELESCOPIC.t3 VSS.t119 nfet_03v3 ad=27.45p pd=91.22u as=11.7p ps=45.52u w=45u l=0.4u
X892 a_51271_79808# scan_chain_0.D_ff1_3.D_latch1$1_0.D scan_chain_0.D_ff1_3.D_latch1$1_0.NAND2$2_0.A VSS.t264 nfet_03v3 ad=0.2646p pd=2.1u as=0.2646p ps=2.1u w=0.42u l=0.28u
X893 a_45880_2844.t7 programmable_folded_cascode_0.programmable_nfet_1.transmission_gate$18_0.out a_55661_23626.t14 VSS.t89 nfet_03v3 ad=18.3p pd=61.22u as=18.3p ps=61.22u w=30u l=0.5u
X894 transmission_gate$2$1_7.ena PROG_ENA.t9 VDD.t517 VDD.t516 pfet_03v3 ad=0.546p pd=2.98u as=0.546p ps=2.98u w=0.84u l=0.28u
X895 a_49197_2844.t22 programmable_folded_cascode_0.programmable_pfet_0.transmission_gate$16_1.out.t22 VDD.t82 VDD.t81 pfet_03v3 ad=9.048p pd=35.32u as=22.62p ps=70.9u w=34.8u l=1u
X896 VDD.t374 scan_chain_0.D_ff1_7.D_latch1$1_0.D scan_chain_0.D_ff1_7.D_latch1$1_1.Q_bar VDD.t373 pfet_03v3 ad=0.2822p pd=2.18u as=0.2822p ps=2.18u w=0.42u l=0.28u
X897 scan_chain_0.D_ff1_2.D_latch1$1_1.NAND2$2_2.B scan_chain_0.D_ff1_2.D_latch1$1_1.inv1$3_0.Y VDD.t50 VDD.t49 pfet_03v3 ad=0.2822p pd=2.18u as=0.2822p ps=2.18u w=0.42u l=0.28u
X898 programmable_5tOTA_0.programmable_pfet$4_0.g.t3 programmable_5tOTA_0.programmable_nfet$7_1.transmission_gate$28_1.out a_91570_47942.t3 VSS.t45 nfet_03v3 ad=2.964p pd=11.92u as=6.954p ps=24.02u w=11.4u l=0.5u
X899 programmable_telescopic_cascode_0.programmable_nfet$4_1.transmission_gate$24_0.out.t2 transmission_gate$2$1_4.out.t23 programmable_telescopic_cascode_0.programmable_nfet$4_0.g.t7 VSS.t367 nfet_03v3 ad=0.2646p pd=2.1u as=0.2646p ps=2.1u w=0.42u l=0.28u
X900 programmable_folded_cascode_0.OUT.t16 programmable_folded_cascode_0.programmable_nfet$1_0.transmission_gate$19_0.out a_58284_41264.t3 VSS.t191 nfet_03v3 ad=6.405p pd=22.22u as=6.405p ps=22.22u w=10.5u l=0.5u
X901 programmable_telescopic_cascode_0.programmable_nfet$5_1.d.t13 programmable_telescopic_cascode_0.programmable_nfet$4_1.transmission_gate$24_1.out.t8 OUT_TELESCOPIC.t16 VSS.t145 nfet_03v3 ad=27.45p pd=91.22u as=27.45p ps=91.22u w=45u l=0.4u
X902 VDD.t298 scan_chain_0.D_ff1_8.inv1$4_0.Y scan_chain_0.D_ff1_8.D_latch1$1_0.NAND2$2_0.A VDD.t297 pfet_03v3 ad=0.2822p pd=2.18u as=0.2822p ps=2.18u w=0.42u l=0.28u
X903 scan_chain_0.D_ff1_4.D_latch1$1_1.Q_bar scan_chain_0.D_ff1_4.D_latch1$1_1.NAND2$2_2.B VDD.t422 VDD.t421 pfet_03v3 ad=0.2822p pd=2.18u as=0.2822p ps=2.18u w=0.42u l=0.28u
X904 OUT_TELESCOPIC.t38 programmable_telescopic_cascode_0.programmable_pfet$2_1.transmission_gate$22_0.out.t11 programmable_telescopic_cascode_0.programmable_pfet$3_1.d.t7 VDD.t139 pfet_03v3 ad=12.22p pd=47.52u as=30.55p ps=95.3u w=47u l=0.5u
X905 programmable_folded_cascode_0.programmable_pfet_0.g.t12 transmission_gate$2$1_7.out.t24 programmable_folded_cascode_0.programmable_pfet_1.transmission_gate$16_0.out.t1 VSS.t522 nfet_03v3 ad=0.2646p pd=2.1u as=0.2646p ps=2.1u w=0.42u l=0.28u
X906 VDD.t162 programmable_telescopic_cascode_0.programmable_pfet$3_0.g.t63 programmable_telescopic_cascode_0.programmable_pfet$3_1.d.t30 VDD.t160 pfet_03v3 ad=26p pd=81.3u as=26p ps=81.3u w=40u l=0.5u
X907 programmable_5tOTA_0.programmable_pfet$4_0.g.t29 programmable_5tOTA_0.ena_bar<1>.t12 programmable_5tOTA_0.programmable_pfet$4_0.transmission_gate$27_0.out.t0 VDD.t712 pfet_03v3 ad=0.2822p pd=2.18u as=0.2822p ps=2.18u w=0.42u l=0.28u
X908 scan_chain_0.D_ff1_0.D_latch1$1_0.NAND2$2_0.A scan_chain_0.D_ff1_0.D_latch1$1_0.D VDD.t348 VDD.t347 pfet_03v3 ad=0.2822p pd=2.18u as=0.2822p ps=2.18u w=0.42u l=0.28u
X909 programmable_folded_cascode_0.programmable_nfet_1.transmission_gate$18_1.out programmable_folded_cascode_0.EN1.t22 VSS.t387 VSS.t386 nfet_03v3 ad=0.2646p pd=2.1u as=0.2646p ps=2.1u w=0.42u l=0.28u
X910 a_55661_23626.t16 programmable_folded_cascode_0.programmable_nfet$3_0.transmission_gate$21_0.out VSS.t214 VSS.t213 nfet_03v3 ad=12.2p pd=41.22u as=12.2p ps=41.22u w=20u l=1u
X911 programmable_5tOTA_0.programmable_pfet$4_0.g.t2 programmable_5tOTA_0.programmable_nfet$7_1.transmission_gate$28_1.out a_91570_47942.t2 VSS.t45 nfet_03v3 ad=2.964p pd=11.92u as=6.954p ps=24.02u w=11.4u l=0.5u
X912 VSS.t158 scan_chain_0.D_ff1_2.inv1$4_0.Y a_43570_79808# VSS.t157 nfet_03v3 ad=0.2646p pd=2.1u as=0.2646p ps=2.1u w=0.42u l=0.28u
X913 VDD.t296 programmable_common_source_0.programmable_pfet$5_0.transmission_gate$30_1.out.t12 OUT_CS.t14 VDD.t256 pfet_03v3 ad=5.98p pd=19.7u as=5.98p ps=19.7u w=9.2u l=1u
X914 a_45880_2844.t53 programmable_folded_cascode_0.programmable_pfet_0.g.t38 VDD.t600 VDD.t599 pfet_03v3 ad=22.62p pd=70.9u as=22.62p ps=70.9u w=34.8u l=1u
X915 VDD.t521 programmable_telescopic_cascode_0.programmable_pfet$3_0.transmission_gate$23_0.out.t14 programmable_telescopic_cascode_0.programmable_pfet$3_0.d.t24 VDD.t95 pfet_03v3 ad=26p pd=81.3u as=10.4p ps=40.52u w=40u l=0.5u
X916 a_10394_79067# scan_chain_0.D_ff1_6.D_latch1$1_1.NAND2$2_2.B VSS.t336 VSS.t335 nfet_03v3 ad=0.2646p pd=2.1u as=0.2646p ps=2.1u w=0.42u l=0.28u
X917 VDD.t416 programmable_common_source_0.EN0.t13 programmable_common_source_0.programmable_pfet$5_0.transmission_gate$30_1.out.t2 VDD.t415 pfet_03v3 ad=0.2822p pd=2.18u as=0.2822p ps=2.18u w=0.42u l=0.28u
X918 scan_chain_0.D_ff1_5.D_latch1$1_1.inv1$3_0.Y SCAN_IN.t3 VSS.t532 VSS.t531 nfet_03v3 ad=0.2646p pd=2.1u as=0.2646p ps=2.1u w=0.42u l=0.28u
X919 programmable_telescopic_cascode_0.EN0.t2 scan_chain_0.D_ff1_7.D_latch1$1_0.NAND2$2_2.B VDD.t432 VDD.t431 pfet_03v3 ad=0.2822p pd=2.18u as=0.2822p ps=2.18u w=0.42u l=0.28u
X920 VSS.t249 scan_chain_0.D_ff1_1.D_latch1$1_1.Q_bar a_33498_79808# VSS.t248 nfet_03v3 ad=0.2646p pd=2.1u as=0.2646p ps=2.1u w=0.42u l=0.28u
X921 VDD.t650 scan_chain_0.D_ff1_0.Q_bar SCAN_OUT.t0 VDD.t649 pfet_03v3 ad=0.2822p pd=2.18u as=0.2822p ps=2.18u w=0.42u l=0.28u
X922 a_45880_2844.t67 programmable_folded_cascode_0.programmable_nfet_1.transmission_gate$18_1.out a_55661_23626.t20 VSS.t457 nfet_03v3 ad=7.8p pd=30.52u as=18.3p ps=61.22u w=30u l=0.5u
X923 a_58284_41264.t1 programmable_folded_cascode_0.programmable_nfet$2_0.transmission_gate$20_1.out VSS.t154 VSS.t153 nfet_03v3 ad=5.33p pd=21.02u as=12.505p ps=42.22u w=20.5u l=1u
X924 programmable_telescopic_cascode_0.programmable_pfet$3_0.g.t1 transmission_gate$2$1_5.out.t22 programmable_telescopic_cascode_0.programmable_pfet$3_0.transmission_gate$23_1.out.t0 VSS.t20 nfet_03v3 ad=0.2646p pd=2.1u as=0.2646p ps=2.1u w=0.42u l=0.28u
X925 programmable_folded_cascode_0.programmable_nfet$1_0.g.t4 programmable_folded_cascode_0.programmable_pfet$1_1.transmission_gate$17_0.out.t7 a_45880_2844.t4 VDD.t20 pfet_03v3 ad=19.24p pd=60.5u as=19.24p ps=60.5u w=29.6u l=0.5u
X926 a_2693_79067# scan_chain_0.D_ff1_5.D_latch1$1_1.NAND2$2_2.B VSS.t260 VSS.t259 nfet_03v3 ad=0.2646p pd=2.1u as=0.2646p ps=2.1u w=0.42u l=0.28u
X927 scan_chain_0.D_ff1_4.D_latch1$1_0.NAND2$2_2.B scan_chain_0.D_ff1_4.D_latch1$1_0.inv1$3_0.Y VDD.t71 VDD.t70 pfet_03v3 ad=0.2822p pd=2.18u as=0.2822p ps=2.18u w=0.42u l=0.28u
X928 VDD.t448 IN_CS.t13 OUT_CS.t13 VDD.t274 pfet_03v3 ad=5.98p pd=19.7u as=5.98p ps=19.7u w=9.2u l=1u
X929 IBIAS.t9 transmission_gate$2$1_2.out.t15 programmable_5tOTA_0.programmable_nfet$8_0.transmission_gate$29_1.out.t2 VSS.t411 nfet_03v3 ad=0.2646p pd=2.1u as=0.2646p ps=2.1u w=0.42u l=0.28u
X930 a_49197_2844.t57 programmable_folded_cascode_0.programmable_pfet_0.transmission_gate$16_0.out.t11 VDD.t526 VDD.t518 pfet_03v3 ad=22.62p pd=70.9u as=22.62p ps=70.9u w=34.8u l=1u
X931 VDD.t217 a_61069_4063.t10 a_61069_4063.t11 VDD.t131 pfet_03v3 ad=14.95p pd=47.3u as=14.95p ps=47.3u w=23u l=1u
X932 OUT_TELESCOPIC.t5 programmable_telescopic_cascode_0.programmable_pfet$2_1.transmission_gate$22_0.out.t12 programmable_telescopic_cascode_0.programmable_pfet$3_1.d.t6 VDD.t139 pfet_03v3 ad=12.22p pd=47.52u as=30.55p ps=95.3u w=47u l=0.5u
X933 programmable_5tOTA_0.programmable_pfet$4_0.g.t25 transmission_gate$2$1_2.out.t16 programmable_5tOTA_0.programmable_pfet$4_0.transmission_gate$27_0.out.t1 VSS.t412 nfet_03v3 ad=0.2646p pd=2.1u as=0.2646p ps=2.1u w=0.42u l=0.28u
X934 a_24313_79067# scan_chain_0.D_ff1_8.D_latch1$1_1.inv1$3_0.Y scan_chain_0.D_ff1_8.D_latch1$1_1.NAND2$2_2.B VSS.t44 nfet_03v3 ad=0.2646p pd=2.1u as=0.2646p ps=2.1u w=0.42u l=0.28u
X935 programmable_5tOTA_0.ena_bar<0>.t0 scan_chain_0.D_ff1_1.D_latch1$1_0.NAND2$2_2.B VDD.t27 VDD.t26 pfet_03v3 ad=0.2822p pd=2.18u as=0.2822p ps=2.18u w=0.42u l=0.28u
X936 VDD.t167 programmable_5tOTA_0.programmable_pfet$4_1.transmission_gate$27_0.out.t6 OUT_5T.t3 VDD.t16 pfet_03v3 ad=32.5p pd=0.1013m as=13p ps=50.52u w=50u l=0.5u
X937 scan_chain_0.D_ff1_3.D_latch1$1_1.inv1$3_0.Y transmission_gate$2$1_2.out.t17 VDD.t540 VDD.t539 pfet_03v3 ad=0.546p pd=2.98u as=0.546p ps=2.98u w=0.84u l=0.28u
X938 OUT_TELESCOPIC.t4 programmable_telescopic_cascode_0.programmable_nfet$4_1.transmission_gate$24_0.out.t14 programmable_telescopic_cascode_0.programmable_nfet$5_1.d.t7 VSS.t120 nfet_03v3 ad=11.7p pd=45.52u as=27.45p ps=91.22u w=45u l=0.4u
X939 a_91570_47942.t12 IBIAS.t21 VSS.t111 VSS.t110 nfet_03v3 ad=13.908p pd=46.82u as=13.908p ps=46.82u w=22.8u l=1u
X940 VSS.t141 programmable_common_source_0.EN1.t7 a_60456_79808# VSS.t140 nfet_03v3 ad=0.2646p pd=2.1u as=0.2646p ps=2.1u w=0.42u l=0.28u
X941 scan_chain_0.D_ff1_0.D_latch1$1_1.Q_bar scan_chain_0.D_ff1_0.D_latch1$1_0.D a_64301_79067# VSS.t254 nfet_03v3 ad=0.2646p pd=2.1u as=0.2646p ps=2.1u w=0.42u l=0.28u
X942 a_49197_2844.t58 programmable_folded_cascode_0.programmable_pfet_0.transmission_gate$16_0.out.t12 VDD.t528 VDD.t527 pfet_03v3 ad=22.62p pd=70.9u as=22.62p ps=70.9u w=34.8u l=1u
X943 scan_chain_0.D_ff1_7.inv1$4_0.Y CLK.t50 VDD.t293 VDD.t292 pfet_03v3 ad=0.546p pd=2.98u as=0.546p ps=2.98u w=0.84u l=0.28u
X944 scan_chain_0.D_ff1_3.inv1$4_0.Y CLK.t51 VDD.t295 VDD.t294 pfet_03v3 ad=0.546p pd=2.98u as=0.546p ps=2.98u w=0.84u l=0.28u
X945 VSS.t105 programmable_5tOTA_0.programmable_nfet$8_0.transmission_gate$29_1.out.t8 a_91570_47942.t11 VSS.t28 nfet_03v3 ad=13.908p pd=46.82u as=5.928p ps=23.32u w=22.8u l=1u
X946 programmable_telescopic_cascode_0.programmable_nfet$4_0.s.t5 programmable_telescopic_cascode_0.programmable_nfet$4_0.transmission_gate$24_1.out.t8 programmable_telescopic_cascode_0.programmable_pfet$3_0.g.t8 VSS.t142 nfet_03v3 ad=27.45p pd=91.22u as=27.45p ps=91.22u w=45u l=0.4u
X947 programmable_folded_cascode_0.OUT.t1 programmable_folded_cascode_0.programmable_pfet$1_0.g.t38 a_49197_2844.t47 VDD.t364 pfet_03v3 ad=19.24p pd=60.5u as=19.24p ps=60.5u w=29.6u l=0.5u
X948 programmable_telescopic_cascode_0.programmable_pfet$3_1.d.t16 programmable_telescopic_cascode_0.programmable_pfet$2_0.g.t20 OUT_TELESCOPIC.t9 VDD.t216 pfet_03v3 ad=30.55p pd=95.3u as=30.55p ps=95.3u w=47u l=0.5u
X949 scan_chain_0.D_ff1_6.D_latch1$1_0.inv1$3_0.Y scan_chain_0.D_ff1_6.D_latch1$1_0.D VDD.t717 VDD.t716 pfet_03v3 ad=0.546p pd=2.98u as=0.546p ps=2.98u w=0.84u l=0.28u
X950 VSS.t225 CLK.t52 a_16612_79067# VSS.t224 nfet_03v3 ad=0.2646p pd=2.1u as=0.2646p ps=2.1u w=0.42u l=0.28u
X951 programmable_telescopic_cascode_0.programmable_pfet$3_1.d.t23 programmable_telescopic_cascode_0.programmable_pfet$3_1.transmission_gate$23_0.out.t14 VDD.t241 VDD.t239 pfet_03v3 ad=10.4p pd=40.52u as=26p ps=81.3u w=40u l=0.5u
X952 programmable_folded_cascode_0.programmable_nfet$2_0.g.t4 transmission_gate$2$1_7.out.t25 programmable_folded_cascode_0.programmable_nfet$2_0.transmission_gate$20_0.out VSS.t523 nfet_03v3 ad=0.2646p pd=2.1u as=0.2646p ps=2.1u w=0.42u l=0.28u
X953 programmable_common_source_0.EN1.t4 transmission_gate$2$1_7.ena VSS.t340 VSS.t339 nfet_03v3 ad=0.2646p pd=2.1u as=0.2646p ps=2.1u w=0.42u l=0.28u
X954 a_45880_2844.t20 programmable_folded_cascode_0.programmable_pfet_1.transmission_gate$16_1.out.t22 VDD.t322 VDD.t321 pfet_03v3 ad=9.048p pd=35.32u as=22.62p ps=70.9u w=34.8u l=1u
X955 a_52754_79067# scan_chain_0.D_ff1_3.D_latch1$1_0.NAND2$2_2.B VSS.t485 VSS.t484 nfet_03v3 ad=0.2646p pd=2.1u as=0.2646p ps=2.1u w=0.42u l=0.28u
X956 a_45880_2844.t6 INP_FOLDED.t5 a_55661_23626.t5 VSS.t18 nfet_03v3 ad=18.3p pd=61.22u as=18.3p ps=61.22u w=30u l=0.5u
X957 a_49197_2844.t13 programmable_folded_cascode_0.programmable_pfet$1_0.transmission_gate$17_1.out.t12 programmable_folded_cascode_0.OUT.t6 VDD.t148 pfet_03v3 ad=19.24p pd=60.5u as=7.696p ps=30.12u w=29.6u l=0.5u
X958 VSS.t227 CLK.t53 a_8911_79067# VSS.t226 nfet_03v3 ad=0.2646p pd=2.1u as=0.2646p ps=2.1u w=0.42u l=0.28u
X959 scan_chain_0.D_ff1_8.D_latch1$1_1.inv1$3_0.Y transmission_gate$2$1_5.out.t23 VSS.t22 VSS.t21 nfet_03v3 ad=0.2646p pd=2.1u as=0.2646p ps=2.1u w=0.42u l=0.28u
X960 a_43570_79067# scan_chain_0.D_ff1_2.D_latch1$1_0.inv1$3_0.Y scan_chain_0.D_ff1_2.D_latch1$1_0.NAND2$2_2.B VSS.t403 nfet_03v3 ad=0.2646p pd=2.1u as=0.2646p ps=2.1u w=0.42u l=0.28u
X961 programmable_telescopic_cascode_0.programmable_pfet$3_0.d.t13 programmable_telescopic_cascode_0.programmable_pfet$2_0.transmission_gate$22_1.out.t7 programmable_telescopic_cascode_0.programmable_pfet$3_0.g.t18 VDD.t653 pfet_03v3 ad=30.55p pd=95.3u as=30.55p ps=95.3u w=47u l=0.5u
X962 programmable_telescopic_cascode_0.programmable_nfet$4_0.g.t2 IBIAS.t22 VSS.t113 VSS.t112 nfet_03v3 ad=18.3p pd=61.22u as=18.3p ps=61.22u w=30u l=0.5u
R0 programmable_folded_cascode_0.programmable_pfet_1.transmission_gate$16_1.out.t21 programmable_folded_cascode_0.programmable_pfet_1.transmission_gate$16_1.out.t14 264.151
R1 programmable_folded_cascode_0.programmable_pfet_1.transmission_gate$16_1.out.t11 programmable_folded_cascode_0.programmable_pfet_1.transmission_gate$16_1.out.t4 264.151
R2 programmable_folded_cascode_0.programmable_pfet_1.transmission_gate$16_1.out.t14 programmable_folded_cascode_0.programmable_pfet_1.transmission_gate$16_1.out.t20 264.115
R3 programmable_folded_cascode_0.programmable_pfet_1.transmission_gate$16_1.out.t22 programmable_folded_cascode_0.programmable_pfet_1.transmission_gate$16_1.out.t21 264.115
R4 programmable_folded_cascode_0.programmable_pfet_1.transmission_gate$16_1.out.t18 programmable_folded_cascode_0.programmable_pfet_1.transmission_gate$16_1.out.t22 264.115
R5 programmable_folded_cascode_0.programmable_pfet_1.transmission_gate$16_1.out.t7 programmable_folded_cascode_0.programmable_pfet_1.transmission_gate$16_1.out.t18 264.115
R6 programmable_folded_cascode_0.programmable_pfet_1.transmission_gate$16_1.out.t8 programmable_folded_cascode_0.programmable_pfet_1.transmission_gate$16_1.out.t7 264.115
R7 programmable_folded_cascode_0.programmable_pfet_1.transmission_gate$16_1.out.t3 programmable_folded_cascode_0.programmable_pfet_1.transmission_gate$16_1.out.t8 264.115
R8 programmable_folded_cascode_0.programmable_pfet_1.transmission_gate$16_1.out.t19 programmable_folded_cascode_0.programmable_pfet_1.transmission_gate$16_1.out.t3 264.115
R9 programmable_folded_cascode_0.programmable_pfet_1.transmission_gate$16_1.out.t5 programmable_folded_cascode_0.programmable_pfet_1.transmission_gate$16_1.out.t19 264.115
R10 programmable_folded_cascode_0.programmable_pfet_1.transmission_gate$16_1.out.t4 programmable_folded_cascode_0.programmable_pfet_1.transmission_gate$16_1.out.t6 264.115
R11 programmable_folded_cascode_0.programmable_pfet_1.transmission_gate$16_1.out.t12 programmable_folded_cascode_0.programmable_pfet_1.transmission_gate$16_1.out.t11 264.115
R12 programmable_folded_cascode_0.programmable_pfet_1.transmission_gate$16_1.out.t9 programmable_folded_cascode_0.programmable_pfet_1.transmission_gate$16_1.out.t12 264.115
R13 programmable_folded_cascode_0.programmable_pfet_1.transmission_gate$16_1.out.t16 programmable_folded_cascode_0.programmable_pfet_1.transmission_gate$16_1.out.t9 264.115
R14 programmable_folded_cascode_0.programmable_pfet_1.transmission_gate$16_1.out.t17 programmable_folded_cascode_0.programmable_pfet_1.transmission_gate$16_1.out.t16 264.115
R15 programmable_folded_cascode_0.programmable_pfet_1.transmission_gate$16_1.out.t13 programmable_folded_cascode_0.programmable_pfet_1.transmission_gate$16_1.out.t17 264.115
R16 programmable_folded_cascode_0.programmable_pfet_1.transmission_gate$16_1.out.t10 programmable_folded_cascode_0.programmable_pfet_1.transmission_gate$16_1.out.t13 264.115
R17 programmable_folded_cascode_0.programmable_pfet_1.transmission_gate$16_1.out.t15 programmable_folded_cascode_0.programmable_pfet_1.transmission_gate$16_1.out.t10 264.115
R18 programmable_folded_cascode_0.programmable_pfet_1.transmission_gate$16_1.out.n0 programmable_folded_cascode_0.programmable_pfet_1.transmission_gate$16_1.out.t15 143.1
R19 programmable_folded_cascode_0.programmable_pfet_1.transmission_gate$16_1.out.n1 programmable_folded_cascode_0.programmable_pfet_1.transmission_gate$16_1.out.t5 138.597
R20 programmable_folded_cascode_0.programmable_pfet_1.transmission_gate$16_1.out.n0 programmable_folded_cascode_0.programmable_pfet_1.transmission_gate$16_1.out.t0 17.7026
R21 programmable_folded_cascode_0.programmable_pfet_1.transmission_gate$16_1.out.n2 programmable_folded_cascode_0.programmable_pfet_1.transmission_gate$16_1.out.t2 12.5327
R22 programmable_folded_cascode_0.programmable_pfet_1.transmission_gate$16_1.out programmable_folded_cascode_0.programmable_pfet_1.transmission_gate$16_1.out.t1 12.2669
R23 programmable_folded_cascode_0.programmable_pfet_1.transmission_gate$16_1.out.n2 programmable_folded_cascode_0.programmable_pfet_1.transmission_gate$16_1.out.n1 10.2686
R24 programmable_folded_cascode_0.programmable_pfet_1.transmission_gate$16_1.out.n1 programmable_folded_cascode_0.programmable_pfet_1.transmission_gate$16_1.out.n0 4.84686
R25 programmable_folded_cascode_0.programmable_pfet_1.transmission_gate$16_1.out programmable_folded_cascode_0.programmable_pfet_1.transmission_gate$16_1.out.n2 0.0245
R26 VDD.t207 VDD.t481 1619.57
R27 VDD.t126 VDD.t674 1619.57
R28 VDD.t557 VDD.t682 1619.57
R29 VDD.t203 VDD.t478 1619.57
R30 VDD.t128 VDD.t677 1619.57
R31 VDD.t602 VDD.t679 1619.57
R32 VDD.t206 VDD.t480 1619.57
R33 VDD.t168 VDD.t34 1619.57
R34 VDD.t169 VDD.t35 1619.57
R35 VDD.t245 VDD.t114 1619.57
R36 VDD.t120 VDD.t459 1619.57
R37 VDD.t41 VDD.t641 1619.57
R38 VDD.t236 VDD.t637 1619.57
R39 VDD.t0 VDD.t38 1619.57
R40 VDD.t113 VDD.t42 1619.57
R41 VDD.t152 VDD.t249 1619.57
R42 VDD.t248 VDD.t154 1619.57
R43 VDD.t40 VDD.t153 1619.57
R44 VDD.t234 VDD.t642 1619.57
R45 VDD.t235 VDD.t640 1619.57
R46 VDD.t18 VDD.t76 1619.57
R47 VDD.t656 VDD.t425 1619.57
R48 VDD.t624 VDD.t451 1619.57
R49 VDD.t266 VDD.t413 1619.57
R50 VDD.t36 VDD.t643 1619.57
R51 VDD.t365 VDD.t385 1619.57
R52 VDD.t445 VDD.t496 1619.57
R53 VDD.t550 VDD.t633 1619.57
R54 VDD.t706 VDD.t146 1619.57
R55 VDD.t201 VDD.t564 1619.57
R56 VDD.t407 VDD.t8 1619.57
R57 VDD.t181 VDD.t635 1619.57
R58 VDD.t403 VDD.t658 1619.57
R59 VDD.t317 VDD.t66 1619.57
R60 VDD.t68 VDD.t313 1619.57
R61 VDD.t627 VDD.t473 1619.57
R62 VDD.t638 VDD.t405 1619.57
R63 VDD.t455 VDD.t297 1619.57
R64 VDD.t492 VDD.t359 1619.57
R65 VDD.t6 VDD.t390 1619.57
R66 VDD.t246 VDD.t305 1619.57
R67 VDD.t377 VDD.t303 1619.57
R68 VDD.t197 VDD.t272 1619.57
R69 VDD.t533 VDD.t284 1619.57
R70 VDD.t675 VDD.t12 1619.57
R71 VDD.t720 VDD.t399 1619.57
R72 VDD.t115 VDD.t282 1619.57
R73 VDD.t288 VDD.t227 1619.57
R74 VDD.t204 VDD.t668 1619.57
R75 VDD.t435 VDD.t140 1619.57
R76 VDD.t441 VDD.t371 1619.57
R77 VDD.t713 VDD.t572 1619.57
R78 VDD.t439 VDD.t355 1619.57
R79 VDD.t396 VDD.t163 1619.57
R80 VDD.t694 VDD.t144 1619.57
R81 VDD.t620 VDD.t142 1619.57
R82 VDD.t718 VDD.t443 1619.57
R83 VDD.t10 VDD.t578 1619.57
R84 VDD.t417 VDD.t531 1619.57
R85 VDD.t124 VDD.t401 1619.57
R86 VDD.t270 VDD.t373 1619.57
R87 VDD.t558 VDD.t576 1619.57
R88 VDD.t2 VDD.t431 1619.57
R89 VDD.t301 VDD.t53 1619.57
R90 VDD.t195 VDD.t453 1619.57
R91 VDD.t51 VDD.t629 1619.57
R92 VDD.t423 VDD.t379 1619.57
R93 VDD.t449 VDD.t299 1619.57
R94 VDD.t315 VDD.t74 1619.57
R95 VDD.t662 VDD.t262 1619.57
R96 VDD.t55 VDD.t26 1619.57
R97 VDD.t433 VDD.t64 1619.57
R98 VDD.t419 VDD.t562 1619.57
R99 VDD.t49 VDD.t290 1619.57
R100 VDD.t552 VDD.t129 1619.57
R101 VDD.t199 VDD.t510 1619.57
R102 VDD.t369 VDD.t488 1619.57
R103 VDD.t486 VDD.t268 1619.57
R104 VDD.t645 VDD.t409 1619.57
R105 VDD.t490 VDD.t383 1619.57
R106 VDD.t429 VDD.t421 1619.57
R107 VDD.t570 VDD.t72 1619.57
R108 VDD.t101 VDD.t494 1619.57
R109 VDD.t654 VDD.t70 1619.57
R110 VDD.t351 VDD.t357 1619.57
R111 VDD.t32 VDD.t392 1619.57
R112 VDD.t560 VDD.t311 1619.57
R113 VDD.t568 VDD.t105 1619.57
R114 VDD.t649 VDD.t666 1619.57
R115 VDD.t347 VDD.t612 1619.57
R116 VDD.t498 VDD.t664 1619.57
R117 VDD.t353 VDD.t610 1619.57
R118 VDD.t709 VDD.t652 1619.57
R119 VDD.t711 VDD.t661 1619.57
R120 VDD.t712 VDD.t63 1619.57
R121 VDD.t710 VDD.t660 1619.57
R122 VDD.t708 VDD.t651 1619.57
R123 VDD.t127 VDD.t681 1616.85
R124 VDD.t479 VDD.t626 1616.85
R125 VDD.t680 VDD.t601 1616.85
R126 VDD.t556 VDD.t678 1616.85
R127 VDD.t4 VDD.t512 1616.84
R128 VDD.t437 VDD.n3575 1172.1
R129 VDD.t698 VDD.n3405 1172.1
R130 VDD.n3200 VDD.t716 1172.1
R131 VDD.n3809 VDD.t683 1172.1
R132 VDD.n3841 VDD.t375 1172.1
R133 VDD.n3145 VDD.t30 1172.1
R134 VDD.t457 VDD.n3106 1172.1
R135 VDD.t475 VDD.n2897 1172.1
R136 VDD.n3942 VDD.t319 1172.1
R137 VDD.n455 VDD.t221 1172.1
R138 VDD.t566 VDD.n425 1172.1
R139 VDD.n403 VDD.t539 1172.1
R140 VDD.n364 VDD.t367 1172.1
R141 VDD.t411 VDD.n342 1172.1
R142 VDD.t427 VDD.n322 1172.1
R143 VDD.n297 VDD.t103 1172.1
R144 VDD.n248 VDD.t349 1172.1
R145 VDD.n1020 VDD.n1016 1010.87
R146 VDD.n1023 VDD.n1022 1010.87
R147 VDD.n1069 VDD.n1063 1010.87
R148 VDD.n1068 VDD.n1064 1010.87
R149 VDD.n1079 VDD.n1073 1010.87
R150 VDD.n1078 VDD.n1074 1010.87
R151 VDD.n3978 VDD.n3974 1010.87
R152 VDD.n3981 VDD.n3980 1010.87
R153 VDD.n2303 VDD.n2302 1010.87
R154 VDD.n2300 VDD.n1973 1010.87
R155 VDD.n3890 VDD.n500 1010.87
R156 VDD.n533 VDD.n532 1010.87
R157 VDD.n3855 VDD.n528 1010.87
R158 VDD.n3857 VDD.n3856 1010.87
R159 VDD.n2918 VDD.n2917 1010.87
R160 VDD.n2674 VDD.n2673 1010.87
R161 VDD.n2672 VDD.n2653 1010.87
R162 VDD.n3892 VDD.n3891 1010.87
R163 VDD.n285 VDD.n284 1010.87
R164 VDD.n281 VDD.n280 1010.87
R165 VDD.n371 VDD.n202 1010.87
R166 VDD.n390 VDD.n200 1010.87
R167 VDD.n388 VDD.n387 1010.87
R168 VDD.n462 VDD.n183 1010.87
R169 VDD.n471 VDD.n470 1010.87
R170 VDD.n3920 VDD.n477 1010.87
R171 VDD.n3917 VDD.n481 1010.87
R172 VDD.n3159 VDD.n3088 1010.87
R173 VDD.n3169 VDD.n3168 1010.87
R174 VDD.n3178 VDD.n3177 1010.87
R175 VDD.n3207 VDD.n3077 1010.87
R176 VDD.n3646 VDD.n3213 1010.87
R177 VDD.n3643 VDD.n3217 1010.87
R178 VDD.n3561 VDD.n3555 1010.87
R179 VDD.n3604 VDD.n3592 1010.87
R180 VDD.n3397 VDD.n3221 1010.87
R181 VDD.n3652 VDD.n3070 1010.87
R182 VDD.n3186 VDD.n3080 1010.87
R183 VDD.n3816 VDD.n3815 1010.87
R184 VDD.n3842 VDD.n603 1010.87
R185 VDD.n3115 VDD.n3091 1010.87
R186 VDD.n2881 VDD.n485 1010.87
R187 VDD.n3926 VDD.n175 1010.87
R188 VDD.n3949 VDD.n3948 1010.87
R189 VDD.n434 VDD.n186 1010.87
R190 VDD.n419 VDD.n418 1010.87
R191 VDD.n402 VDD.n197 1010.87
R192 VDD.n350 VDD.n205 1010.87
R193 VDD.n333 VDD.n332 1010.87
R194 VDD.n313 VDD.n312 1010.87
R195 VDD.n296 VDD.n219 1010.87
R196 VDD.n289 VDD.n288 1010.87
R197 VDD.n255 VDD.n224 1010.87
R198 VDD.n234 VDD.n227 1010.87
R199 VDD.n31 VDD.n27 1010.87
R200 VDD.n34 VDD.n33 1010.87
R201 VDD.n41 VDD.n37 1010.87
R202 VDD.n44 VDD.n43 1010.87
R203 VDD.n3603 VDD.t516 838.769
R204 VDD.n3562 VDD.t713 718.361
R205 VDD.t664 VDD.n233 718.361
R206 VDD.n229 VDD.t649 718.36
R207 VDD.n286 VDD.t18 718.188
R208 VDD.n282 VDD.t624 718.188
R209 VDD.n278 VDD.t36 718.188
R210 VDD.n373 VDD.t445 718.188
R211 VDD.n389 VDD.t706 718.188
R212 VDD.n385 VDD.t407 718.188
R213 VDD.t658 VDD.n469 718.188
R214 VDD.t313 VDD.n476 718.188
R215 VDD.n3918 VDD.t638 718.188
R216 VDD.n3095 VDD.t492 718.188
R217 VDD.n3161 VDD.t246 718.188
R218 VDD.t272 VDD.n3176 718.188
R219 VDD.n3180 VDD.t675 718.188
R220 VDD.t282 VDD.n3212 718.188
R221 VDD.n3644 VDD.t204 718.188
R222 VDD.n3558 VDD.t441 718.188
R223 VDD.t311 VDD.n259 718.188
R224 VDD.t425 VDD.n283 718.188
R225 VDD.t413 VDD.n279 718.188
R226 VDD.n372 VDD.t365 718.188
R227 VDD.n391 VDD.t550 718.188
R228 VDD.t564 VDD.n386 718.188
R229 VDD.n463 VDD.t181 718.188
R230 VDD.n472 VDD.t317 718.188
R231 VDD.t473 VDD.n3919 718.188
R232 VDD.n3094 VDD.t455 718.188
R233 VDD.n3160 VDD.t6 718.188
R234 VDD.n3170 VDD.t377 718.188
R235 VDD.n3179 VDD.t533 718.188
R236 VDD.n3208 VDD.t720 718.188
R237 VDD.t227 VDD.n3645 718.188
R238 VDD.n3557 VDD.t435 718.188
R239 VDD.t105 VDD.n287 718.188
R240 VDD.n256 VDD.t347 718.188
R241 VDD.t153 VDD.n3962 713.689
R242 VDD.t642 VDD.n154 713.689
R243 VDD.t640 VDD.n150 713.689
R244 VDD.t481 VDD.n1056 713.688
R245 VDD.t674 VDD.n1053 713.688
R246 VDD.t682 VDD.n1048 713.688
R247 VDD.t478 VDD.n1045 713.688
R248 VDD.t677 VDD.n1040 713.688
R249 VDD.t679 VDD.n1037 713.688
R250 VDD.t480 VDD.n1034 713.688
R251 VDD.n1964 VDD.t169 713.688
R252 VDD.n2923 VDD.t152 713.688
R253 VDD.t154 VDD.n2640 713.688
R254 VDD.n1057 VDD.t207 713.688
R255 VDD.n1054 VDD.t126 713.688
R256 VDD.n1049 VDD.t557 713.688
R257 VDD.n1046 VDD.t203 713.688
R258 VDD.n1041 VDD.t128 713.688
R259 VDD.n1038 VDD.t602 713.688
R260 VDD.n1035 VDD.t206 713.688
R261 VDD.t35 VDD.n1963 713.688
R262 VDD.t249 VDD.n2922 713.688
R263 VDD.n2641 VDD.t248 713.688
R264 VDD.n3963 VDD.t40 713.688
R265 VDD.n155 VDD.t234 713.688
R266 VDD.n151 VDD.t235 713.688
R267 VDD.t652 VDD.n21 713.688
R268 VDD.n22 VDD.t709 713.688
R269 VDD.t661 VDD.n23 713.688
R270 VDD.n24 VDD.t711 713.688
R271 VDD.t651 VDD.n4179 713.688
R272 VDD.n4180 VDD.t708 713.688
R273 VDD.n1016 VDD.t537 701.087
R274 VDD.t681 VDD.n1020 701.087
R275 VDD.n1023 VDD.t127 701.087
R276 VDD.n1022 VDD.t225 701.087
R277 VDD.n1063 VDD.t685 701.087
R278 VDD.n1069 VDD.t479 701.087
R279 VDD.t626 VDD.n1068 701.087
R280 VDD.n1064 VDD.t700 701.087
R281 VDD.n1073 VDD.t535 701.087
R282 VDD.n1079 VDD.t680 701.087
R283 VDD.t601 VDD.n1078 701.087
R284 VDD.n1074 VDD.t696 701.087
R285 VDD.n3974 VDD.t541 701.087
R286 VDD.t678 VDD.n3978 701.087
R287 VDD.n3980 VDD.t556 701.087
R288 VDD.n3981 VDD.t223 701.087
R289 VDD.n2303 VDD.t107 701.087
R290 VDD.n2302 VDD.t168 701.087
R291 VDD.t34 VDD.n2300 701.087
R292 VDD.n1973 VDD.t415 701.087
R293 VDD.t512 VDD.n3890 701.087
R294 VDD.t114 VDD.n500 701.087
R295 VDD.n532 VDD.t245 701.087
R296 VDD.n533 VDD.t120 701.087
R297 VDD.t459 VDD.n528 701.087
R298 VDD.t641 VDD.n3855 701.087
R299 VDD.n3857 VDD.t41 701.087
R300 VDD.n3856 VDD.t28 701.087
R301 VDD.n2918 VDD.t529 701.087
R302 VDD.n2917 VDD.t637 701.087
R303 VDD.n2674 VDD.t236 701.087
R304 VDD.n2673 VDD.t0 701.087
R305 VDD.t38 VDD.n2672 701.087
R306 VDD.n2653 VDD.t113 701.087
R307 VDD.n3892 VDD.t42 701.087
R308 VDD.n3891 VDD.t4 701.087
R309 VDD.t76 VDD.n285 701.087
R310 VDD.n284 VDD.t656 701.087
R311 VDD.t451 VDD.n281 701.087
R312 VDD.n280 VDD.t266 701.087
R313 VDD.t643 VDD.n202 701.087
R314 VDD.t385 VDD.n371 701.087
R315 VDD.t496 VDD.n200 701.087
R316 VDD.t633 VDD.n390 701.087
R317 VDD.t146 VDD.n388 701.087
R318 VDD.n387 VDD.t201 701.087
R319 VDD.t8 VDD.n183 701.087
R320 VDD.t635 VDD.n462 701.087
R321 VDD.n470 VDD.t403 701.087
R322 VDD.t66 VDD.n471 701.087
R323 VDD.n477 VDD.t68 701.087
R324 VDD.n3920 VDD.t627 701.087
R325 VDD.t405 VDD.n3917 701.087
R326 VDD.t297 VDD.n481 701.087
R327 VDD.t359 VDD.n3088 701.087
R328 VDD.t390 VDD.n3159 701.087
R329 VDD.n3168 VDD.t305 701.087
R330 VDD.t303 VDD.n3169 701.087
R331 VDD.n3177 VDD.t197 701.087
R332 VDD.t284 VDD.n3178 701.087
R333 VDD.t12 VDD.n3077 701.087
R334 VDD.t399 VDD.n3207 701.087
R335 VDD.n3213 VDD.t115 701.087
R336 VDD.n3646 VDD.t288 701.087
R337 VDD.t668 VDD.n3643 701.087
R338 VDD.t140 VDD.n3217 701.087
R339 VDD.t371 VDD.n3555 701.087
R340 VDD.t572 VDD.n3561 701.087
R341 VDD.n3592 VDD.t355 701.087
R342 VDD.n3604 VDD.t396 701.087
R343 VDD.t163 VDD.n3603 701.087
R344 VDD.t144 VDD.n3397 701.087
R345 VDD.t142 VDD.n3221 701.087
R346 VDD.n3575 VDD.t620 701.087
R347 VDD.t443 VDD.n3652 701.087
R348 VDD.t578 VDD.n3070 701.087
R349 VDD.n3405 VDD.t10 701.087
R350 VDD.n3186 VDD.t417 701.087
R351 VDD.t401 VDD.n3080 701.087
R352 VDD.n3200 VDD.t124 701.087
R353 VDD.n3816 VDD.t270 701.087
R354 VDD.n3815 VDD.t576 701.087
R355 VDD.n3809 VDD.t558 701.087
R356 VDD.t431 VDD.n603 701.087
R357 VDD.n3842 VDD.t301 701.087
R358 VDD.t53 VDD.n3841 701.087
R359 VDD.n3115 VDD.t195 701.087
R360 VDD.t629 VDD.n3091 701.087
R361 VDD.n3145 VDD.t51 701.087
R362 VDD.t379 VDD.n2881 701.087
R363 VDD.t299 VDD.n485 701.087
R364 VDD.n3106 VDD.t449 701.087
R365 VDD.t74 VDD.n3926 701.087
R366 VDD.t262 VDD.n175 701.087
R367 VDD.n2897 VDD.t662 701.087
R368 VDD.n3949 VDD.t26 701.087
R369 VDD.n3948 VDD.t64 701.087
R370 VDD.n3942 VDD.t433 701.087
R371 VDD.n434 VDD.t419 701.087
R372 VDD.t290 VDD.n186 701.087
R373 VDD.n455 VDD.t49 701.087
R374 VDD.n418 VDD.t129 701.087
R375 VDD.n419 VDD.t199 701.087
R376 VDD.n425 VDD.t510 701.087
R377 VDD.t488 VDD.n197 701.087
R378 VDD.t268 VDD.n402 701.087
R379 VDD.n403 VDD.t486 701.087
R380 VDD.n350 VDD.t645 701.087
R381 VDD.t383 VDD.n205 701.087
R382 VDD.n364 VDD.t490 701.087
R383 VDD.n332 VDD.t421 701.087
R384 VDD.n333 VDD.t570 701.087
R385 VDD.n342 VDD.t72 701.087
R386 VDD.n312 VDD.t494 701.087
R387 VDD.n313 VDD.t654 701.087
R388 VDD.n322 VDD.t70 701.087
R389 VDD.t357 VDD.n219 701.087
R390 VDD.t392 VDD.n296 701.087
R391 VDD.n297 VDD.t32 701.087
R392 VDD.n289 VDD.t560 701.087
R393 VDD.n288 VDD.t568 701.087
R394 VDD.t666 VDD.n224 701.087
R395 VDD.t612 VDD.n255 701.087
R396 VDD.n234 VDD.t498 701.087
R397 VDD.t610 VDD.n227 701.087
R398 VDD.n248 VDD.t353 701.087
R399 VDD.n27 VDD.t47 701.087
R400 VDD.t63 VDD.n31 701.087
R401 VDD.n34 VDD.t712 701.087
R402 VDD.n33 VDD.t548 701.087
R403 VDD.n37 VDD.t484 701.087
R404 VDD.t660 VDD.n41 701.087
R405 VDD.n44 VDD.t710 701.087
R406 VDD.n43 VDD.t554 701.087
R407 VDD.n3579 VDD.t439 515.22
R408 VDD.n3653 VDD.t718 515.22
R409 VDD.t373 VDD.n606 515.22
R410 VDD.t453 VDD.n3114 515.22
R411 VDD.n3927 VDD.t315 515.22
R412 VDD.t562 VDD.n433 515.22
R413 VDD.n357 VDD.t369 515.22
R414 VDD.n326 VDD.t429 515.22
R415 VDD.n240 VDD.t351 515.22
R416 VDD.n3406 VDD.t698 483.17
R417 VDD.t683 VDD.n3808 483.17
R418 VDD.t30 VDD.n3144 483.17
R419 VDD.n2898 VDD.t475 483.17
R420 VDD.t221 VDD.n454 483.17
R421 VDD.t539 VDD.n195 483.17
R422 VDD.n343 VDD.t411 483.17
R423 VDD.t103 VDD.n217 483.17
R424 VDD.n3576 VDD.t437 470.943
R425 VDD.t716 VDD.n3199 470.943
R426 VDD.n3836 VDD.t375 470.943
R427 VDD.n3107 VDD.t457 470.943
R428 VDD.t319 VDD.n3941 470.943
R429 VDD.n426 VDD.t566 470.943
R430 VDD.t367 VDD.n363 470.943
R431 VDD.n323 VDD.t427 470.943
R432 VDD.t349 VDD.n247 470.943
R433 VDD.n3403 VDD.t694 466.091
R434 VDD.t531 VDD.n3185 466.091
R435 VDD.n3139 VDD.t2 466.091
R436 VDD.n2886 VDD.t423 466.091
R437 VDD.n449 VDD.t55 466.091
R438 VDD.n412 VDD.t552 466.091
R439 VDD.t409 VDD.n349 466.091
R440 VDD.n306 VDD.t101 466.091
R441 VDD.n3578 VDD.t388 311.219
R442 VDD.n3654 VDD.t580 311.219
R443 VDD.t292 VDD.n3835 311.219
R444 VDD.t394 VDD.n3100 311.219
R445 VDD.n174 VDD.t631 311.219
R446 VDD.t264 VDD.n189 311.219
R447 VDD.n358 VDD.t294 311.219
R448 VDD.n325 VDD.t286 311.219
R449 VDD.t574 VDD.n246 311.219
R450 VDD.n3404 VDD.t515 296.894
R451 VDD.t514 VDD.n614 296.894
R452 VDD.t84 VDD.n3125 296.894
R453 VDD.n2887 VDD.t86 296.894
R454 VDD.t85 VDD.n438 296.894
R455 VDD.t87 VDD.n411 296.894
R456 VDD.n344 VDD.t88 296.894
R457 VDD.t83 VDD.n305 296.894
R458 VDD.n3598 VDD.t516 290.541
R459 VDD.t388 VDD.n3576 236.798
R460 VDD.n3199 VDD.t580 236.798
R461 VDD.n3836 VDD.t292 236.798
R462 VDD.n3107 VDD.t394 236.798
R463 VDD.n3941 VDD.t631 236.798
R464 VDD.n426 VDD.t264 236.798
R465 VDD.n363 VDD.t294 236.798
R466 VDD.t286 VDD.n323 236.798
R467 VDD.n247 VDD.t574 236.798
R468 VDD.t515 VDD.n3403 170.311
R469 VDD.n3185 VDD.t514 170.311
R470 VDD.n3139 VDD.t84 170.311
R471 VDD.t86 VDD.n2886 170.311
R472 VDD.n449 VDD.t85 170.311
R473 VDD.n412 VDD.t87 170.311
R474 VDD.n349 VDD.t88 170.311
R475 VDD.n306 VDD.t83 170.311
R476 VDD.n3406 VDD.n3404 114.959
R477 VDD.n3808 VDD.n614 114.959
R478 VDD.n3144 VDD.n3125 114.959
R479 VDD.n2898 VDD.n2887 114.959
R480 VDD.n454 VDD.n438 114.959
R481 VDD.n411 VDD.n195 114.959
R482 VDD.n344 VDD.n343 114.959
R483 VDD.n305 VDD.n217 114.959
R484 VDD.n1010 VDD.t605 76.2963
R485 VDD.n951 VDD.t527 76.2963
R486 VDD.n3579 VDD.n3578 73.5831
R487 VDD.n3654 VDD.n3653 73.5831
R488 VDD.n3835 VDD.n606 73.5831
R489 VDD.n3114 VDD.n3100 73.5831
R490 VDD.n3927 VDD.n174 73.5831
R491 VDD.n433 VDD.n189 73.5831
R492 VDD.n358 VDD.n357 73.5831
R493 VDD.n326 VDD.n325 73.5831
R494 VDD.n246 VDD.n240 73.5831
R495 VDD.n1011 VDD.t599 71.8733
R496 VDD.n952 VDD.t187 71.8733
R497 VDD.n1009 VDD.t323 45.6121
R498 VDD.t599 VDD.n1010 45.6121
R499 VDD.n950 VDD.t231 45.6121
R500 VDD.t187 VDD.n951 45.6121
R501 VDD.t323 VDD.t336 42.0185
R502 VDD.t231 VDD.t93 42.0185
R503 VDD.t21 VDD.n900 40.5105
R504 VDD.t648 VDD.n870 40.5105
R505 VDD.n897 VDD.n894 38.1703
R506 VDD.n866 VDD.n861 38.1703
R507 VDD.n1007 VDD.t593 38.1431
R508 VDD.n1006 VDD.t603 38.1431
R509 VDD.n948 VDD.t193 38.1431
R510 VDD.n947 VDD.t518 38.1431
R511 VDD.t482 VDD.n2658 35.1644
R512 VDD.n898 VDD.t20 27.0072
R513 VDD.n867 VDD.t647 27.0072
R514 VDD.t465 VDD.n2105 26.0875
R515 VDD.n2294 VDD.t274 26.0875
R516 VDD.n897 VDD.n896 25.5008
R517 VDD.n866 VDD.n865 25.5008
R518 VDD.n4170 VDD.t170 24.4263
R519 VDD.t253 VDD.n4169 24.4263
R520 VDD.n4174 VDD.t307 24.4263
R521 VDD.t309 VDD.n4173 24.4263
R522 VDD.n2659 VDD.t482 24.4109
R523 VDD.n903 VDD.t165 24.1238
R524 VDD.n1025 VDD 23.6696
R525 VDD.n1030 VDD.n1004 23.5207
R526 VDD.n960 VDD.n945 23.5207
R527 VDD.n1007 VDD.t325 22.8032
R528 VDD.t593 VDD.n1006 22.8032
R529 VDD.n948 VDD.t81 22.8032
R530 VDD.t193 VDD.n947 22.8032
R531 VDD.t647 VDD.n858 22.611
R532 VDD.n901 VDD.t21 22.6015
R533 VDD.n894 VDD.t209 22.5957
R534 VDD.n900 VDD.t363 22.5957
R535 VDD.n861 VDD.t149 22.5957
R536 VDD.n870 VDD.t362 22.5957
R537 VDD.n871 VDD.t648 22.5957
R538 VDD.n593 VDD.n592 22.169
R539 VDD.t325 VDD.t342 21.0066
R540 VDD.t81 VDD.t60 21.0066
R541 VDD.n2658 VDD.t381 19.6138
R542 VDD.n880 VDD.t117 18.7069
R543 VDD.n887 VDD.t133 18.5957
R544 VDD.n881 VDD.t131 18.5881
R545 VDD.n2669 VDD.n2668 18.5146
R546 VDD.n2656 VDD.t382 17.6917
R547 VDD.n3891 VDD.n499 17.1029
R548 VDD.n2673 VDD.n2650 17.1029
R549 VDD.n1022 VDD.n1021 17.1017
R550 VDD.n1017 VDD.n1016 17.1017
R551 VDD.n1065 VDD.n1064 17.1017
R552 VDD.n1063 VDD.n1062 17.1017
R553 VDD.n1075 VDD.n1074 17.1017
R554 VDD.n1073 VDD.n1072 17.1017
R555 VDD.n3982 VDD.n3981 17.1017
R556 VDD.n3975 VDD.n3974 17.1017
R557 VDD.n1975 VDD.n1973 17.1017
R558 VDD.n2672 VDD.n2671 17.1017
R559 VDD.n3856 VDD.n527 17.1017
R560 VDD.n595 VDD.n528 17.1017
R561 VDD.n534 VDD.n533 17.1017
R562 VDD.n3890 VDD.n3889 17.1017
R563 VDD.n2919 VDD.n2918 17.1017
R564 VDD.n28 VDD.n27 17.1017
R565 VDD.n38 VDD.n37 17.1017
R566 VDD.n2304 VDD.n2303 17.1005
R567 VDD.n249 VDD.n248 17.1005
R568 VDD.n243 VDD.n240 17.1005
R569 VDD.n298 VDD.n297 17.1005
R570 VDD.n307 VDD.n306 17.1005
R571 VDD.n322 VDD.n321 17.1005
R572 VDD.n327 VDD.n326 17.1005
R573 VDD.n342 VDD.n341 17.1005
R574 VDD.n349 VDD.n348 17.1005
R575 VDD.n365 VDD.n364 17.1005
R576 VDD.n357 VDD.n356 17.1005
R577 VDD.n404 VDD.n403 17.1005
R578 VDD.n413 VDD.n412 17.1005
R579 VDD.n425 VDD.n424 17.1005
R580 VDD.n433 VDD.n432 17.1005
R581 VDD.n456 VDD.n455 17.1005
R582 VDD.n450 VDD.n449 17.1005
R583 VDD.n3943 VDD.n3942 17.1005
R584 VDD.n3928 VDD.n3927 17.1005
R585 VDD.n2897 VDD.n2896 17.1005
R586 VDD.n2886 VDD.n2885 17.1005
R587 VDD.n3106 VDD.n3105 17.1005
R588 VDD.n3114 VDD.n3113 17.1005
R589 VDD.n3146 VDD.n3145 17.1005
R590 VDD.n3140 VDD.n3139 17.1005
R591 VDD.n3841 VDD.n3840 17.1005
R592 VDD.n3832 VDD.n606 17.1005
R593 VDD.n3810 VDD.n3809 17.1005
R594 VDD.n3185 VDD.n618 17.1005
R595 VDD.n3201 VDD.n3200 17.1005
R596 VDD.n3653 VDD.n3069 17.1005
R597 VDD.n3405 VDD.n3394 17.1005
R598 VDD.n3403 VDD.n3402 17.1005
R599 VDD.n3575 VDD.n3574 17.1005
R600 VDD.n3580 VDD.n3579 17.1005
R601 VDD.n3603 VDD.n3602 17.1005
R602 VDD.n33 VDD.n32 17.1005
R603 VDD.n43 VDD.n42 17.1005
R604 VDD.n1021 VDD.t226 16.7003
R605 VDD.n1065 VDD.t701 16.7003
R606 VDD.n1075 VDD.t697 16.7003
R607 VDD.n1975 VDD.t416 16.7003
R608 VDD.n28 VDD.t48 16.7003
R609 VDD.n38 VDD.t485 16.7003
R610 VDD.n527 VDD.t29 16.6992
R611 VDD.n32 VDD.t549 16.6992
R612 VDD.n42 VDD.t555 16.6992
R613 VDD.n1017 VDD.t538 16.698
R614 VDD.n1062 VDD.t686 16.698
R615 VDD.n1072 VDD.t536 16.698
R616 VDD.n3975 VDD.t542 16.698
R617 VDD.n2305 VDD.t108 16.5286
R618 VDD.n594 VDD.t460 16.5286
R619 VDD.n502 VDD.t513 16.5286
R620 VDD.n501 VDD.t5 16.5286
R621 VDD.n2654 VDD.t1 16.5286
R622 VDD.n3553 VDD.t397 16.5286
R623 VDD.n3582 VDD.t356 16.5286
R624 VDD.n3636 VDD.t143 16.5286
R625 VDD.n3400 VDD.t145 16.5286
R626 VDD.n3074 VDD.t579 16.5286
R627 VDD.n3073 VDD.t444 16.5286
R628 VDD.n3203 VDD.t402 16.5286
R629 VDD.n3083 VDD.t418 16.5286
R630 VDD.n3812 VDD.t577 16.5286
R631 VDD.n3819 VDD.t271 16.5286
R632 VDD.n601 VDD.t302 16.5286
R633 VDD.n3129 VDD.t432 16.5286
R634 VDD.n3118 VDD.t630 16.5286
R635 VDD.n3092 VDD.t196 16.5286
R636 VDD.n3910 VDD.t300 16.5286
R637 VDD.n2883 VDD.t380 16.5286
R638 VDD.n179 VDD.t263 16.5286
R639 VDD.n178 VDD.t75 16.5286
R640 VDD.n3945 VDD.t65 16.5286
R641 VDD.n3952 VDD.t27 16.5286
R642 VDD.n458 VDD.t291 16.5286
R643 VDD.n187 VDD.t420 16.5286
R644 VDD.n422 VDD.t200 16.5286
R645 VDD.n415 VDD.t130 16.5286
R646 VDD.n399 VDD.t269 16.5286
R647 VDD.n199 VDD.t489 16.5286
R648 VDD.n367 VDD.t384 16.5286
R649 VDD.n206 VDD.t646 16.5286
R650 VDD.n336 VDD.t571 16.5286
R651 VDD.n329 VDD.t422 16.5286
R652 VDD.n316 VDD.t655 16.5286
R653 VDD.n309 VDD.t495 16.5286
R654 VDD.n293 VDD.t393 16.5286
R655 VDD.n221 VDD.t358 16.5286
R656 VDD.n251 VDD.t611 16.5286
R657 VDD.n228 VDD.t499 16.5286
R658 VDD.n3563 VDD.t573 16.5286
R659 VDD.n3559 VDD.t442 16.5286
R660 VDD.n3220 VDD.t141 16.5286
R661 VDD.n3216 VDD.t205 16.5286
R662 VDD.n3214 VDD.t289 16.5286
R663 VDD.n3211 VDD.t283 16.5286
R664 VDD.n3078 VDD.t400 16.5286
R665 VDD.n3181 VDD.t676 16.5286
R666 VDD.n3171 VDD.t285 16.5286
R667 VDD.n3175 VDD.t273 16.5286
R668 VDD.n3164 VDD.t304 16.5286
R669 VDD.n3162 VDD.t247 16.5286
R670 VDD.n3089 VDD.t391 16.5286
R671 VDD.n3096 VDD.t493 16.5286
R672 VDD.n484 VDD.t298 16.5286
R673 VDD.n480 VDD.t639 16.5286
R674 VDD.n478 VDD.t628 16.5286
R675 VDD.n475 VDD.t314 16.5286
R676 VDD.n464 VDD.t67 16.5286
R677 VDD.n468 VDD.t659 16.5286
R678 VDD.n184 VDD.t636 16.5286
R679 VDD.n384 VDD.t408 16.5286
R680 VDD.n380 VDD.t202 16.5286
R681 VDD.n376 VDD.t707 16.5286
R682 VDD.n393 VDD.t634 16.5286
R683 VDD.n374 VDD.t446 16.5286
R684 VDD.n203 VDD.t386 16.5286
R685 VDD.n277 VDD.t37 16.5286
R686 VDD.n273 VDD.t267 16.5286
R687 VDD.n269 VDD.t625 16.5286
R688 VDD.n267 VDD.t657 16.5286
R689 VDD.n263 VDD.t19 16.5286
R690 VDD.n261 VDD.t569 16.5286
R691 VDD.n258 VDD.t312 16.5286
R692 VDD.n225 VDD.t613 16.5286
R693 VDD.n229 VDD.t650 16.5286
R694 VDD.n3983 VDD.t224 16.5274
R695 VDD.n535 VDD.t121 16.5274
R696 VDD.n2670 VDD.t39 16.5274
R697 VDD.n2920 VDD.t530 16.5274
R698 VDD.n3593 VDD.t164 16.5263
R699 VDD.n3581 VDD.t440 16.5263
R700 VDD.n3570 VDD.t621 16.5263
R701 VDD.n3401 VDD.t695 16.5263
R702 VDD.n3386 VDD.t11 16.5263
R703 VDD.n3072 VDD.t719 16.5263
R704 VDD.n3202 VDD.t125 16.5263
R705 VDD.n3081 VDD.t532 16.5263
R706 VDD.n3811 VDD.t559 16.5263
R707 VDD.n3831 VDD.t374 16.5263
R708 VDD.n604 VDD.t54 16.5263
R709 VDD.n3138 VDD.t3 16.5263
R710 VDD.n3147 VDD.t52 16.5263
R711 VDD.n3112 VDD.t454 16.5263
R712 VDD.n3103 VDD.t450 16.5263
R713 VDD.n2884 VDD.t424 16.5263
R714 VDD.n2888 VDD.t663 16.5263
R715 VDD.n177 VDD.t316 16.5263
R716 VDD.n3944 VDD.t434 16.5263
R717 VDD.n448 VDD.t56 16.5263
R718 VDD.n457 VDD.t50 16.5263
R719 VDD.n431 VDD.t563 16.5263
R720 VDD.n423 VDD.t511 16.5263
R721 VDD.n414 VDD.t553 16.5263
R722 VDD.n196 VDD.t487 16.5263
R723 VDD.n355 VDD.t370 16.5263
R724 VDD.n366 VDD.t491 16.5263
R725 VDD.n347 VDD.t410 16.5263
R726 VDD.n337 VDD.t73 16.5263
R727 VDD.n328 VDD.t430 16.5263
R728 VDD.n317 VDD.t71 16.5263
R729 VDD.n308 VDD.t102 16.5263
R730 VDD.n218 VDD.t33 16.5263
R731 VDD.n242 VDD.t352 16.5263
R732 VDD.n250 VDD.t354 16.5263
R733 VDD.n233 VDD.t665 16.5263
R734 VDD.n3562 VDD.t714 16.5263
R735 VDD.n3560 VDD.t372 16.5263
R736 VDD.n3556 VDD.t436 16.5263
R737 VDD.n3219 VDD.t669 16.5263
R738 VDD.n3215 VDD.t228 16.5263
R739 VDD.n3210 VDD.t116 16.5263
R740 VDD.n3076 VDD.t721 16.5263
R741 VDD.n3182 VDD.t13 16.5263
R742 VDD.n3084 VDD.t534 16.5263
R743 VDD.n3174 VDD.t198 16.5263
R744 VDD.n3085 VDD.t378 16.5263
R745 VDD.n3163 VDD.t306 16.5263
R746 VDD.n3087 VDD.t7 16.5263
R747 VDD.n3097 VDD.t360 16.5263
R748 VDD.n3093 VDD.t456 16.5263
R749 VDD.n483 VDD.t406 16.5263
R750 VDD.n479 VDD.t474 16.5263
R751 VDD.n474 VDD.t69 16.5263
R752 VDD.n181 VDD.t318 16.5263
R753 VDD.n467 VDD.t404 16.5263
R754 VDD.n182 VDD.t182 16.5263
R755 VDD.n383 VDD.t9 16.5263
R756 VDD.n381 VDD.t565 16.5263
R757 VDD.n377 VDD.t147 16.5263
R758 VDD.n392 VDD.t551 16.5263
R759 VDD.n375 VDD.t497 16.5263
R760 VDD.n201 VDD.t366 16.5263
R761 VDD.n276 VDD.t644 16.5263
R762 VDD.n274 VDD.t414 16.5263
R763 VDD.n270 VDD.t452 16.5263
R764 VDD.n268 VDD.t426 16.5263
R765 VDD.n264 VDD.t77 16.5263
R766 VDD.n262 VDD.t106 16.5263
R767 VDD.n257 VDD.t561 16.5263
R768 VDD.n223 VDD.t348 16.5263
R769 VDD.n230 VDD.t667 16.5263
R770 VDD.t209 VDD.t123 16.4627
R771 VDD.t149 VDD.t148 16.4627
R772 VDD.n4172 VDD.t170 16.0939
R773 VDD.n4176 VDD.t307 16.0939
R774 VDD.n3576 VDD.n3568 15.6676
R775 VDD.n3199 VDD.n3198 15.6676
R776 VDD.n3837 VDD.n3836 15.6676
R777 VDD.n3108 VDD.n3107 15.6676
R778 VDD.n3941 VDD.n3940 15.6676
R779 VDD.n427 VDD.n426 15.6676
R780 VDD.n363 VDD.n362 15.6676
R781 VDD.n323 VDD.n213 15.6676
R782 VDD.n247 VDD.n239 15.6676
R783 VDD.n2106 VDD.t461 15.596
R784 VDD.n2105 VDD.t274 15.596
R785 VDD.n2294 VDD.t256 15.596
R786 VDD.n3407 VDD.n3406 15.511
R787 VDD.n3808 VDD.n3807 15.511
R788 VDD.n3144 VDD.n3143 15.511
R789 VDD.n2899 VDD.n2898 15.511
R790 VDD.n454 VDD.n453 15.511
R791 VDD.n409 VDD.n195 15.511
R792 VDD.n343 VDD.n209 15.511
R793 VDD.n303 VDD.n217 15.511
R794 VDD.n4177 VDD.n4176 15.4739
R795 VDD.n14 VDD.n13 15.1566
R796 VDD.t20 VDD.n893 15.1476
R797 VDD.n896 VDD.t208 15.064
R798 VDD.n898 VDD.t361 15.064
R799 VDD.n865 VDD.t151 15.064
R800 VDD.n867 VDD.t364 15.064
R801 VDD.n4177 VDD.n4172 15.0341
R802 VDD.n14 VDD.n6 14.7072
R803 VDD.t461 VDD.t465 14.3672
R804 VDD.n893 VDD.n892 14.2216
R805 VDD.n4170 VDD.t253 13.6245
R806 VDD.n4169 VDD.t210 13.6245
R807 VDD.n4174 VDD.t309 13.6245
R808 VDD.n4173 VDD.t16 13.6245
R809 VDD.n2660 VDD.n2659 13.4312
R810 VDD VDD.t95 13.3485
R811 VDD.n1044 VDD.n1036 13.3484
R812 VDD.n2658 VDD.n2657 13.1913
R813 VDD.n325 VDD 12.7012
R814 VDD VDD.n358 12.7012
R815 VDD VDD.n189 12.7012
R816 VDD.n174 VDD 12.7012
R817 VDD VDD.n3100 12.7012
R818 VDD.n3835 VDD 12.7012
R819 VDD VDD.n3654 12.7012
R820 VDD.n3578 VDD 12.7012
R821 VDD.n246 VDD 12.7012
R822 VDD.n3599 VDD.n3598 12.6108
R823 VDD.n3855 VDD.n3854 12.6029
R824 VDD.n3887 VDD.n500 12.6029
R825 VDD.n305 VDD 12.6029
R826 VDD VDD.n344 12.6029
R827 VDD.n411 VDD 12.6029
R828 VDD VDD.n438 12.6029
R829 VDD.n2887 VDD 12.6029
R830 VDD VDD.n3125 12.6029
R831 VDD VDD.n614 12.6029
R832 VDD.n3404 VDD 12.6029
R833 VDD.n1068 VDD.n1067 12.6017
R834 VDD.n1078 VDD.n1077 12.6017
R835 VDD.n3980 VDD.n3979 12.6017
R836 VDD.n2300 VDD.n2299 12.6017
R837 VDD.n2653 VDD.n2652 12.6017
R838 VDD.n2917 VDD.n2916 12.6017
R839 VDD.n296 VDD.n295 12.6017
R840 VDD.n314 VDD.n313 12.6017
R841 VDD.n312 VDD.n311 12.6017
R842 VDD.n334 VDD.n333 12.6017
R843 VDD.n332 VDD.n331 12.6017
R844 VDD.n369 VDD.n205 12.6017
R845 VDD.n351 VDD.n350 12.6017
R846 VDD.n402 VDD.n401 12.6017
R847 VDD.n397 VDD.n197 12.6017
R848 VDD.n420 VDD.n419 12.6017
R849 VDD.n418 VDD.n417 12.6017
R850 VDD.n460 VDD.n186 12.6017
R851 VDD.n435 VDD.n434 12.6017
R852 VDD.n3948 VDD.n3947 12.6017
R853 VDD.n3950 VDD.n3949 12.6017
R854 VDD.n3922 VDD.n175 12.6017
R855 VDD.n3926 VDD.n3925 12.6017
R856 VDD.n3912 VDD.n485 12.6017
R857 VDD.n2881 VDD.n482 12.6017
R858 VDD.n3157 VDD.n3091 12.6017
R859 VDD.n3116 VDD.n3115 12.6017
R860 VDD.n3843 VDD.n3842 12.6017
R861 VDD.n3086 VDD.n603 12.6017
R862 VDD.n3815 VDD.n3814 12.6017
R863 VDD.n3817 VDD.n3816 12.6017
R864 VDD.n3205 VDD.n3080 12.6017
R865 VDD.n3187 VDD.n3186 12.6017
R866 VDD.n3648 VDD.n3070 12.6017
R867 VDD.n3652 VDD.n3651 12.6017
R868 VDD.n3638 VDD.n3221 12.6017
R869 VDD.n3397 VDD.n3218 12.6017
R870 VDD.n3605 VDD.n3604 12.6017
R871 VDD.n3592 VDD.n3591 12.6017
R872 VDD.n291 VDD.n219 12.6017
R873 VDD.n253 VDD.n227 12.6017
R874 VDD.n235 VDD.n234 12.6017
R875 VDD.n31 VDD.n30 12.6017
R876 VDD.n41 VDD.n40 12.6017
R877 VDD.n1020 VDD.n1019 12.6005
R878 VDD.n1024 VDD.n1023 12.6005
R879 VDD.n1080 VDD.n1079 12.6005
R880 VDD.n1070 VDD.n1069 12.6005
R881 VDD.n3978 VDD.n3977 12.6005
R882 VDD.n2302 VDD.n2301 12.6005
R883 VDD.n532 VDD.n531 12.6005
R884 VDD.n3858 VDD.n3857 12.6005
R885 VDD.n2675 VDD.n2674 12.6005
R886 VDD.n3893 VDD.n3892 12.6005
R887 VDD.n284 VDD.n214 12.6005
R888 VDD.n285 VDD.n215 12.6005
R889 VDD.n280 VDD.n210 12.6005
R890 VDD.n281 VDD.n211 12.6005
R891 VDD.n371 VDD.n370 12.6005
R892 VDD.n207 VDD.n202 12.6005
R893 VDD.n390 VDD.n198 12.6005
R894 VDD.n396 VDD.n200 12.6005
R895 VDD.n387 VDD.n192 12.6005
R896 VDD.n388 VDD.n193 12.6005
R897 VDD.n462 VDD.n461 12.6005
R898 VDD.n188 VDD.n183 12.6005
R899 VDD.n471 VDD.n164 12.6005
R900 VDD.n470 VDD.n163 12.6005
R901 VDD.n3921 VDD.n3920 12.6005
R902 VDD.n477 VDD.n176 12.6005
R903 VDD.n3913 VDD.n481 12.6005
R904 VDD.n3917 VDD.n3916 12.6005
R905 VDD.n3159 VDD.n3158 12.6005
R906 VDD.n3099 VDD.n3088 12.6005
R907 VDD.n3169 VDD.n602 12.6005
R908 VDD.n3168 VDD.n3167 12.6005
R909 VDD.n3178 VDD.n612 12.6005
R910 VDD.n3177 VDD.n611 12.6005
R911 VDD.n3207 VDD.n3206 12.6005
R912 VDD.n3184 VDD.n3077 12.6005
R913 VDD.n3647 VDD.n3646 12.6005
R914 VDD.n3213 VDD.n3071 12.6005
R915 VDD.n3639 VDD.n3217 12.6005
R916 VDD.n3643 VDD.n3642 12.6005
R917 VDD.n3561 VDD.n3554 12.6005
R918 VDD.n3566 VDD.n3555 12.6005
R919 VDD.n3598 VDD.n3597 12.6005
R920 VDD.n290 VDD.n289 12.6005
R921 VDD.n288 VDD.n220 12.6005
R922 VDD.n255 VDD.n254 12.6005
R923 VDD.n232 VDD.n224 12.6005
R924 VDD.n45 VDD.n44 12.6005
R925 VDD.n35 VDD.n34 12.6005
R926 VDD.n0 VDD.t172 12.2773
R927 VDD.n1 VDD.t214 12.2773
R928 VDD.n2 VDD.t211 12.2773
R929 VDD.n4 VDD.t255 12.2773
R930 VDD.n7 VDD.t590 12.2773
R931 VDD.n8 VDD.t166 12.2773
R932 VDD.n9 VDD.t17 12.2773
R933 VDD.n11 VDD.t387 12.2773
R934 VDD.t208 VDD.t122 10.9753
R935 VDD.t151 VDD.t150 10.9753
R936 VDD.n1084 VDD.n1083 10.9203
R937 VDD.t607 VDD.n1028 10.8984
R938 VDD.t173 VDD.n958 10.8984
R939 VDD.t605 VDD.n1004 10.7298
R940 VDD.t527 VDD.n945 10.7298
R941 VDD.n2665 VDD.t139 10.3767
R942 VDD.t216 VDD.n2664 10.3767
R943 VDD.n2661 VDD.t622 10.3767
R944 VDD.t46 VDD.n2655 10.3767
R945 VDD.n1012 VDD.t185 10.2666
R946 VDD.n953 VDD.t183 10.2666
R947 VDD.n588 VDD.t239 10.1101
R948 VDD.t160 VDD.n587 10.1101
R949 VDD.t99 VDD.n536 10.1101
R950 VDD.n537 VDD.t155 10.1101
R951 VDD.n582 VDD.t672 9.93643
R952 VDD.n564 VDD.t44 9.93643
R953 VDD.n569 VDD.t161 9.93643
R954 VDD.n575 VDD.t240 9.93643
R955 VDD.n558 VDD.t175 9.93643
R956 VDD.n551 VDD.t722 9.93643
R957 VDD.n545 VDD.t100 9.93643
R958 VDD.n540 VDD.t96 9.93643
R959 VDD.t210 VDD.t213 9.92654
R960 VDD.t16 VDD.t14 9.92654
R961 VDD.n567 VDD.n566 9.80103
R962 VDD.n566 VDD.n565 9.80103
R963 VDD.n565 VDD.n564 9.80103
R964 VDD.n572 VDD.n571 9.80103
R965 VDD.n571 VDD.n570 9.80103
R966 VDD.n570 VDD.n569 9.80103
R967 VDD.n578 VDD.n577 9.80103
R968 VDD.n577 VDD.n576 9.80103
R969 VDD.n576 VDD.n575 9.80103
R970 VDD.n585 VDD.n584 9.80103
R971 VDD.n584 VDD.n583 9.80103
R972 VDD.n583 VDD.n582 9.80103
R973 VDD.n554 VDD.n553 9.80103
R974 VDD.n553 VDD.n552 9.80103
R975 VDD.n552 VDD.n551 9.80103
R976 VDD.n548 VDD.n547 9.80103
R977 VDD.n547 VDD.n546 9.80103
R978 VDD.n546 VDD.n545 9.80103
R979 VDD.n543 VDD.n542 9.80103
R980 VDD.n542 VDD.n541 9.80103
R981 VDD.n541 VDD.n540 9.80103
R982 VDD.n561 VDD.n560 9.80103
R983 VDD.n560 VDD.n559 9.80103
R984 VDD.n559 VDD.n558 9.80103
R985 VDD.n3596 VDD.n3594 9.44391
R986 VDD.n992 VDD.n991 9.09918
R987 VDD.n933 VDD.n932 9.09918
R988 VDD.n1970 VDD.n1969 9.03471
R989 VDD.n3901 VDD.n494 9.03471
R990 VDD.n2910 VDD.n2648 9.03471
R991 VDD.n3830 VDD.n3829 9.03471
R992 VDD.n3137 VDD.n3136 9.03471
R993 VDD.n3155 VDD.n3154 9.03471
R994 VDD.n3586 VDD.n3583 9.03471
R995 VDD.n3390 VDD.n3387 9.03471
R996 VDD.n3909 VDD.n3908 9.03471
R997 VDD.n3938 VDD.n3937 9.03471
R998 VDD.n3804 VDD.n3803 9.03471
R999 VDD.n3635 VDD.n3634 9.03471
R1000 VDD.n3192 VDD.n3189 9.03471
R1001 VDD.n2895 VDD.n2894 9.03471
R1002 VDD.n447 VDD.n446 9.03471
R1003 VDD.n3960 VDD.n3959 9.03471
R1004 VDD.n2644 VDD.n2643 9.03471
R1005 VDD.n3852 VDD.n3851 9.03471
R1006 VDD.n3886 VDD.n3885 9.03471
R1007 VDD.n4167 VDD.n4166 9.03471
R1008 VDD.n498 VDD.n495 9.00164
R1009 VDD.n2908 VDD.n2649 9.00164
R1010 VDD.n157 VDD.n148 9.00164
R1011 VDD.n3822 VDD.n3821 9.00164
R1012 VDD.n3132 VDD.n3131 9.00164
R1013 VDD.n596 VDD.n526 9.00164
R1014 VDD.n3123 VDD.n3122 9.00164
R1015 VDD.n3589 VDD.n3588 9.00164
R1016 VDD.n3627 VDD.n3222 9.00164
R1017 VDD.n3393 VDD.n3392 9.00164
R1018 VDD.n490 VDD.n486 9.00164
R1019 VDD.n3930 VDD.n3929 9.00164
R1020 VDD.n2647 VDD.n2646 9.00164
R1021 VDD.n2890 VDD.n2889 9.00164
R1022 VDD.n3195 VDD.n3194 9.00164
R1023 VDD.n442 VDD.n162 9.00164
R1024 VDD.n508 VDD.n503 9.00164
R1025 VDD.n20 VDD.n15 9.00164
R1026 VDD.n2040 VDD.n2039 9.0005
R1027 VDD.n2038 VDD.n2032 9.0005
R1028 VDD.n2037 VDD.n2036 9.0005
R1029 VDD.n2035 VDD.n2033 9.0005
R1030 VDD.n2046 VDD.n2045 9.0005
R1031 VDD.n2044 VDD.n2030 9.0005
R1032 VDD.n2043 VDD.n2042 9.0005
R1033 VDD.n2041 VDD.n2031 9.0005
R1034 VDD.n2053 VDD.n2052 9.0005
R1035 VDD.n2051 VDD.n2050 9.0005
R1036 VDD.n2049 VDD.n2029 9.0005
R1037 VDD.n2048 VDD.n2047 9.0005
R1038 VDD.n2054 VDD.n2028 9.0005
R1039 VDD.n2056 VDD.n2055 9.0005
R1040 VDD.n2064 VDD.n2063 9.0005
R1041 VDD.n2062 VDD.n2026 9.0005
R1042 VDD.n2061 VDD.n2060 9.0005
R1043 VDD.n2059 VDD.n2058 9.0005
R1044 VDD.n2057 VDD.n2027 9.0005
R1045 VDD.n2065 VDD.n2025 9.0005
R1046 VDD.n2072 VDD.n2071 9.0005
R1047 VDD.n2070 VDD.n2069 9.0005
R1048 VDD.n2068 VDD.n2024 9.0005
R1049 VDD.n2067 VDD.n2066 9.0005
R1050 VDD.n2073 VDD.n2023 9.0005
R1051 VDD.n2075 VDD.n2074 9.0005
R1052 VDD.n2084 VDD.n2020 9.0005
R1053 VDD.n2083 VDD.n2082 9.0005
R1054 VDD.n2081 VDD.n2021 9.0005
R1055 VDD.n2080 VDD.n2079 9.0005
R1056 VDD.n2078 VDD.n2077 9.0005
R1057 VDD.n2076 VDD.n2022 9.0005
R1058 VDD.n2090 VDD.n2018 9.0005
R1059 VDD.n2089 VDD.n2088 9.0005
R1060 VDD.n2087 VDD.n2019 9.0005
R1061 VDD.n2086 VDD.n2085 9.0005
R1062 VDD.n2092 VDD.n2091 9.0005
R1063 VDD.n2093 VDD.n2017 9.0005
R1064 VDD.n2100 VDD.n2099 9.0005
R1065 VDD.n2101 VDD.n2016 9.0005
R1066 VDD.n2103 VDD.n2102 9.0005
R1067 VDD.n2096 VDD.n2015 9.0005
R1068 VDD.n2095 VDD.n2094 9.0005
R1069 VDD.n2098 VDD.n2004 9.0005
R1070 VDD.n2137 VDD.n2136 9.0005
R1071 VDD.n2135 VDD.n2127 9.0005
R1072 VDD.n2134 VDD.n2133 9.0005
R1073 VDD.n2132 VDD.n2128 9.0005
R1074 VDD.n2144 VDD.n2143 9.0005
R1075 VDD.n2141 VDD.n2125 9.0005
R1076 VDD.n2140 VDD.n2139 9.0005
R1077 VDD.n2138 VDD.n2126 9.0005
R1078 VDD.n2151 VDD.n2150 9.0005
R1079 VDD.n2148 VDD.n2123 9.0005
R1080 VDD.n2147 VDD.n2146 9.0005
R1081 VDD.n2145 VDD.n2124 9.0005
R1082 VDD.n2152 VDD.n2122 9.0005
R1083 VDD.n2154 VDD.n2153 9.0005
R1084 VDD.n2162 VDD.n2119 9.0005
R1085 VDD.n2161 VDD.n2160 9.0005
R1086 VDD.n2159 VDD.n2120 9.0005
R1087 VDD.n2158 VDD.n2157 9.0005
R1088 VDD.n2155 VDD.n2121 9.0005
R1089 VDD.n2164 VDD.n2163 9.0005
R1090 VDD.n2171 VDD.n2170 9.0005
R1091 VDD.n2168 VDD.n2117 9.0005
R1092 VDD.n2167 VDD.n2166 9.0005
R1093 VDD.n2165 VDD.n2118 9.0005
R1094 VDD.n2172 VDD.n2116 9.0005
R1095 VDD.n2174 VDD.n2173 9.0005
R1096 VDD.n2184 VDD.n2183 9.0005
R1097 VDD.n2182 VDD.n2113 9.0005
R1098 VDD.n2181 VDD.n2180 9.0005
R1099 VDD.n2179 VDD.n2114 9.0005
R1100 VDD.n2178 VDD.n2177 9.0005
R1101 VDD.n2175 VDD.n2115 9.0005
R1102 VDD.n2191 VDD.n2190 9.0005
R1103 VDD.n2188 VDD.n2111 9.0005
R1104 VDD.n2187 VDD.n2186 9.0005
R1105 VDD.n2185 VDD.n2112 9.0005
R1106 VDD.n2192 VDD.n2110 9.0005
R1107 VDD.n2194 VDD.n2193 9.0005
R1108 VDD.n2202 VDD.n2107 9.0005
R1109 VDD.n2201 VDD.n2200 9.0005
R1110 VDD.n2199 VDD.n2108 9.0005
R1111 VDD.n2198 VDD.n2197 9.0005
R1112 VDD.n2195 VDD.n2109 9.0005
R1113 VDD.n2204 VDD.n2203 9.0005
R1114 VDD.n2286 VDD.n1987 9.0005
R1115 VDD.n2288 VDD.n2287 9.0005
R1116 VDD.n2289 VDD.n1986 9.0005
R1117 VDD.n2291 VDD.n2290 9.0005
R1118 VDD.n2280 VDD.n1989 9.0005
R1119 VDD.n2282 VDD.n2281 9.0005
R1120 VDD.n2283 VDD.n1988 9.0005
R1121 VDD.n2285 VDD.n2284 9.0005
R1122 VDD.n2272 VDD.n1991 9.0005
R1123 VDD.n2274 VDD.n2273 9.0005
R1124 VDD.n2276 VDD.n2275 9.0005
R1125 VDD.n2277 VDD.n1990 9.0005
R1126 VDD.n2279 VDD.n2278 9.0005
R1127 VDD.n2271 VDD.n2270 9.0005
R1128 VDD.n2263 VDD.n2262 9.0005
R1129 VDD.n2264 VDD.n1993 9.0005
R1130 VDD.n2266 VDD.n2265 9.0005
R1131 VDD.n2268 VDD.n2267 9.0005
R1132 VDD.n2269 VDD.n1992 9.0005
R1133 VDD.n2261 VDD.n1994 9.0005
R1134 VDD.n2253 VDD.n1996 9.0005
R1135 VDD.n2255 VDD.n2254 9.0005
R1136 VDD.n2257 VDD.n2256 9.0005
R1137 VDD.n2258 VDD.n1995 9.0005
R1138 VDD.n2260 VDD.n2259 9.0005
R1139 VDD.n2252 VDD.n2251 9.0005
R1140 VDD.n2242 VDD.n1999 9.0005
R1141 VDD.n2244 VDD.n2243 9.0005
R1142 VDD.n2245 VDD.n1998 9.0005
R1143 VDD.n2247 VDD.n2246 9.0005
R1144 VDD.n2249 VDD.n2248 9.0005
R1145 VDD.n2250 VDD.n1997 9.0005
R1146 VDD.n2234 VDD.n2001 9.0005
R1147 VDD.n2236 VDD.n2235 9.0005
R1148 VDD.n2238 VDD.n2237 9.0005
R1149 VDD.n2239 VDD.n2000 9.0005
R1150 VDD.n2241 VDD.n2240 9.0005
R1151 VDD.n2233 VDD.n2232 9.0005
R1152 VDD.n2223 VDD.n1976 9.0005
R1153 VDD.n2225 VDD.n2224 9.0005
R1154 VDD.n2226 VDD.n2003 9.0005
R1155 VDD.n2228 VDD.n2227 9.0005
R1156 VDD.n2230 VDD.n2229 9.0005
R1157 VDD.n2231 VDD.n2002 9.0005
R1158 VDD.n2307 VDD.n2306 9.0005
R1159 VDD.n3104 VDD.n491 9.0005
R1160 VDD.n3412 VDD.n3411 9.0005
R1161 VDD.n3569 VDD.n3225 9.0005
R1162 VDD.n3608 VDD.n3607 9.0005
R1163 VDD.n3658 VDD.n3657 9.0005
R1164 VDD.n3149 VDD.n3148 9.0005
R1165 VDD.n3846 VDD.n3845 9.0005
R1166 VDD.n3820 VDD.n609 9.0005
R1167 VDD.n2903 VDD.n2902 9.0005
R1168 VDD.n172 VDD.n169 9.0005
R1169 VDD.n3082 VDD.n621 9.0005
R1170 VDD.n3954 VDD.n3953 9.0005
R1171 VDD.n3966 VDD.n3965 9.0005
R1172 VDD.n2926 VDD.n2925 9.0005
R1173 VDD.n2914 VDD.n2913 9.0005
R1174 VDD.n3896 VDD.n3895 9.0005
R1175 VDD.n3861 VDD.n3860 9.0005
R1176 VDD.n529 VDD.n509 9.0005
R1177 VDD.n49 VDD.n48 9.0005
R1178 VDD.n956 VDD.n944 8.88116
R1179 VDD.n1026 VDD.n1014 8.87551
R1180 VDD.n956 VDD.n955 8.87551
R1181 VDD.n981 VDD.n971 8.76484
R1182 VDD.n922 VDD.n912 8.76484
R1183 VDD.n1014 VDD.n1008 8.75464
R1184 VDD.n955 VDD.n949 8.75464
R1185 VDD.n1008 VDD.n1007 8.75136
R1186 VDD.n949 VDD.n948 8.75136
R1187 VDD.n972 VDD.t326 8.7356
R1188 VDD.n963 VDD.t343 8.7356
R1189 VDD.n998 VDD.t619 8.7356
R1190 VDD.n913 VDD.t82 8.7356
R1191 VDD.n904 VDD.t61 8.7356
R1192 VDD.n939 VDD.t519 8.7356
R1193 VDD.n238 VDD.t350 8.70918
R1194 VDD.n299 VDD.t104 8.70918
R1195 VDD.n319 VDD.t428 8.70918
R1196 VDD.n339 VDD.t412 8.70918
R1197 VDD.n354 VDD.t368 8.70918
R1198 VDD.n405 VDD.t540 8.70918
R1199 VDD.n191 VDD.t567 8.70918
R1200 VDD.n439 VDD.t222 8.70918
R1201 VDD.n166 VDD.t320 8.70918
R1202 VDD.n2879 VDD.t476 8.70918
R1203 VDD.n3102 VDD.t458 8.70918
R1204 VDD.n3126 VDD.t31 8.70918
R1205 VDD.n3838 VDD.t376 8.70918
R1206 VDD.n615 VDD.t684 8.70918
R1207 VDD.n3197 VDD.t717 8.70918
R1208 VDD.n3409 VDD.t699 8.70918
R1209 VDD.n3572 VDD.t438 8.70918
R1210 VDD.n3600 VDD.t715 8.70918
R1211 VDD.n324 VDD.t287 8.7005
R1212 VDD.n359 VDD.t295 8.7005
R1213 VDD.n429 VDD.t265 8.7005
R1214 VDD.n173 VDD.t632 8.7005
R1215 VDD.n3110 VDD.t395 8.7005
R1216 VDD.n3834 VDD.t293 8.7005
R1217 VDD.n3655 VDD.t581 8.7005
R1218 VDD.n3577 VDD.t389 8.7005
R1219 VDD.n3595 VDD.t517 8.7005
R1220 VDD.n245 VDD.t575 8.7005
R1221 VDD.n1027 VDD.n1005 8.64832
R1222 VDD.n957 VDD.n946 8.64832
R1223 VDD.n1006 VDD.n1005 8.64505
R1224 VDD.n947 VDD.n946 8.64505
R1225 VDD.n982 VDD.t595 8.62933
R1226 VDD.n923 VDD.t194 8.62933
R1227 VDD.n973 VDD.n972 8.5811
R1228 VDD.n964 VDD.n963 8.5811
R1229 VDD.n1000 VDD.n999 8.5811
R1230 VDD.n914 VDD.n913 8.5811
R1231 VDD.n905 VDD.n904 8.5811
R1232 VDD.n941 VDD.n940 8.5811
R1233 VDD.n974 VDD.n973 8.57988
R1234 VDD.n975 VDD.n974 8.57988
R1235 VDD.n976 VDD.n975 8.57988
R1236 VDD.n977 VDD.n976 8.57988
R1237 VDD.n978 VDD.n977 8.57988
R1238 VDD.n979 VDD.n978 8.57988
R1239 VDD.n980 VDD.n979 8.57988
R1240 VDD.n965 VDD.n964 8.57988
R1241 VDD.n966 VDD.n965 8.57988
R1242 VDD.n967 VDD.n966 8.57988
R1243 VDD.n968 VDD.n967 8.57988
R1244 VDD.n969 VDD.n968 8.57988
R1245 VDD.n970 VDD.n969 8.57988
R1246 VDD.n971 VDD.n970 8.57988
R1247 VDD.n993 VDD.n992 8.57988
R1248 VDD.n994 VDD.n993 8.57988
R1249 VDD.n995 VDD.n994 8.57988
R1250 VDD.n996 VDD.n995 8.57988
R1251 VDD.n997 VDD.n996 8.57988
R1252 VDD.n999 VDD.n998 8.57988
R1253 VDD.n915 VDD.n914 8.57988
R1254 VDD.n916 VDD.n915 8.57988
R1255 VDD.n917 VDD.n916 8.57988
R1256 VDD.n918 VDD.n917 8.57988
R1257 VDD.n919 VDD.n918 8.57988
R1258 VDD.n920 VDD.n919 8.57988
R1259 VDD.n921 VDD.n920 8.57988
R1260 VDD.n906 VDD.n905 8.57988
R1261 VDD.n907 VDD.n906 8.57988
R1262 VDD.n908 VDD.n907 8.57988
R1263 VDD.n909 VDD.n908 8.57988
R1264 VDD.n910 VDD.n909 8.57988
R1265 VDD.n911 VDD.n910 8.57988
R1266 VDD.n912 VDD.n911 8.57988
R1267 VDD.n934 VDD.n933 8.57988
R1268 VDD.n935 VDD.n934 8.57988
R1269 VDD.n936 VDD.n935 8.57988
R1270 VDD.n937 VDD.n936 8.57988
R1271 VDD.n938 VDD.n937 8.57988
R1272 VDD.n940 VDD.n939 8.57988
R1273 VDD.n2662 VDD.n2660 8.56509
R1274 VDD.n983 VDD.n982 8.47483
R1275 VDD.n924 VDD.n923 8.47483
R1276 VDD.n984 VDD.n983 8.47361
R1277 VDD.n985 VDD.n984 8.47361
R1278 VDD.n986 VDD.n985 8.47361
R1279 VDD.n987 VDD.n986 8.47361
R1280 VDD.n988 VDD.n987 8.47361
R1281 VDD.n989 VDD.n988 8.47361
R1282 VDD.n990 VDD.n989 8.47361
R1283 VDD.n925 VDD.n924 8.47361
R1284 VDD.n926 VDD.n925 8.47361
R1285 VDD.n927 VDD.n926 8.47361
R1286 VDD.n928 VDD.n927 8.47361
R1287 VDD.n929 VDD.n928 8.47361
R1288 VDD.n930 VDD.n929 8.47361
R1289 VDD.n931 VDD.n930 8.47361
R1290 VDD.n1083 VDD.n1082 8.34885
R1291 VDD.n3985 VDD.n3983 8.16461
R1292 VDD.n4171 VDD.n4169 8.12789
R1293 VDD.n4175 VDD.n4173 8.12789
R1294 VDD.n895 VDD.n875 8.02647
R1295 VDD.n47 VDD.n25 7.97971
R1296 VDD.n3 VDD.n1 7.88126
R1297 VDD.n10 VDD.n8 7.88126
R1298 VDD.n872 VDD.n859 7.83339
R1299 VDD.n862 VDD.n859 7.83339
R1300 VDD.n902 VDD.n875 7.82511
R1301 VDD.n2659 VDD.n2657 7.81392
R1302 VDD.n589 VDD.n587 7.75959
R1303 VDD.n538 VDD.n537 7.75959
R1304 VDD.n896 VDD.n895 7.73963
R1305 VDD.n1059 VDD.n1055 7.71682
R1306 VDD.n1051 VDD.n1047 7.71326
R1307 VDD.n1043 VDD.n1039 7.70497
R1308 VDD.n981 VDD.n980 7.70379
R1309 VDD.n922 VDD.n921 7.70379
R1310 VDD.n2656 VDD.t483 7.68737
R1311 VDD.n991 VDD.n990 7.66219
R1312 VDD.n932 VDD.n931 7.66219
R1313 VDD.n901 VDD.n893 7.656
R1314 VDD.n2664 VDD 7.61532
R1315 VDD.n899 VDD.n898 7.60466
R1316 VDD.n865 VDD.n864 7.54756
R1317 VDD.n1027 VDD.n1026 7.47307
R1318 VDD.n957 VDD.n956 7.47307
R1319 VDD.n869 VDD.n867 7.41172
R1320 VDD.n2666 VDD.n2665 7.39925
R1321 VDD.n2662 VDD.n2661 7.39825
R1322 VDD.n2667 VDD.t477 7.21673
R1323 VDD.n1083 VDD.n1033 7.17827
R1324 VDD.n3 VDD.n2 7.17326
R1325 VDD.n5 VDD.n4 7.17326
R1326 VDD.n10 VDD.n9 7.17326
R1327 VDD.n12 VDD.n11 7.17326
R1328 VDD.n2667 VDD.n2666 7.1371
R1329 VDD.n899 VDD.n875 7.01825
R1330 VDD.n4175 VDD.n4174 6.96989
R1331 VDD.n4171 VDD.n4170 6.96989
R1332 VDD.n590 VDD.t237 6.8742
R1333 VDD.n568 VDD.n567 6.84405
R1334 VDD.n555 VDD.n554 6.84405
R1335 VDD.n573 VDD.n572 6.84168
R1336 VDD.n579 VDD.n578 6.84168
R1337 VDD.n549 VDD.n548 6.84168
R1338 VDD.n544 VDD.n543 6.84168
R1339 VDD.n860 VDD.n859 6.82531
R1340 VDD.n589 VDD.n588 6.7402
R1341 VDD.n1013 VDD.t321 6.51554
R1342 VDD.n1028 VDD.t185 6.51554
R1343 VDD.n1029 VDD.t607 6.51554
R1344 VDD.n954 VDD.t57 6.51554
R1345 VDD.n958 VDD.t183 6.51554
R1346 VDD.n959 VDD.t173 6.51554
R1347 VDD.n590 VDD 6.47482
R1348 VDD.n2668 VDD.n2663 6.39395
R1349 VDD.n2297 VDD.n2296 6.21038
R1350 VDD.n2097 VDD.n1974 6.20395
R1351 VDD.n2205 VDD.n1971 6.20395
R1352 VDD.n2663 VDD 6.18943
R1353 VDD.n882 VDD.t218 6.01087
R1354 VDD.n883 VDD.t132 6.01087
R1355 VDD.n876 VDD.t118 6.01087
R1356 VDD.n877 VDD.t588 6.01087
R1357 VDD.t321 VDD.t329 6.00224
R1358 VDD.t57 VDD.t78 6.00224
R1359 VDD.n888 VDD.t138 5.94068
R1360 VDD.n889 VDD.t136 5.94068
R1361 VDD.n1026 VDD.n1025 5.87067
R1362 VDD.n2218 VDD.n1977 5.822
R1363 VDD.n2222 VDD.n2221 5.822
R1364 VDD.n152 VDD.n150 5.81853
R1365 VDD.n563 VDD.n539 5.7898
R1366 VDD.t623 VDD.n2660 5.78874
R1367 VDD.n2665 VDD.t216 5.78802
R1368 VDD.n2664 VDD.t472 5.78802
R1369 VDD.n2661 VDD.t46 5.78802
R1370 VDD.n2655 VDD.t653 5.78802
R1371 VDD.n884 VDD.n883 5.77471
R1372 VDD.n878 VDD.n877 5.77471
R1373 VDD.n873 VDD.n872 5.71819
R1374 VDD.n863 VDD.n862 5.717
R1375 VDD.n890 VDD.n889 5.70452
R1376 VDD.n6 VDD.n5 5.6735
R1377 VDD.n13 VDD.n12 5.6735
R1378 VDD.n4172 VDD.n4171 5.6675
R1379 VDD.n4176 VDD.n4175 5.6675
R1380 VDD.n868 VDD.n860 5.64877
R1381 VDD.n588 VDD.t160 5.63929
R1382 VDD.n587 VDD.t22 5.63929
R1383 VDD.t155 VDD.n536 5.63929
R1384 VDD.n537 VDD.t543 5.63929
R1385 VDD.n591 VDD.n590 5.61646
R1386 VDD.n574 VDD.n568 5.5205
R1387 VDD.n556 VDD.n555 5.5205
R1388 VDD.t603 VDD.n1004 5.51975
R1389 VDD.t518 VDD.n945 5.51975
R1390 VDD.n539 VDD.n538 5.50534
R1391 VDD.n2006 VDD 5.4995
R1392 VDD.n879 VDD.n876 5.42774
R1393 VDD.n885 VDD.n882 5.41353
R1394 VDD.n4007 VDD.n4006 5.39468
R1395 VDD.n2668 VDD.n2667 5.38279
R1396 VDD.n961 VDD.n960 5.38133
R1397 VDD.n4181 VDD 5.38037
R1398 VDD.n1031 VDD.n1030 5.38014
R1399 VDD.n1001 VDD.n1000 5.38014
R1400 VDD.n942 VDD.n941 5.38014
R1401 VDD VDD.n2207 5.3735
R1402 VDD.n891 VDD.n888 5.34569
R1403 VDD.n1043 VDD.n1042 5.288
R1404 VDD.n1051 VDD.n1050 5.28445
R1405 VDD.n1059 VDD.n1058 5.28208
R1406 VDD.n4180 VDD 5.16129
R1407 VDD.n22 VDD 5.16127
R1408 VDD.n24 VDD 5.16127
R1409 VDD.n1056 VDD 5.16011
R1410 VDD.n1053 VDD 5.16011
R1411 VDD.n1048 VDD 5.16011
R1412 VDD.n1045 VDD 5.16011
R1413 VDD.n1040 VDD 5.16011
R1414 VDD.n1037 VDD 5.16011
R1415 VDD.n1034 VDD 5.16011
R1416 VDD.n1963 VDD 5.15892
R1417 VDD.n21 VDD 5.15892
R1418 VDD.n23 VDD 5.15892
R1419 VDD.n4179 VDD 5.15892
R1420 VDD.n1055 VDD.n1054 5.14116
R1421 VDD.n1058 VDD.n1057 5.13879
R1422 VDD.n581 VDD.n580 5.11615
R1423 VDD.n550 VDD.n544 5.11615
R1424 VDD.n1047 VDD.n1046 5.11392
R1425 VDD.n1050 VDD.n1049 5.11274
R1426 VDD.n1039 VDD.n1038 5.10918
R1427 VDD.n1042 VDD.n1041 5.10445
R1428 VDD.n1036 VDD.n1035 5.05589
R1429 VDD.n324 VDD.n212 5.03193
R1430 VDD.n360 VDD.n359 5.03193
R1431 VDD.n430 VDD.n429 5.03193
R1432 VDD.n173 VDD.n171 5.03193
R1433 VDD.n3111 VDD.n3110 5.03193
R1434 VDD.n3834 VDD.n3833 5.03193
R1435 VDD.n3656 VDD.n3655 5.03193
R1436 VDD.n3577 VDD.n3567 5.03193
R1437 VDD.n245 VDD.n244 5.03192
R1438 VDD.n863 VDD.n857 4.92502
R1439 VDD.n1105 VDD.n1104 4.92456
R1440 VDD.n2657 VDD.n2656 4.74326
R1441 VDD.n591 VDD.n586 4.67466
R1442 VDD.n3596 VDD.n3595 4.67339
R1443 VDD.n1085 VDD.n1084 4.65562
R1444 VDD.n304 VDD.n216 4.51116
R1445 VDD.n346 VDD.n345 4.51116
R1446 VDD.n410 VDD.n194 4.51116
R1447 VDD.n452 VDD.n451 4.51116
R1448 VDD.n2880 VDD.n2878 4.51116
R1449 VDD.n3142 VDD.n3141 4.51116
R1450 VDD.n3806 VDD.n3805 4.51116
R1451 VDD.n3398 VDD.n3396 4.51116
R1452 VDD.n3894 VDD.n3893 4.50287
R1453 VDD.n2676 VDD.n2675 4.50287
R1454 VDD.n1962 VDD.n1960 4.50199
R1455 VDD.n3899 VDD.n492 4.50199
R1456 VDD.n2912 VDD.n2873 4.50199
R1457 VDD.n3827 VDD.n3826 4.50199
R1458 VDD.n525 VDD.n523 4.50199
R1459 VDD.n600 VDD.n598 4.50199
R1460 VDD.n3121 VDD.n3120 4.50199
R1461 VDD.n3552 VDD.n3550 4.50199
R1462 VDD.n3632 VDD.n3631 4.50199
R1463 VDD.n3385 VDD.n3383 4.50199
R1464 VDD.n489 VDD.n488 4.50199
R1465 VDD.n2639 VDD.n2636 4.50199
R1466 VDD.n3935 VDD.n3934 4.50199
R1467 VDD.n3801 VDD.n3800 4.50199
R1468 VDD.n2876 VDD.n2874 4.50199
R1469 VDD.n3067 VDD.n3065 4.50199
R1470 VDD.n161 VDD.n159 4.50199
R1471 VDD.n147 VDD.n145 4.50199
R1472 VDD.n507 VDD.n506 4.50199
R1473 VDD.n19 VDD.n18 4.50199
R1474 VDD.n1070 VDD.n1061 4.50168
R1475 VDD.n1080 VDD.n1071 4.50168
R1476 VDD.n2301 VDD.n1972 4.50168
R1477 VDD.n3859 VDD.n3858 4.50168
R1478 VDD.n531 VDD.n530 4.50168
R1479 VDD.n3964 VDD.n3963 4.50168
R1480 VDD.n156 VDD.n155 4.50168
R1481 VDD.n152 VDD.n151 4.50168
R1482 VDD.n260 VDD.n220 4.50168
R1483 VDD.n266 VDD.n214 4.50168
R1484 VDD.n272 VDD.n210 4.50168
R1485 VDD.n370 VDD.n204 4.50168
R1486 VDD.n394 VDD.n198 4.50168
R1487 VDD.n379 VDD.n192 4.50168
R1488 VDD.n461 VDD.n185 4.50168
R1489 VDD.n465 VDD.n164 4.50168
R1490 VDD.n3921 VDD.n180 4.50168
R1491 VDD.n3914 VDD.n3913 4.50168
R1492 VDD.n3158 VDD.n3090 4.50168
R1493 VDD.n3165 VDD.n602 4.50168
R1494 VDD.n3172 VDD.n612 4.50168
R1495 VDD.n3206 VDD.n3079 4.50168
R1496 VDD.n3647 VDD.n3075 4.50168
R1497 VDD.n3640 VDD.n3639 4.50168
R1498 VDD.n3564 VDD.n3554 4.50168
R1499 VDD.n254 VDD.n226 4.50168
R1500 VDD.n35 VDD.n26 4.50167
R1501 VDD.n45 VDD.n36 4.50167
R1502 VDD.n3616 VDD.n3234 4.50095
R1503 VDD.n3544 VDD.n3543 4.50095
R1504 VDD.n3536 VDD.n3535 4.50095
R1505 VDD.n3528 VDD.n3527 4.50095
R1506 VDD.n3520 VDD.n3519 4.50095
R1507 VDD.n3512 VDD.n3511 4.50095
R1508 VDD.n3504 VDD.n3503 4.50095
R1509 VDD.n4043 VDD.n111 4.5007
R1510 VDD.n4063 VDD.n101 4.5007
R1511 VDD.n4053 VDD.n106 4.5007
R1512 VDD.n4033 VDD.n116 4.5007
R1513 VDD.n4023 VDD.n121 4.5007
R1514 VDD.n4013 VDD.n126 4.5007
R1515 VDD.n4073 VDD.n96 4.5007
R1516 VDD.n4083 VDD.n91 4.5007
R1517 VDD.n4125 VDD.n4120 4.5007
R1518 VDD.n4113 VDD.n77 4.5007
R1519 VDD.n4103 VDD.n81 4.5007
R1520 VDD.n4093 VDD.n86 4.5007
R1521 VDD.n4120 VDD.n74 4.50065
R1522 VDD.n4134 VDD.n4133 4.50065
R1523 VDD.n4159 VDD.n51 4.50065
R1524 VDD.n1726 VDD.n1725 4.50065
R1525 VDD.n1714 VDD.n1318 4.50065
R1526 VDD.n1511 VDD.n1510 4.50065
R1527 VDD.n1499 VDD.n1414 4.50065
R1528 VDD.n1019 VDD.n1018 4.5005
R1529 VDD.n1024 VDD.n1015 4.5005
R1530 VDD.n880 VDD.n879 4.5005
R1531 VDD.n886 VDD.n885 4.5005
R1532 VDD.n892 VDD.n891 4.5005
R1533 VDD.n903 VDD.n902 4.5005
R1534 VDD.n943 VDD.n942 4.5005
R1535 VDD.n962 VDD.n961 4.5005
R1536 VDD.n1002 VDD.n1001 4.5005
R1537 VDD.n1032 VDD.n1031 4.5005
R1538 VDD.n1067 VDD.n1066 4.5005
R1539 VDD.n1077 VDD.n1076 4.5005
R1540 VDD.n1044 VDD.n1043 4.5005
R1541 VDD.n1052 VDD.n1051 4.5005
R1542 VDD.n1060 VDD.n1059 4.5005
R1543 VDD.n1082 VDD.n1081 4.5005
R1544 VDD.n868 VDD.n857 4.5005
R1545 VDD.n874 VDD.n873 4.5005
R1546 VDD.n3977 VDD.n3976 4.5005
R1547 VDD.n3979 VDD.n3973 4.5005
R1548 VDD.n2217 VDD.n2216 4.5005
R1549 VDD.n2219 VDD.n2218 4.5005
R1550 VDD.n2221 VDD.n2220 4.5005
R1551 VDD.n1965 VDD.n1964 4.5005
R1552 VDD.n2299 VDD.n2298 4.5005
R1553 VDD.n1968 VDD.n1962 4.5005
R1554 VDD.n1969 VDD.n1968 4.5005
R1555 VDD.n1967 VDD.n1961 4.5005
R1556 VDD.n1966 VDD.n1960 4.5005
R1557 VDD.n2309 VDD.n2308 4.5005
R1558 VDD.n580 VDD.n579 4.5005
R1559 VDD.n574 VDD.n573 4.5005
R1560 VDD.n550 VDD.n549 4.5005
R1561 VDD.n557 VDD.n556 4.5005
R1562 VDD.n563 VDD.n562 4.5005
R1563 VDD.n3828 VDD.n3827 4.5005
R1564 VDD.n3829 VDD.n3828 4.5005
R1565 VDD.n3823 VDD.n608 4.5005
R1566 VDD.n3826 VDD.n607 4.5005
R1567 VDD.n3825 VDD.n3824 4.5005
R1568 VDD.n3850 VDD.n525 4.5005
R1569 VDD.n3851 VDD.n3850 4.5005
R1570 VDD.n3849 VDD.n524 4.5005
R1571 VDD.n597 VDD.n523 4.5005
R1572 VDD.n3863 VDD.n3862 4.5005
R1573 VDD.n3135 VDD.n600 4.5005
R1574 VDD.n3136 VDD.n3135 4.5005
R1575 VDD.n3134 VDD.n599 4.5005
R1576 VDD.n3133 VDD.n598 4.5005
R1577 VDD.n3848 VDD.n3847 4.5005
R1578 VDD.n3585 VDD.n3552 4.5005
R1579 VDD.n3586 VDD.n3585 4.5005
R1580 VDD.n3584 VDD.n3551 4.5005
R1581 VDD.n3587 VDD.n3550 4.5005
R1582 VDD.n3610 VDD.n3609 4.5005
R1583 VDD.n3633 VDD.n3632 4.5005
R1584 VDD.n3634 VDD.n3633 4.5005
R1585 VDD.n3628 VDD.n3224 4.5005
R1586 VDD.n3631 VDD.n3223 4.5005
R1587 VDD.n3630 VDD.n3629 4.5005
R1588 VDD.n3389 VDD.n3385 4.5005
R1589 VDD.n3390 VDD.n3389 4.5005
R1590 VDD.n3388 VDD.n3384 4.5005
R1591 VDD.n3391 VDD.n3383 4.5005
R1592 VDD.n3414 VDD.n3413 4.5005
R1593 VDD.n2639 VDD.n170 4.5005
R1594 VDD.n2644 VDD.n170 4.5005
R1595 VDD.n2638 VDD.n2637 4.5005
R1596 VDD.n2645 VDD.n2636 4.5005
R1597 VDD.n2928 VDD.n2927 4.5005
R1598 VDD.n3936 VDD.n3935 4.5005
R1599 VDD.n3937 VDD.n3936 4.5005
R1600 VDD.n3931 VDD.n168 4.5005
R1601 VDD.n3934 VDD.n167 4.5005
R1602 VDD.n3933 VDD.n3932 4.5005
R1603 VDD.n3802 VDD.n3801 4.5005
R1604 VDD.n3803 VDD.n3802 4.5005
R1605 VDD.n3797 VDD.n620 4.5005
R1606 VDD.n3800 VDD.n619 4.5005
R1607 VDD.n3799 VDD.n3798 4.5005
R1608 VDD.n3597 VDD.n3596 4.5005
R1609 VDD.n290 VDD.n222 4.5005
R1610 VDD.n265 VDD.n215 4.5005
R1611 VDD.n271 VDD.n211 4.5005
R1612 VDD.n275 VDD.n207 4.5005
R1613 VDD.n396 VDD.n395 4.5005
R1614 VDD.n378 VDD.n193 4.5005
R1615 VDD.n382 VDD.n188 4.5005
R1616 VDD.n466 VDD.n163 4.5005
R1617 VDD.n473 VDD.n176 4.5005
R1618 VDD.n3916 VDD.n3915 4.5005
R1619 VDD.n3099 VDD.n3098 4.5005
R1620 VDD.n3167 VDD.n3166 4.5005
R1621 VDD.n3173 VDD.n611 4.5005
R1622 VDD.n3184 VDD.n3183 4.5005
R1623 VDD.n3209 VDD.n3071 4.5005
R1624 VDD.n3642 VDD.n3641 4.5005
R1625 VDD.n3566 VDD.n3565 4.5005
R1626 VDD.n232 VDD.n231 4.5005
R1627 VDD.n241 VDD.n239 4.5005
R1628 VDD.n238 VDD.n237 4.5005
R1629 VDD.n302 VDD.n301 4.5005
R1630 VDD.n300 VDD.n299 4.5005
R1631 VDD.n318 VDD.n213 4.5005
R1632 VDD.n320 VDD.n319 4.5005
R1633 VDD.n338 VDD.n208 4.5005
R1634 VDD.n340 VDD.n339 4.5005
R1635 VDD.n362 VDD.n361 4.5005
R1636 VDD.n354 VDD.n353 4.5005
R1637 VDD.n408 VDD.n407 4.5005
R1638 VDD.n406 VDD.n405 4.5005
R1639 VDD.n428 VDD.n427 4.5005
R1640 VDD.n191 VDD.n190 4.5005
R1641 VDD.n441 VDD.n440 4.5005
R1642 VDD.n439 VDD.n437 4.5005
R1643 VDD.n3940 VDD.n3939 4.5005
R1644 VDD.n166 VDD.n165 4.5005
R1645 VDD.n2901 VDD.n2900 4.5005
R1646 VDD.n2879 VDD.n2877 4.5005
R1647 VDD.n3109 VDD.n3108 4.5005
R1648 VDD.n3102 VDD.n3101 4.5005
R1649 VDD.n3128 VDD.n3127 4.5005
R1650 VDD.n3126 VDD.n3124 4.5005
R1651 VDD.n3837 VDD.n605 4.5005
R1652 VDD.n3839 VDD.n3838 4.5005
R1653 VDD.n617 VDD.n616 4.5005
R1654 VDD.n615 VDD.n613 4.5005
R1655 VDD.n3198 VDD.n3068 4.5005
R1656 VDD.n3197 VDD.n3196 4.5005
R1657 VDD.n3408 VDD.n3395 4.5005
R1658 VDD.n3410 VDD.n3409 4.5005
R1659 VDD.n3571 VDD.n3568 4.5005
R1660 VDD.n3573 VDD.n3572 4.5005
R1661 VDD.n3599 VDD.n3594 4.5005
R1662 VDD.n3601 VDD.n3600 4.5005
R1663 VDD.n236 VDD.n235 4.5005
R1664 VDD.n253 VDD.n252 4.5005
R1665 VDD.n292 VDD.n291 4.5005
R1666 VDD.n295 VDD.n294 4.5005
R1667 VDD.n311 VDD.n310 4.5005
R1668 VDD.n315 VDD.n314 4.5005
R1669 VDD.n331 VDD.n330 4.5005
R1670 VDD.n335 VDD.n334 4.5005
R1671 VDD.n352 VDD.n351 4.5005
R1672 VDD.n369 VDD.n368 4.5005
R1673 VDD.n398 VDD.n397 4.5005
R1674 VDD.n401 VDD.n400 4.5005
R1675 VDD.n417 VDD.n416 4.5005
R1676 VDD.n421 VDD.n420 4.5005
R1677 VDD.n436 VDD.n435 4.5005
R1678 VDD.n460 VDD.n459 4.5005
R1679 VDD.n3951 VDD.n3950 4.5005
R1680 VDD.n3947 VDD.n3946 4.5005
R1681 VDD.n3925 VDD.n3924 4.5005
R1682 VDD.n3923 VDD.n3922 4.5005
R1683 VDD.n2882 VDD.n482 4.5005
R1684 VDD.n3912 VDD.n3911 4.5005
R1685 VDD.n3117 VDD.n3116 4.5005
R1686 VDD.n3157 VDD.n3156 4.5005
R1687 VDD.n3130 VDD.n3086 4.5005
R1688 VDD.n3844 VDD.n3843 4.5005
R1689 VDD.n3818 VDD.n3817 4.5005
R1690 VDD.n3814 VDD.n3813 4.5005
R1691 VDD.n3188 VDD.n3187 4.5005
R1692 VDD.n3205 VDD.n3204 4.5005
R1693 VDD.n3651 VDD.n3650 4.5005
R1694 VDD.n3649 VDD.n3648 4.5005
R1695 VDD.n3399 VDD.n3218 4.5005
R1696 VDD.n3638 VDD.n3637 4.5005
R1697 VDD.n3591 VDD.n3590 4.5005
R1698 VDD.n3606 VDD.n3605 4.5005
R1699 VDD.n445 VDD.n161 4.5005
R1700 VDD.n446 VDD.n445 4.5005
R1701 VDD.n444 VDD.n160 4.5005
R1702 VDD.n443 VDD.n159 4.5005
R1703 VDD.n3956 VDD.n3955 4.5005
R1704 VDD.n3958 VDD.n147 4.5005
R1705 VDD.n3959 VDD.n3958 4.5005
R1706 VDD.n3957 VDD.n146 4.5005
R1707 VDD.n158 VDD.n145 4.5005
R1708 VDD.n3968 VDD.n3967 4.5005
R1709 VDD.n154 VDD.n153 4.5005
R1710 VDD.n3962 VDD.n3961 4.5005
R1711 VDD.n2640 VDD.n149 4.5005
R1712 VDD.n2642 VDD.n2641 4.5005
R1713 VDD.n2924 VDD.n2923 4.5005
R1714 VDD.n2922 VDD.n2921 4.5005
R1715 VDD.n2916 VDD.n2915 4.5005
R1716 VDD.n2652 VDD.n2651 4.5005
R1717 VDD.n3888 VDD.n3887 4.5005
R1718 VDD.n3854 VDD.n3853 4.5005
R1719 VDD.n3884 VDD.n506 4.5005
R1720 VDD.n3885 VDD.n3884 4.5005
R1721 VDD.n3883 VDD.n3882 4.5005
R1722 VDD.n507 VDD.n504 4.5005
R1723 VDD.n3881 VDD.n3880 4.5005
R1724 VDD.n3153 VDD.n3120 4.5005
R1725 VDD.n3154 VDD.n3153 4.5005
R1726 VDD.n3152 VDD.n3151 4.5005
R1727 VDD.n3121 VDD.n3119 4.5005
R1728 VDD.n3150 VDD.n505 4.5005
R1729 VDD.n4083 VDD.n4080 4.5005
R1730 VDD.n4084 VDD.n4083 4.5005
R1731 VDD.n4073 VDD.n4072 4.5005
R1732 VDD.n4074 VDD.n4073 4.5005
R1733 VDD.n513 VDD.n510 4.5005
R1734 VDD.n516 VDD.n510 4.5005
R1735 VDD.n3868 VDD.n3865 4.5005
R1736 VDD.n3869 VDD.n3868 4.5005
R1737 VDD.n3422 VDD.n3416 4.5005
R1738 VDD.n3423 VDD.n3422 4.5005
R1739 VDD.n3229 VDD.n3226 4.5005
R1740 VDD.n3232 VDD.n3226 4.5005
R1741 VDD.n3615 VDD.n3612 4.5005
R1742 VDD.n3616 VDD.n3615 4.5005
R1743 VDD.n2812 VDD.n2806 4.5005
R1744 VDD.n628 VDD.n622 4.5005
R1745 VDD.n627 VDD.n622 4.5005
R1746 VDD.n2809 VDD.n610 4.5005
R1747 VDD.n2933 VDD.n2929 4.5005
R1748 VDD.n3988 VDD.n3969 4.5005
R1749 VDD.n3864 VDD.n517 4.5005
R1750 VDD.n3879 VDD.n3878 4.5005
R1751 VDD.n4053 VDD.n4052 4.5005
R1752 VDD.n4054 VDD.n4053 4.5005
R1753 VDD.n4063 VDD.n4060 4.5005
R1754 VDD.n4064 VDD.n4063 4.5005
R1755 VDD.n4043 VDD.n4040 4.5005
R1756 VDD.n4044 VDD.n4043 4.5005
R1757 VDD.n4033 VDD.n4030 4.5005
R1758 VDD.n4034 VDD.n4033 4.5005
R1759 VDD.n4023 VDD.n4020 4.5005
R1760 VDD.n4024 VDD.n4023 4.5005
R1761 VDD.n4013 VDD.n4010 4.5005
R1762 VDD.n4014 VDD.n4013 4.5005
R1763 VDD.n3991 VDD.n3970 4.5005
R1764 VDD.n3992 VDD.n3991 4.5005
R1765 VDD.n2936 VDD.n2930 4.5005
R1766 VDD.n2937 VDD.n2936 4.5005
R1767 VDD.n3796 VDD.n3795 4.5005
R1768 VDD.n2813 VDD.n2812 4.5005
R1769 VDD.n3419 VDD.n3415 4.5005
R1770 VDD.n3626 VDD.n3625 4.5005
R1771 VDD.n3611 VDD.n3233 4.5005
R1772 VDD.n4082 VDD.n4081 4.5005
R1773 VDD.n95 VDD.n92 4.5005
R1774 VDD.n4079 VDD.n92 4.5005
R1775 VDD.n100 VDD.n97 4.5005
R1776 VDD.n4069 VDD.n97 4.5005
R1777 VDD.n3875 VDD.n514 4.5005
R1778 VDD.n3875 VDD.n3874 4.5005
R1779 VDD.n521 VDD.n518 4.5005
R1780 VDD.n522 VDD.n518 4.5005
R1781 VDD.n3417 VDD.n3381 4.5005
R1782 VDD.n3417 VDD.n3382 4.5005
R1783 VDD.n3622 VDD.n3230 4.5005
R1784 VDD.n3622 VDD.n3621 4.5005
R1785 VDD.n3549 VDD.n3234 4.5005
R1786 VDD.n2807 VDD.n2804 4.5005
R1787 VDD.n3792 VDD.n625 4.5005
R1788 VDD.n3792 VDD.n3791 4.5005
R1789 VDD.n2811 VDD.n2810 4.5005
R1790 VDD.n2935 VDD.n2934 4.5005
R1791 VDD.n3990 VDD.n3989 4.5005
R1792 VDD.n4012 VDD.n4011 4.5005
R1793 VDD.n4022 VDD.n4021 4.5005
R1794 VDD.n4032 VDD.n4031 4.5005
R1795 VDD.n3867 VDD.n3866 4.5005
R1796 VDD.n3877 VDD.n3876 4.5005
R1797 VDD.n110 VDD.n107 4.5005
R1798 VDD.n4049 VDD.n107 4.5005
R1799 VDD.n4051 VDD.n4050 4.5005
R1800 VDD.n4071 VDD.n4070 4.5005
R1801 VDD.n4062 VDD.n4061 4.5005
R1802 VDD.n105 VDD.n102 4.5005
R1803 VDD.n4059 VDD.n102 4.5005
R1804 VDD.n4042 VDD.n4041 4.5005
R1805 VDD.n115 VDD.n112 4.5005
R1806 VDD.n4039 VDD.n112 4.5005
R1807 VDD.n120 VDD.n117 4.5005
R1808 VDD.n4029 VDD.n117 4.5005
R1809 VDD.n125 VDD.n122 4.5005
R1810 VDD.n4019 VDD.n122 4.5005
R1811 VDD.n130 VDD.n127 4.5005
R1812 VDD.n4009 VDD.n127 4.5005
R1813 VDD.n3971 VDD.n143 4.5005
R1814 VDD.n3971 VDD.n144 4.5005
R1815 VDD.n2931 VDD.n2634 4.5005
R1816 VDD.n2931 VDD.n2635 4.5005
R1817 VDD.n3794 VDD.n3793 4.5005
R1818 VDD.n2807 VDD.n2805 4.5005
R1819 VDD.n3421 VDD.n3420 4.5005
R1820 VDD.n3624 VDD.n3623 4.5005
R1821 VDD.n3614 VDD.n3613 4.5005
R1822 VDD.n4088 VDD.n4087 4.5005
R1823 VDD.n4086 VDD.n93 4.5005
R1824 VDD.n4086 VDD.n4085 4.5005
R1825 VDD.n2838 VDD.n512 4.5005
R1826 VDD.n2838 VDD.n2837 4.5005
R1827 VDD.n3871 VDD.n519 4.5005
R1828 VDD.n3871 VDD.n3870 4.5005
R1829 VDD.n3425 VDD.n3380 4.5005
R1830 VDD.n3425 VDD.n3424 4.5005
R1831 VDD.n3367 VDD.n3228 4.5005
R1832 VDD.n3367 VDD.n3366 4.5005
R1833 VDD.n3618 VDD.n3235 4.5005
R1834 VDD.n3618 VDD.n3617 4.5005
R1835 VDD.n2815 VDD.n2803 4.5005
R1836 VDD.n3790 VDD.n3789 4.5005
R1837 VDD.n3789 VDD.n624 4.5005
R1838 VDD.n2808 VDD.n2802 4.5005
R1839 VDD.n2932 VDD.n2632 4.5005
R1840 VDD.n3873 VDD.n3872 4.5005
R1841 VDD.n515 VDD.n511 4.5005
R1842 VDD.n4018 VDD.n4017 4.5005
R1843 VDD.n4028 VDD.n4027 4.5005
R1844 VDD.n4038 VDD.n4037 4.5005
R1845 VDD.n4048 VDD.n4047 4.5005
R1846 VDD.n4056 VDD.n108 4.5005
R1847 VDD.n4056 VDD.n4055 4.5005
R1848 VDD.n4068 VDD.n4067 4.5005
R1849 VDD.n4066 VDD.n103 4.5005
R1850 VDD.n4066 VDD.n4065 4.5005
R1851 VDD.n4058 VDD.n4057 4.5005
R1852 VDD.n4078 VDD.n4077 4.5005
R1853 VDD.n4076 VDD.n98 4.5005
R1854 VDD.n4076 VDD.n4075 4.5005
R1855 VDD.n4046 VDD.n113 4.5005
R1856 VDD.n4046 VDD.n4045 4.5005
R1857 VDD.n4036 VDD.n118 4.5005
R1858 VDD.n4036 VDD.n4035 4.5005
R1859 VDD.n4026 VDD.n123 4.5005
R1860 VDD.n4026 VDD.n4025 4.5005
R1861 VDD.n4016 VDD.n128 4.5005
R1862 VDD.n4016 VDD.n4015 4.5005
R1863 VDD.n3987 VDD.n141 4.5005
R1864 VDD.n3994 VDD.n142 4.5005
R1865 VDD.n3994 VDD.n3993 4.5005
R1866 VDD.n2939 VDD.n2633 4.5005
R1867 VDD.n2939 VDD.n2938 4.5005
R1868 VDD.n626 VDD.n623 4.5005
R1869 VDD.n2815 VDD.n2814 4.5005
R1870 VDD.n3418 VDD.n3379 4.5005
R1871 VDD.n3231 VDD.n3227 4.5005
R1872 VDD.n3620 VDD.n3619 4.5005
R1873 VDD.n3986 VDD.n3985 4.5005
R1874 VDD.n3984 VDD.n3972 4.5005
R1875 VDD.n132 VDD.n131 4.5005
R1876 VDD.n4008 VDD.n4007 4.5005
R1877 VDD.n30 VDD.n29 4.5005
R1878 VDD.n40 VDD.n39 4.5005
R1879 VDD.n4178 VDD.n4177 4.5005
R1880 VDD.n4168 VDD.n14 4.5005
R1881 VDD.n47 VDD.n46 4.5005
R1882 VDD.n4165 VDD.n18 4.5005
R1883 VDD.n4166 VDD.n4165 4.5005
R1884 VDD.n4164 VDD.n4163 4.5005
R1885 VDD.n19 VDD.n16 4.5005
R1886 VDD.n4162 VDD.n4161 4.5005
R1887 VDD.n4125 VDD.n4121 4.5005
R1888 VDD.n4126 VDD.n4125 4.5005
R1889 VDD.n4124 VDD.n4123 4.5005
R1890 VDD.n4122 VDD.n76 4.5005
R1891 VDD.n4122 VDD.n4119 4.5005
R1892 VDD.n4128 VDD.n75 4.5005
R1893 VDD.n4128 VDD.n4127 4.5005
R1894 VDD.n4133 VDD.n4132 4.5005
R1895 VDD.n4131 VDD.n4130 4.5005
R1896 VDD.n4131 VDD.n69 4.5005
R1897 VDD.n2394 VDD.n94 4.5005
R1898 VDD.n2391 VDD.n2390 4.5005
R1899 VDD.n2390 VDD.n1145 4.5005
R1900 VDD.n2400 VDD.n2399 4.5005
R1901 VDD.n2399 VDD.n1140 4.5005
R1902 VDD.n2843 VDD.n2840 4.5005
R1903 VDD.n2844 VDD.n2843 4.5005
R1904 VDD.n2830 VDD.n2827 4.5005
R1905 VDD.n2831 VDD.n2830 4.5005
R1906 VDD.n3433 VDD.n3427 4.5005
R1907 VDD.n3434 VDD.n3433 4.5005
R1908 VDD.n3372 VDD.n3369 4.5005
R1909 VDD.n3373 VDD.n3372 4.5005
R1910 VDD.n3239 VDD.n3236 4.5005
R1911 VDD.n3543 VDD.n3236 4.5005
R1912 VDD.n2820 VDD.n2817 4.5005
R1913 VDD.n635 VDD.n629 4.5005
R1914 VDD.n634 VDD.n629 4.5005
R1915 VDD.n2816 VDD.n2709 4.5005
R1916 VDD.n2944 VDD.n2943 4.5005
R1917 VDD.n3995 VDD.n135 4.5005
R1918 VDD.n849 VDD.n129 4.5005
R1919 VDD.n2445 VDD.n124 4.5005
R1920 VDD.n2439 VDD.n119 4.5005
R1921 VDD.n2704 VDD.n520 4.5005
R1922 VDD.n2839 VDD.n2699 4.5005
R1923 VDD.n2418 VDD.n2417 4.5005
R1924 VDD.n2417 VDD.n1130 4.5005
R1925 VDD.n2421 VDD.n109 4.5005
R1926 VDD.n2403 VDD.n99 4.5005
R1927 VDD.n2412 VDD.n104 4.5005
R1928 VDD.n2409 VDD.n2408 4.5005
R1929 VDD.n2408 VDD.n1135 4.5005
R1930 VDD.n2430 VDD.n114 4.5005
R1931 VDD.n2427 VDD.n2426 4.5005
R1932 VDD.n2426 VDD.n1125 4.5005
R1933 VDD.n2436 VDD.n2435 4.5005
R1934 VDD.n2435 VDD.n1120 4.5005
R1935 VDD.n2448 VDD.n1118 4.5005
R1936 VDD.n2449 VDD.n2448 4.5005
R1937 VDD.n1111 VDD.n1108 4.5005
R1938 VDD.n1112 VDD.n1111 4.5005
R1939 VDD.n3999 VDD.n3996 4.5005
R1940 VDD.n4000 VDD.n3999 4.5005
R1941 VDD.n2942 VDD.n2941 4.5005
R1942 VDD.n2942 VDD.n735 4.5005
R1943 VDD.n3788 VDD.n3787 4.5005
R1944 VDD.n2821 VDD.n2820 4.5005
R1945 VDD.n3430 VDD.n3426 4.5005
R1946 VDD.n3368 VDD.n3316 4.5005
R1947 VDD.n3548 VDD.n3547 4.5005
R1948 VDD.n73 VDD.n70 4.5005
R1949 VDD.n4135 VDD.n72 4.5005
R1950 VDD.n4136 VDD.n4135 4.5005
R1951 VDD.n2393 VDD.n1146 4.5005
R1952 VDD.n2397 VDD.n1147 4.5005
R1953 VDD.n2398 VDD.n2397 4.5005
R1954 VDD.n2406 VDD.n1142 4.5005
R1955 VDD.n2407 VDD.n2406 4.5005
R1956 VDD.n2703 VDD.n2700 4.5005
R1957 VDD.n2836 VDD.n2700 4.5005
R1958 VDD.n2708 VDD.n2705 4.5005
R1959 VDD.n2826 VDD.n2705 4.5005
R1960 VDD.n3428 VDD.n3315 4.5005
R1961 VDD.n3428 VDD.n3378 4.5005
R1962 VDD.n3364 VDD.n3317 4.5005
R1963 VDD.n3365 VDD.n3317 4.5005
R1964 VDD.n3544 VDD.n3240 4.5005
R1965 VDD.n2800 VDD.n2710 4.5005
R1966 VDD.n3784 VDD.n632 4.5005
R1967 VDD.n3784 VDD.n3783 4.5005
R1968 VDD.n2819 VDD.n2818 4.5005
R1969 VDD.n2631 VDD.n736 4.5005
R1970 VDD.n3998 VDD.n3997 4.5005
R1971 VDD.n1110 VDD.n1109 4.5005
R1972 VDD.n2447 VDD.n2446 4.5005
R1973 VDD.n2438 VDD.n1121 4.5005
R1974 VDD.n2829 VDD.n2828 4.5005
R1975 VDD.n2842 VDD.n2841 4.5005
R1976 VDD.n2424 VDD.n1132 4.5005
R1977 VDD.n2425 VDD.n2424 4.5005
R1978 VDD.n2420 VDD.n1131 4.5005
R1979 VDD.n2402 VDD.n1141 4.5005
R1980 VDD.n2411 VDD.n1136 4.5005
R1981 VDD.n2415 VDD.n1137 4.5005
R1982 VDD.n2416 VDD.n2415 4.5005
R1983 VDD.n2429 VDD.n1126 4.5005
R1984 VDD.n2433 VDD.n1127 4.5005
R1985 VDD.n2434 VDD.n2433 4.5005
R1986 VDD.n2442 VDD.n1122 4.5005
R1987 VDD.n2443 VDD.n2442 4.5005
R1988 VDD.n1119 VDD.n848 4.5005
R1989 VDD.n1119 VDD.n1117 4.5005
R1990 VDD.n852 VDD.n850 4.5005
R1991 VDD.n1107 VDD.n850 4.5005
R1992 VDD.n139 VDD.n136 4.5005
R1993 VDD.n140 VDD.n136 4.5005
R1994 VDD.n2947 VDD.n737 4.5005
R1995 VDD.n2948 VDD.n2947 4.5005
R1996 VDD.n3786 VDD.n3785 4.5005
R1997 VDD.n2801 VDD.n2710 4.5005
R1998 VDD.n3432 VDD.n3431 4.5005
R1999 VDD.n3371 VDD.n3370 4.5005
R2000 VDD.n3546 VDD.n3545 4.5005
R2001 VDD.n4129 VDD.n17 4.5005
R2002 VDD.n71 VDD.n17 4.5005
R2003 VDD.n2396 VDD.n2395 4.5005
R2004 VDD.n2392 VDD.n1149 4.5005
R2005 VDD.n1149 VDD.n1148 4.5005
R2006 VDD.n2846 VDD.n2701 4.5005
R2007 VDD.n2846 VDD.n2845 4.5005
R2008 VDD.n2833 VDD.n2706 4.5005
R2009 VDD.n2833 VDD.n2832 4.5005
R2010 VDD.n3436 VDD.n3314 4.5005
R2011 VDD.n3436 VDD.n3435 4.5005
R2012 VDD.n3375 VDD.n3318 4.5005
R2013 VDD.n3375 VDD.n3374 4.5005
R2014 VDD.n3541 VDD.n3238 4.5005
R2015 VDD.n3542 VDD.n3541 4.5005
R2016 VDD.n2823 VDD.n2711 4.5005
R2017 VDD.n3782 VDD.n3781 4.5005
R2018 VDD.n3781 VDD.n631 4.5005
R2019 VDD.n2825 VDD.n2824 4.5005
R2020 VDD.n2946 VDD.n2945 4.5005
R2021 VDD.n4004 VDD.n4003 4.5005
R2022 VDD.n2835 VDD.n2834 4.5005
R2023 VDD.n2848 VDD.n2847 4.5005
R2024 VDD.n1116 VDD.n1115 4.5005
R2025 VDD.n2444 VDD.n846 4.5005
R2026 VDD.n2441 VDD.n2440 4.5005
R2027 VDD.n2432 VDD.n2431 4.5005
R2028 VDD.n2419 VDD.n1134 4.5005
R2029 VDD.n1134 VDD.n1133 4.5005
R2030 VDD.n2414 VDD.n2413 4.5005
R2031 VDD.n2410 VDD.n1139 4.5005
R2032 VDD.n1139 VDD.n1138 4.5005
R2033 VDD.n2423 VDD.n2422 4.5005
R2034 VDD.n2405 VDD.n2404 4.5005
R2035 VDD.n2401 VDD.n1144 4.5005
R2036 VDD.n1144 VDD.n1143 4.5005
R2037 VDD.n2428 VDD.n1129 4.5005
R2038 VDD.n1129 VDD.n1128 4.5005
R2039 VDD.n2437 VDD.n1124 4.5005
R2040 VDD.n1124 VDD.n1123 4.5005
R2041 VDD.n2451 VDD.n847 4.5005
R2042 VDD.n2451 VDD.n2450 4.5005
R2043 VDD.n1114 VDD.n851 4.5005
R2044 VDD.n1114 VDD.n1113 4.5005
R2045 VDD.n4002 VDD.n137 4.5005
R2046 VDD.n4002 VDD.n4001 4.5005
R2047 VDD.n2940 VDD.n2630 4.5005
R2048 VDD.n2630 VDD.n2629 4.5005
R2049 VDD.n633 VDD.n630 4.5005
R2050 VDD.n2823 VDD.n2822 4.5005
R2051 VDD.n3429 VDD.n3313 4.5005
R2052 VDD.n3377 VDD.n3376 4.5005
R2053 VDD.n3241 VDD.n3237 4.5005
R2054 VDD.n4006 VDD.n4005 4.5005
R2055 VDD.n134 VDD.n133 4.5005
R2056 VDD.n854 VDD.n853 4.5005
R2057 VDD.n1106 VDD.n1105 4.5005
R2058 VDD.n4138 VDD.n66 4.5005
R2059 VDD.n4141 VDD.n67 4.5005
R2060 VDD.n4142 VDD.n4141 4.5005
R2061 VDD.n4140 VDD.n4139 4.5005
R2062 VDD.n68 VDD.n64 4.5005
R2063 VDD.n68 VDD.n65 4.5005
R2064 VDD.n4137 VDD.n62 4.5005
R2065 VDD.n4144 VDD.n63 4.5005
R2066 VDD.n4144 VDD.n4143 4.5005
R2067 VDD.n4113 VDD.n4110 4.5005
R2068 VDD.n4114 VDD.n4113 4.5005
R2069 VDD.n4112 VDD.n4111 4.5005
R2070 VDD.n80 VDD.n78 4.5005
R2071 VDD.n4109 VDD.n78 4.5005
R2072 VDD.n4118 VDD.n4117 4.5005
R2073 VDD.n4116 VDD.n79 4.5005
R2074 VDD.n4116 VDD.n4115 4.5005
R2075 VDD.n4145 VDD.n56 4.5005
R2076 VDD.n4160 VDD.n4159 4.5005
R2077 VDD.n53 VDD.n50 4.5005
R2078 VDD.n55 VDD.n50 4.5005
R2079 VDD.n2343 VDD.n1170 4.5005
R2080 VDD.n2347 VDD.n2344 4.5005
R2081 VDD.n2348 VDD.n2347 4.5005
R2082 VDD.n2336 VDD.n2333 4.5005
R2083 VDD.n2337 VDD.n2336 4.5005
R2084 VDD.n2737 VDD.n2736 4.5005
R2085 VDD.n2736 VDD.n2731 4.5005
R2086 VDD.n2749 VDD.n2729 4.5005
R2087 VDD.n2750 VDD.n2749 4.5005
R2088 VDD.n3444 VDD.n3438 4.5005
R2089 VDD.n3445 VDD.n3444 4.5005
R2090 VDD.n3322 VDD.n3319 4.5005
R2091 VDD.n3357 VDD.n3319 4.5005
R2092 VDD.n3245 VDD.n3242 4.5005
R2093 VDD.n3535 VDD.n3242 4.5005
R2094 VDD.n2715 VDD.n2712 4.5005
R2095 VDD.n642 VDD.n636 4.5005
R2096 VDD.n641 VDD.n636 4.5005
R2097 VDD.n2799 VDD.n2798 4.5005
R2098 VDD.n2628 VDD.n2627 4.5005
R2099 VDD.n1089 VDD.n138 4.5005
R2100 VDD.n2462 VDD.n836 4.5005
R2101 VDD.n2456 VDD.n2455 4.5005
R2102 VDD.n1938 VDD.n1195 4.5005
R2103 VDD.n2746 VDD.n2707 4.5005
R2104 VDD.n2740 VDD.n2702 4.5005
R2105 VDD.n2314 VDD.n2311 4.5005
R2106 VDD.n2315 VDD.n2314 4.5005
R2107 VDD.n2310 VDD.n1185 4.5005
R2108 VDD.n4149 VDD.n4146 4.5005
R2109 VDD.n4150 VDD.n4149 4.5005
R2110 VDD.n2332 VDD.n1175 4.5005
R2111 VDD.n2321 VDD.n1180 4.5005
R2112 VDD.n2325 VDD.n2322 4.5005
R2113 VDD.n2326 VDD.n2325 4.5005
R2114 VDD.n1949 VDD.n1190 4.5005
R2115 VDD.n1953 VDD.n1950 4.5005
R2116 VDD.n1954 VDD.n1953 4.5005
R2117 VDD.n1942 VDD.n1939 4.5005
R2118 VDD.n1943 VDD.n1942 4.5005
R2119 VDD.n2454 VDD.n2453 4.5005
R2120 VDD.n2454 VDD.n839 4.5005
R2121 VDD.n2465 VDD.n837 4.5005
R2122 VDD.n2466 VDD.n2465 4.5005
R2123 VDD.n1097 VDD.n1094 4.5005
R2124 VDD.n1098 VDD.n1097 4.5005
R2125 VDD.n741 VDD.n738 4.5005
R2126 VDD.n2620 VDD.n738 4.5005
R2127 VDD.n3780 VDD.n3779 4.5005
R2128 VDD.n2793 VDD.n2712 4.5005
R2129 VDD.n3441 VDD.n3437 4.5005
R2130 VDD.n3363 VDD.n3362 4.5005
R2131 VDD.n3540 VDD.n3539 4.5005
R2132 VDD.n4148 VDD.n4147 4.5005
R2133 VDD.n4158 VDD.n4157 4.5005
R2134 VDD.n4156 VDD.n54 4.5005
R2135 VDD.n4156 VDD.n4155 4.5005
R2136 VDD.n2346 VDD.n2345 4.5005
R2137 VDD.n1174 VDD.n1171 4.5005
R2138 VDD.n2342 VDD.n1171 4.5005
R2139 VDD.n1179 VDD.n1176 4.5005
R2140 VDD.n2331 VDD.n1176 4.5005
R2141 VDD.n2743 VDD.n2733 4.5005
R2142 VDD.n2744 VDD.n2743 4.5005
R2143 VDD.n2730 VDD.n2727 4.5005
R2144 VDD.n2730 VDD.n2728 4.5005
R2145 VDD.n3439 VDD.n3311 4.5005
R2146 VDD.n3439 VDD.n3312 4.5005
R2147 VDD.n3359 VDD.n3323 4.5005
R2148 VDD.n3359 VDD.n3358 4.5005
R2149 VDD.n3536 VDD.n3246 4.5005
R2150 VDD.n2795 VDD.n2716 4.5005
R2151 VDD.n3776 VDD.n639 4.5005
R2152 VDD.n3776 VDD.n3775 4.5005
R2153 VDD.n2797 VDD.n2796 4.5005
R2154 VDD.n2626 VDD.n2625 4.5005
R2155 VDD.n1096 VDD.n1095 4.5005
R2156 VDD.n2464 VDD.n2463 4.5005
R2157 VDD.n845 VDD.n840 4.5005
R2158 VDD.n1941 VDD.n1940 4.5005
R2159 VDD.n2748 VDD.n2747 4.5005
R2160 VDD.n2739 VDD.n2732 4.5005
R2161 VDD.n1189 VDD.n1186 4.5005
R2162 VDD.n1959 VDD.n1186 4.5005
R2163 VDD.n2313 VDD.n2312 4.5005
R2164 VDD.n60 VDD.n57 4.5005
R2165 VDD.n61 VDD.n57 4.5005
R2166 VDD.n2335 VDD.n2334 4.5005
R2167 VDD.n2324 VDD.n2323 4.5005
R2168 VDD.n1184 VDD.n1181 4.5005
R2169 VDD.n2320 VDD.n1181 4.5005
R2170 VDD.n1952 VDD.n1951 4.5005
R2171 VDD.n1194 VDD.n1191 4.5005
R2172 VDD.n1948 VDD.n1191 4.5005
R2173 VDD.n1937 VDD.n1196 4.5005
R2174 VDD.n1196 VDD.n844 4.5005
R2175 VDD.n2459 VDD.n841 4.5005
R2176 VDD.n2460 VDD.n2459 4.5005
R2177 VDD.n838 VDD.n834 4.5005
R2178 VDD.n838 VDD.n835 4.5005
R2179 VDD.n1092 VDD.n1090 4.5005
R2180 VDD.n1093 VDD.n1090 4.5005
R2181 VDD.n2624 VDD.n742 4.5005
R2182 VDD.n2624 VDD.n726 4.5005
R2183 VDD.n3778 VDD.n3777 4.5005
R2184 VDD.n2795 VDD.n2794 4.5005
R2185 VDD.n3443 VDD.n3442 4.5005
R2186 VDD.n3361 VDD.n3360 4.5005
R2187 VDD.n3538 VDD.n3537 4.5005
R2188 VDD.n4154 VDD.n4153 4.5005
R2189 VDD.n1720 VDD.n52 4.5005
R2190 VDD.n1720 VDD.n1719 4.5005
R2191 VDD.n2352 VDD.n2351 4.5005
R2192 VDD.n2350 VDD.n1172 4.5005
R2193 VDD.n2350 VDD.n2349 4.5005
R2194 VDD.n2738 VDD.n2735 4.5005
R2195 VDD.n2735 VDD.n2734 4.5005
R2196 VDD.n2752 VDD.n2726 4.5005
R2197 VDD.n2752 VDD.n2751 4.5005
R2198 VDD.n3447 VDD.n3310 4.5005
R2199 VDD.n3447 VDD.n3446 4.5005
R2200 VDD.n3355 VDD.n3321 4.5005
R2201 VDD.n3356 VDD.n3355 4.5005
R2202 VDD.n3533 VDD.n3244 4.5005
R2203 VDD.n3534 VDD.n3533 4.5005
R2204 VDD.n2791 VDD.n2714 4.5005
R2205 VDD.n3774 VDD.n3773 4.5005
R2206 VDD.n3773 VDD.n638 4.5005
R2207 VDD.n2717 VDD.n2713 4.5005
R2208 VDD.n2623 VDD.n739 4.5005
R2209 VDD.n1102 VDD.n1101 4.5005
R2210 VDD.n2461 VDD.n832 4.5005
R2211 VDD.n2745 VDD.n2725 4.5005
R2212 VDD.n2742 VDD.n2741 4.5005
R2213 VDD.n2458 VDD.n2457 4.5005
R2214 VDD.n1947 VDD.n1946 4.5005
R2215 VDD.n1958 VDD.n1957 4.5005
R2216 VDD.n2317 VDD.n1187 4.5005
R2217 VDD.n2317 VDD.n2316 4.5005
R2218 VDD.n2330 VDD.n2329 4.5005
R2219 VDD.n2328 VDD.n1182 4.5005
R2220 VDD.n2328 VDD.n2327 4.5005
R2221 VDD.n2319 VDD.n2318 4.5005
R2222 VDD.n4152 VDD.n58 4.5005
R2223 VDD.n4152 VDD.n4151 4.5005
R2224 VDD.n2341 VDD.n2340 4.5005
R2225 VDD.n2339 VDD.n1177 4.5005
R2226 VDD.n2339 VDD.n2338 4.5005
R2227 VDD.n1956 VDD.n1192 4.5005
R2228 VDD.n1956 VDD.n1955 4.5005
R2229 VDD.n1945 VDD.n1197 4.5005
R2230 VDD.n1945 VDD.n1944 4.5005
R2231 VDD.n2452 VDD.n843 4.5005
R2232 VDD.n843 VDD.n842 4.5005
R2233 VDD.n2468 VDD.n833 4.5005
R2234 VDD.n2468 VDD.n2467 4.5005
R2235 VDD.n1100 VDD.n1091 4.5005
R2236 VDD.n1100 VDD.n1099 4.5005
R2237 VDD.n2622 VDD.n740 4.5005
R2238 VDD.n2622 VDD.n2621 4.5005
R2239 VDD.n640 VDD.n637 4.5005
R2240 VDD.n2792 VDD.n2791 4.5005
R2241 VDD.n3440 VDD.n3309 4.5005
R2242 VDD.n3324 VDD.n3320 4.5005
R2243 VDD.n3247 VDD.n3243 4.5005
R2244 VDD.n1104 VDD.n1103 4.5005
R2245 VDD.n1088 VDD.n855 4.5005
R2246 VDD.n1087 VDD.n1086 4.5005
R2247 VDD.n1085 VDD.n856 4.5005
R2248 VDD.n2369 VDD.n2368 4.5005
R2249 VDD.n1161 VDD.n1158 4.5005
R2250 VDD.n1164 VDD.n1158 4.5005
R2251 VDD.n2367 VDD.n2366 4.5005
R2252 VDD.n2365 VDD.n1162 4.5005
R2253 VDD.n2365 VDD.n2364 4.5005
R2254 VDD.n1163 VDD.n1159 4.5005
R2255 VDD.n1740 VDD.n1160 4.5005
R2256 VDD.n1740 VDD.n1739 4.5005
R2257 VDD.n2376 VDD.n84 4.5005
R2258 VDD.n2373 VDD.n2372 4.5005
R2259 VDD.n2372 VDD.n1155 4.5005
R2260 VDD.n2375 VDD.n1156 4.5005
R2261 VDD.n2379 VDD.n1157 4.5005
R2262 VDD.n2380 VDD.n2379 4.5005
R2263 VDD.n2378 VDD.n2377 4.5005
R2264 VDD.n2374 VDD.n2371 4.5005
R2265 VDD.n2371 VDD.n2370 4.5005
R2266 VDD.n4103 VDD.n4100 4.5005
R2267 VDD.n4104 VDD.n4103 4.5005
R2268 VDD.n4102 VDD.n4101 4.5005
R2269 VDD.n85 VDD.n82 4.5005
R2270 VDD.n4099 VDD.n82 4.5005
R2271 VDD.n4108 VDD.n4107 4.5005
R2272 VDD.n4106 VDD.n83 4.5005
R2273 VDD.n4106 VDD.n4105 4.5005
R2274 VDD.n1745 VDD.n1744 4.5005
R2275 VDD.n1733 VDD.n59 4.5005
R2276 VDD.n1725 VDD.n1724 4.5005
R2277 VDD.n1723 VDD.n1722 4.5005
R2278 VDD.n1723 VDD.n1314 4.5005
R2279 VDD.n1763 VDD.n1173 4.5005
R2280 VDD.n1760 VDD.n1759 4.5005
R2281 VDD.n1759 VDD.n1294 4.5005
R2282 VDD.n1769 VDD.n1768 4.5005
R2283 VDD.n1768 VDD.n1289 4.5005
R2284 VDD.n2987 VDD.n705 4.5005
R2285 VDD.n2988 VDD.n2987 4.5005
R2286 VDD.n2755 VDD.n2754 4.5005
R2287 VDD.n2755 VDD.n2719 4.5005
R2288 VDD.n3455 VDD.n3449 4.5005
R2289 VDD.n3456 VDD.n3455 4.5005
R2290 VDD.n3328 VDD.n3325 4.5005
R2291 VDD.n3348 VDD.n3325 4.5005
R2292 VDD.n3251 VDD.n3248 4.5005
R2293 VDD.n3527 VDD.n3248 4.5005
R2294 VDD.n2764 VDD.n2718 4.5005
R2295 VDD.n649 VDD.n643 4.5005
R2296 VDD.n648 VDD.n643 4.5005
R2297 VDD.n2790 VDD.n2789 4.5005
R2298 VDD.n2619 VDD.n2618 4.5005
R2299 VDD.n2479 VDD.n822 4.5005
R2300 VDD.n2473 VDD.n2472 4.5005
R2301 VDD.n1921 VDD.n1205 4.5005
R2302 VDD.n1936 VDD.n1935 4.5005
R2303 VDD.n2757 VDD.n2756 4.5005
R2304 VDD.n2984 VDD.n704 4.5005
R2305 VDD.n1787 VDD.n1786 4.5005
R2306 VDD.n1786 VDD.n1279 4.5005
R2307 VDD.n1790 VDD.n1188 4.5005
R2308 VDD.n1730 VDD.n1729 4.5005
R2309 VDD.n1729 VDD.n1309 4.5005
R2310 VDD.n1743 VDD.n1742 4.5005
R2311 VDD.n1743 VDD.n1304 4.5005
R2312 VDD.n1772 VDD.n1178 4.5005
R2313 VDD.n1781 VDD.n1183 4.5005
R2314 VDD.n1778 VDD.n1777 4.5005
R2315 VDD.n1777 VDD.n1284 4.5005
R2316 VDD.n1796 VDD.n1193 4.5005
R2317 VDD.n1799 VDD.n1277 4.5005
R2318 VDD.n1800 VDD.n1799 4.5005
R2319 VDD.n1201 VDD.n1198 4.5005
R2320 VDD.n1204 VDD.n1198 4.5005
R2321 VDD.n1925 VDD.n1922 4.5005
R2322 VDD.n1926 VDD.n1925 4.5005
R2323 VDD.n2471 VDD.n2470 4.5005
R2324 VDD.n2471 VDD.n825 4.5005
R2325 VDD.n2482 VDD.n823 4.5005
R2326 VDD.n2483 VDD.n2482 4.5005
R2327 VDD.n746 VDD.n743 4.5005
R2328 VDD.n749 VDD.n743 4.5005
R2329 VDD.n3772 VDD.n3771 4.5005
R2330 VDD.n2784 VDD.n2718 4.5005
R2331 VDD.n3452 VDD.n3448 4.5005
R2332 VDD.n3354 VDD.n3353 4.5005
R2333 VDD.n3532 VDD.n3531 4.5005
R2334 VDD.n1738 VDD.n1305 4.5005
R2335 VDD.n1732 VDD.n1310 4.5005
R2336 VDD.n1718 VDD.n1315 4.5005
R2337 VDD.n1727 VDD.n1316 4.5005
R2338 VDD.n1728 VDD.n1727 4.5005
R2339 VDD.n1762 VDD.n1295 4.5005
R2340 VDD.n1766 VDD.n1296 4.5005
R2341 VDD.n1767 VDD.n1766 4.5005
R2342 VDD.n1775 VDD.n1291 4.5005
R2343 VDD.n1776 VDD.n1775 4.5005
R2344 VDD.n706 VDD.n702 4.5005
R2345 VDD.n706 VDD.n703 4.5005
R2346 VDD.n2760 VDD.n2721 4.5005
R2347 VDD.n2761 VDD.n2760 4.5005
R2348 VDD.n3450 VDD.n3307 4.5005
R2349 VDD.n3450 VDD.n3308 4.5005
R2350 VDD.n3350 VDD.n3329 4.5005
R2351 VDD.n3350 VDD.n3349 4.5005
R2352 VDD.n3528 VDD.n3252 4.5005
R2353 VDD.n2786 VDD.n2765 4.5005
R2354 VDD.n3768 VDD.n646 4.5005
R2355 VDD.n3768 VDD.n3767 4.5005
R2356 VDD.n2788 VDD.n2787 4.5005
R2357 VDD.n2617 VDD.n2616 4.5005
R2358 VDD.n2481 VDD.n2480 4.5005
R2359 VDD.n831 VDD.n826 4.5005
R2360 VDD.n1924 VDD.n1923 4.5005
R2361 VDD.n1934 VDD.n1933 4.5005
R2362 VDD.n2724 VDD.n2720 4.5005
R2363 VDD.n2986 VDD.n2985 4.5005
R2364 VDD.n1793 VDD.n1281 4.5005
R2365 VDD.n1794 VDD.n1793 4.5005
R2366 VDD.n1789 VDD.n1280 4.5005
R2367 VDD.n1736 VDD.n1311 4.5005
R2368 VDD.n1737 VDD.n1736 4.5005
R2369 VDD.n1748 VDD.n1306 4.5005
R2370 VDD.n1749 VDD.n1748 4.5005
R2371 VDD.n1771 VDD.n1290 4.5005
R2372 VDD.n1780 VDD.n1285 4.5005
R2373 VDD.n1784 VDD.n1286 4.5005
R2374 VDD.n1785 VDD.n1784 4.5005
R2375 VDD.n1798 VDD.n1797 4.5005
R2376 VDD.n1278 VDD.n1275 4.5005
R2377 VDD.n1278 VDD.n1276 4.5005
R2378 VDD.n1932 VDD.n1202 4.5005
R2379 VDD.n1932 VDD.n1931 4.5005
R2380 VDD.n1920 VDD.n1206 4.5005
R2381 VDD.n1206 VDD.n830 4.5005
R2382 VDD.n2476 VDD.n827 4.5005
R2383 VDD.n2477 VDD.n2476 4.5005
R2384 VDD.n824 VDD.n820 4.5005
R2385 VDD.n824 VDD.n821 4.5005
R2386 VDD.n2615 VDD.n747 4.5005
R2387 VDD.n2615 VDD.n2614 4.5005
R2388 VDD.n3770 VDD.n3769 4.5005
R2389 VDD.n2786 VDD.n2785 4.5005
R2390 VDD.n3454 VDD.n3453 4.5005
R2391 VDD.n3352 VDD.n3351 4.5005
R2392 VDD.n3530 VDD.n3529 4.5005
R2393 VDD.n1747 VDD.n1746 4.5005
R2394 VDD.n1735 VDD.n1734 4.5005
R2395 VDD.n1721 VDD.n1717 4.5005
R2396 VDD.n1717 VDD.n1716 4.5005
R2397 VDD.n1765 VDD.n1764 4.5005
R2398 VDD.n1761 VDD.n1298 4.5005
R2399 VDD.n1298 VDD.n1297 4.5005
R2400 VDD.n1770 VDD.n1293 4.5005
R2401 VDD.n1293 VDD.n1292 4.5005
R2402 VDD.n2990 VDD.n701 4.5005
R2403 VDD.n2990 VDD.n2989 4.5005
R2404 VDD.n2753 VDD.n2723 4.5005
R2405 VDD.n2723 VDD.n2722 4.5005
R2406 VDD.n3458 VDD.n3306 4.5005
R2407 VDD.n3458 VDD.n3457 4.5005
R2408 VDD.n3346 VDD.n3327 4.5005
R2409 VDD.n3347 VDD.n3346 4.5005
R2410 VDD.n3525 VDD.n3250 4.5005
R2411 VDD.n3526 VDD.n3525 4.5005
R2412 VDD.n2782 VDD.n2763 4.5005
R2413 VDD.n3766 VDD.n3765 4.5005
R2414 VDD.n3765 VDD.n645 4.5005
R2415 VDD.n2766 VDD.n2762 4.5005
R2416 VDD.n748 VDD.n744 4.5005
R2417 VDD.n2478 VDD.n818 4.5005
R2418 VDD.n2475 VDD.n2474 4.5005
R2419 VDD.n1930 VDD.n1929 4.5005
R2420 VDD.n1203 VDD.n1199 4.5005
R2421 VDD.n2759 VDD.n2758 4.5005
R2422 VDD.n2983 VDD.n700 4.5005
R2423 VDD.n1788 VDD.n1283 4.5005
R2424 VDD.n1283 VDD.n1282 4.5005
R2425 VDD.n1792 VDD.n1791 4.5005
R2426 VDD.n1731 VDD.n1313 4.5005
R2427 VDD.n1313 VDD.n1312 4.5005
R2428 VDD.n1741 VDD.n1308 4.5005
R2429 VDD.n1308 VDD.n1307 4.5005
R2430 VDD.n1774 VDD.n1773 4.5005
R2431 VDD.n1783 VDD.n1782 4.5005
R2432 VDD.n1779 VDD.n1288 4.5005
R2433 VDD.n1288 VDD.n1287 4.5005
R2434 VDD.n1795 VDD.n1273 4.5005
R2435 VDD.n1802 VDD.n1274 4.5005
R2436 VDD.n1802 VDD.n1801 4.5005
R2437 VDD.n1262 VDD.n1200 4.5005
R2438 VDD.n1262 VDD.n1261 4.5005
R2439 VDD.n1928 VDD.n1207 4.5005
R2440 VDD.n1928 VDD.n1927 4.5005
R2441 VDD.n2469 VDD.n829 4.5005
R2442 VDD.n829 VDD.n828 4.5005
R2443 VDD.n2485 VDD.n819 4.5005
R2444 VDD.n2485 VDD.n2484 4.5005
R2445 VDD.n807 VDD.n745 4.5005
R2446 VDD.n807 VDD.n806 4.5005
R2447 VDD.n647 VDD.n644 4.5005
R2448 VDD.n2783 VDD.n2782 4.5005
R2449 VDD.n3451 VDD.n3305 4.5005
R2450 VDD.n3330 VDD.n3326 4.5005
R2451 VDD.n3253 VDD.n3249 4.5005
R2452 VDD.n1754 VDD.n1168 4.5005
R2453 VDD.n1751 VDD.n1750 4.5005
R2454 VDD.n1750 VDD.n1299 4.5005
R2455 VDD.n1753 VDD.n1300 4.5005
R2456 VDD.n1757 VDD.n1301 4.5005
R2457 VDD.n1758 VDD.n1757 4.5005
R2458 VDD.n1756 VDD.n1755 4.5005
R2459 VDD.n1752 VDD.n1303 4.5005
R2460 VDD.n1303 VDD.n1302 4.5005
R2461 VDD.n2354 VDD.n1165 4.5005
R2462 VDD.n2358 VDD.n2355 4.5005
R2463 VDD.n2359 VDD.n2358 4.5005
R2464 VDD.n2357 VDD.n2356 4.5005
R2465 VDD.n1169 VDD.n1166 4.5005
R2466 VDD.n2353 VDD.n1166 4.5005
R2467 VDD.n2363 VDD.n2362 4.5005
R2468 VDD.n2361 VDD.n1167 4.5005
R2469 VDD.n2361 VDD.n2360 4.5005
R2470 VDD.n2385 VDD.n89 4.5005
R2471 VDD.n2382 VDD.n2381 4.5005
R2472 VDD.n2381 VDD.n1150 4.5005
R2473 VDD.n2384 VDD.n1151 4.5005
R2474 VDD.n2388 VDD.n1152 4.5005
R2475 VDD.n2389 VDD.n2388 4.5005
R2476 VDD.n2387 VDD.n2386 4.5005
R2477 VDD.n2383 VDD.n1154 4.5005
R2478 VDD.n1154 VDD.n1153 4.5005
R2479 VDD.n4093 VDD.n4090 4.5005
R2480 VDD.n4094 VDD.n4093 4.5005
R2481 VDD.n4092 VDD.n4091 4.5005
R2482 VDD.n90 VDD.n87 4.5005
R2483 VDD.n4089 VDD.n87 4.5005
R2484 VDD.n4098 VDD.n4097 4.5005
R2485 VDD.n4096 VDD.n88 4.5005
R2486 VDD.n4096 VDD.n4095 4.5005
R2487 VDD.n1678 VDD.n1333 4.5005
R2488 VDD.n1689 VDD.n1328 4.5005
R2489 VDD.n1700 VDD.n1323 4.5005
R2490 VDD.n1715 VDD.n1714 4.5005
R2491 VDD.n1320 VDD.n1317 4.5005
R2492 VDD.n1322 VDD.n1317 4.5005
R2493 VDD.n1667 VDD.n1338 4.5005
R2494 VDD.n1671 VDD.n1668 4.5005
R2495 VDD.n1672 VDD.n1671 4.5005
R2496 VDD.n1660 VDD.n1657 4.5005
R2497 VDD.n1661 VDD.n1660 4.5005
R2498 VDD.n2993 VDD.n2992 4.5005
R2499 VDD.n2993 VDD.n693 4.5005
R2500 VDD.n3004 VDD.n691 4.5005
R2501 VDD.n3005 VDD.n3004 4.5005
R2502 VDD.n3466 VDD.n3460 4.5005
R2503 VDD.n3467 VDD.n3466 4.5005
R2504 VDD.n3334 VDD.n3331 4.5005
R2505 VDD.n3339 VDD.n3331 4.5005
R2506 VDD.n3257 VDD.n3254 4.5005
R2507 VDD.n3519 VDD.n3254 4.5005
R2508 VDD.n2770 VDD.n2767 4.5005
R2509 VDD.n656 VDD.n650 4.5005
R2510 VDD.n655 VDD.n650 4.5005
R2511 VDD.n2781 VDD.n2780 4.5005
R2512 VDD.n2496 VDD.n808 4.5005
R2513 VDD.n2490 VDD.n2489 4.5005
R2514 VDD.n1904 VDD.n1215 4.5005
R2515 VDD.n1919 VDD.n1918 4.5005
R2516 VDD.n1813 VDD.n1263 4.5005
R2517 VDD.n3001 VDD.n690 4.5005
R2518 VDD.n2995 VDD.n2994 4.5005
R2519 VDD.n1638 VDD.n1635 4.5005
R2520 VDD.n1639 VDD.n1638 4.5005
R2521 VDD.n1634 VDD.n1353 4.5005
R2522 VDD.n1704 VDD.n1701 4.5005
R2523 VDD.n1705 VDD.n1704 4.5005
R2524 VDD.n1693 VDD.n1690 4.5005
R2525 VDD.n1694 VDD.n1693 4.5005
R2526 VDD.n1682 VDD.n1679 4.5005
R2527 VDD.n1683 VDD.n1682 4.5005
R2528 VDD.n1656 VDD.n1343 4.5005
R2529 VDD.n1645 VDD.n1348 4.5005
R2530 VDD.n1649 VDD.n1646 4.5005
R2531 VDD.n1650 VDD.n1649 4.5005
R2532 VDD.n1807 VDD.n1806 4.5005
R2533 VDD.n1805 VDD.n1804 4.5005
R2534 VDD.n1805 VDD.n1266 4.5005
R2535 VDD.n1816 VDD.n1264 4.5005
R2536 VDD.n1817 VDD.n1816 4.5005
R2537 VDD.n1211 VDD.n1208 4.5005
R2538 VDD.n1214 VDD.n1208 4.5005
R2539 VDD.n1908 VDD.n1905 4.5005
R2540 VDD.n1909 VDD.n1908 4.5005
R2541 VDD.n2488 VDD.n2487 4.5005
R2542 VDD.n2488 VDD.n811 4.5005
R2543 VDD.n2499 VDD.n809 4.5005
R2544 VDD.n2500 VDD.n2499 4.5005
R2545 VDD.n3764 VDD.n3763 4.5005
R2546 VDD.n2775 VDD.n2767 4.5005
R2547 VDD.n3463 VDD.n3459 4.5005
R2548 VDD.n3345 VDD.n3344 4.5005
R2549 VDD.n3524 VDD.n3523 4.5005
R2550 VDD.n1681 VDD.n1680 4.5005
R2551 VDD.n1692 VDD.n1691 4.5005
R2552 VDD.n1703 VDD.n1702 4.5005
R2553 VDD.n1713 VDD.n1712 4.5005
R2554 VDD.n1711 VDD.n1321 4.5005
R2555 VDD.n1711 VDD.n1710 4.5005
R2556 VDD.n1670 VDD.n1669 4.5005
R2557 VDD.n1342 VDD.n1339 4.5005
R2558 VDD.n1666 VDD.n1339 4.5005
R2559 VDD.n1347 VDD.n1344 4.5005
R2560 VDD.n1655 VDD.n1344 4.5005
R2561 VDD.n2998 VDD.n695 4.5005
R2562 VDD.n2999 VDD.n2998 4.5005
R2563 VDD.n692 VDD.n688 4.5005
R2564 VDD.n692 VDD.n689 4.5005
R2565 VDD.n3461 VDD.n3303 4.5005
R2566 VDD.n3461 VDD.n3304 4.5005
R2567 VDD.n3341 VDD.n3335 4.5005
R2568 VDD.n3341 VDD.n3340 4.5005
R2569 VDD.n3520 VDD.n3258 4.5005
R2570 VDD.n2777 VDD.n2771 4.5005
R2571 VDD.n3760 VDD.n653 4.5005
R2572 VDD.n3760 VDD.n3759 4.5005
R2573 VDD.n2779 VDD.n2778 4.5005
R2574 VDD.n2498 VDD.n2497 4.5005
R2575 VDD.n817 VDD.n812 4.5005
R2576 VDD.n1907 VDD.n1906 4.5005
R2577 VDD.n1917 VDD.n1916 4.5005
R2578 VDD.n1815 VDD.n1814 4.5005
R2579 VDD.n3003 VDD.n3002 4.5005
R2580 VDD.n699 VDD.n694 4.5005
R2581 VDD.n1633 VDD.n1354 4.5005
R2582 VDD.n1354 VDD.n1271 4.5005
R2583 VDD.n1637 VDD.n1636 4.5005
R2584 VDD.n1327 VDD.n1324 4.5005
R2585 VDD.n1699 VDD.n1324 4.5005
R2586 VDD.n1332 VDD.n1329 4.5005
R2587 VDD.n1688 VDD.n1329 4.5005
R2588 VDD.n1337 VDD.n1334 4.5005
R2589 VDD.n1677 VDD.n1334 4.5005
R2590 VDD.n1659 VDD.n1658 4.5005
R2591 VDD.n1648 VDD.n1647 4.5005
R2592 VDD.n1352 VDD.n1349 4.5005
R2593 VDD.n1644 VDD.n1349 4.5005
R2594 VDD.n1272 VDD.n1267 4.5005
R2595 VDD.n1810 VDD.n1268 4.5005
R2596 VDD.n1811 VDD.n1810 4.5005
R2597 VDD.n1265 VDD.n1259 4.5005
R2598 VDD.n1265 VDD.n1260 4.5005
R2599 VDD.n1915 VDD.n1212 4.5005
R2600 VDD.n1915 VDD.n1914 4.5005
R2601 VDD.n1903 VDD.n1216 4.5005
R2602 VDD.n1216 VDD.n816 4.5005
R2603 VDD.n2493 VDD.n813 4.5005
R2604 VDD.n2494 VDD.n2493 4.5005
R2605 VDD.n810 VDD.n804 4.5005
R2606 VDD.n810 VDD.n805 4.5005
R2607 VDD.n3762 VDD.n3761 4.5005
R2608 VDD.n2777 VDD.n2776 4.5005
R2609 VDD.n3465 VDD.n3464 4.5005
R2610 VDD.n3343 VDD.n3342 4.5005
R2611 VDD.n3522 VDD.n3521 4.5005
R2612 VDD.n1687 VDD.n1686 4.5005
R2613 VDD.n1698 VDD.n1697 4.5005
R2614 VDD.n1709 VDD.n1708 4.5005
R2615 VDD.n1505 VDD.n1319 4.5005
R2616 VDD.n1505 VDD.n1504 4.5005
R2617 VDD.n1676 VDD.n1675 4.5005
R2618 VDD.n1674 VDD.n1340 4.5005
R2619 VDD.n1674 VDD.n1673 4.5005
R2620 VDD.n1663 VDD.n1345 4.5005
R2621 VDD.n1663 VDD.n1662 4.5005
R2622 VDD.n2991 VDD.n697 4.5005
R2623 VDD.n697 VDD.n696 4.5005
R2624 VDD.n3007 VDD.n687 4.5005
R2625 VDD.n3007 VDD.n3006 4.5005
R2626 VDD.n3469 VDD.n3302 4.5005
R2627 VDD.n3469 VDD.n3468 4.5005
R2628 VDD.n3337 VDD.n3333 4.5005
R2629 VDD.n3338 VDD.n3337 4.5005
R2630 VDD.n3517 VDD.n3256 4.5005
R2631 VDD.n3518 VDD.n3517 4.5005
R2632 VDD.n2773 VDD.n2769 4.5005
R2633 VDD.n3758 VDD.n3757 4.5005
R2634 VDD.n3757 VDD.n652 4.5005
R2635 VDD.n2772 VDD.n2768 4.5005
R2636 VDD.n2495 VDD.n802 4.5005
R2637 VDD.n2492 VDD.n2491 4.5005
R2638 VDD.n1913 VDD.n1912 4.5005
R2639 VDD.n1213 VDD.n1209 4.5005
R2640 VDD.n1812 VDD.n1257 4.5005
R2641 VDD.n3000 VDD.n686 4.5005
R2642 VDD.n2997 VDD.n2996 4.5005
R2643 VDD.n1641 VDD.n1355 4.5005
R2644 VDD.n1641 VDD.n1640 4.5005
R2645 VDD.n1643 VDD.n1642 4.5005
R2646 VDD.n1707 VDD.n1325 4.5005
R2647 VDD.n1707 VDD.n1706 4.5005
R2648 VDD.n1696 VDD.n1330 4.5005
R2649 VDD.n1696 VDD.n1695 4.5005
R2650 VDD.n1685 VDD.n1335 4.5005
R2651 VDD.n1685 VDD.n1684 4.5005
R2652 VDD.n1665 VDD.n1664 4.5005
R2653 VDD.n1654 VDD.n1653 4.5005
R2654 VDD.n1652 VDD.n1350 4.5005
R2655 VDD.n1652 VDD.n1651 4.5005
R2656 VDD.n1809 VDD.n1808 4.5005
R2657 VDD.n1803 VDD.n1270 4.5005
R2658 VDD.n1270 VDD.n1269 4.5005
R2659 VDD.n1819 VDD.n1258 4.5005
R2660 VDD.n1819 VDD.n1818 4.5005
R2661 VDD.n1246 VDD.n1210 4.5005
R2662 VDD.n1246 VDD.n1245 4.5005
R2663 VDD.n1911 VDD.n1217 4.5005
R2664 VDD.n1911 VDD.n1910 4.5005
R2665 VDD.n2486 VDD.n815 4.5005
R2666 VDD.n815 VDD.n814 4.5005
R2667 VDD.n2502 VDD.n803 4.5005
R2668 VDD.n2502 VDD.n2501 4.5005
R2669 VDD.n654 VDD.n651 4.5005
R2670 VDD.n2774 VDD.n2773 4.5005
R2671 VDD.n3462 VDD.n3301 4.5005
R2672 VDD.n3336 VDD.n3332 4.5005
R2673 VDD.n3259 VDD.n3255 4.5005
R2674 VDD.n2602 VDD.n2601 4.5005
R2675 VDD.n756 VDD.n753 4.5005
R2676 VDD.n759 VDD.n753 4.5005
R2677 VDD.n2600 VDD.n2599 4.5005
R2678 VDD.n2598 VDD.n757 4.5005
R2679 VDD.n2598 VDD.n2597 4.5005
R2680 VDD.n758 VDD.n754 4.5005
R2681 VDD.n791 VDD.n755 4.5005
R2682 VDD.n791 VDD.n790 4.5005
R2683 VDD.n2604 VDD.n750 4.5005
R2684 VDD.n2608 VDD.n2605 4.5005
R2685 VDD.n2609 VDD.n2608 4.5005
R2686 VDD.n2607 VDD.n2606 4.5005
R2687 VDD.n2603 VDD.n751 4.5005
R2688 VDD.n751 VDD.n712 4.5005
R2689 VDD.n2613 VDD.n2612 4.5005
R2690 VDD.n2611 VDD.n752 4.5005
R2691 VDD.n2611 VDD.n2610 4.5005
R2692 VDD.n2961 VDD.n2960 4.5005
R2693 VDD.n2959 VDD.n2958 4.5005
R2694 VDD.n2959 VDD.n721 4.5005
R2695 VDD.n727 VDD.n722 4.5005
R2696 VDD.n2964 VDD.n723 4.5005
R2697 VDD.n2965 VDD.n2964 4.5005
R2698 VDD.n2963 VDD.n2962 4.5005
R2699 VDD.n2957 VDD.n725 4.5005
R2700 VDD.n725 VDD.n724 4.5005
R2701 VDD.n2950 VDD.n732 4.5005
R2702 VDD.n2953 VDD.n733 4.5005
R2703 VDD.n2954 VDD.n2953 4.5005
R2704 VDD.n2952 VDD.n2951 4.5005
R2705 VDD.n734 VDD.n730 4.5005
R2706 VDD.n734 VDD.n731 4.5005
R2707 VDD.n2949 VDD.n728 4.5005
R2708 VDD.n2956 VDD.n729 4.5005
R2709 VDD.n2956 VDD.n2955 4.5005
R2710 VDD.n2871 VDD.n2870 4.5005
R2711 VDD.n2681 VDD.n2678 4.5005
R2712 VDD.n2686 VDD.n2678 4.5005
R2713 VDD.n2869 VDD.n2868 4.5005
R2714 VDD.n2867 VDD.n2682 4.5005
R2715 VDD.n2867 VDD.n2866 4.5005
R2716 VDD.n2683 VDD.n2679 4.5005
R2717 VDD.n2684 VDD.n2680 4.5005
R2718 VDD.n2685 VDD.n2684 4.5005
R2719 VDD.n2912 VDD.n2911 4.5005
R2720 VDD.n2911 VDD.n2910 4.5005
R2721 VDD.n2907 VDD.n2906 4.5005
R2722 VDD.n2909 VDD.n2873 4.5005
R2723 VDD.n2872 VDD.n2677 4.5005
R2724 VDD.n2893 VDD.n2876 4.5005
R2725 VDD.n2894 VDD.n2893 4.5005
R2726 VDD.n2892 VDD.n2875 4.5005
R2727 VDD.n2891 VDD.n2874 4.5005
R2728 VDD.n2905 VDD.n2904 4.5005
R2729 VDD.n2513 VDD.n792 4.5005
R2730 VDD.n1536 VDD.n1336 4.5005
R2731 VDD.n1527 VDD.n1331 4.5005
R2732 VDD.n1518 VDD.n1326 4.5005
R2733 VDD.n1510 VDD.n1509 4.5005
R2734 VDD.n1508 VDD.n1507 4.5005
R2735 VDD.n1508 VDD.n1410 4.5005
R2736 VDD.n1545 VDD.n1341 4.5005
R2737 VDD.n1542 VDD.n1541 4.5005
R2738 VDD.n1541 VDD.n1390 4.5005
R2739 VDD.n1551 VDD.n1550 4.5005
R2740 VDD.n1550 VDD.n1385 4.5005
R2741 VDD.n2574 VDD.n2571 4.5005
R2742 VDD.n2575 VDD.n2574 4.5005
R2743 VDD.n3010 VDD.n3009 4.5005
R2744 VDD.n3010 VDD.n679 4.5005
R2745 VDD.n3472 VDD.n3471 4.5005
R2746 VDD.n3472 VDD.n3281 4.5005
R2747 VDD.n3483 VDD.n3279 4.5005
R2748 VDD.n3484 VDD.n3483 4.5005
R2749 VDD.n3263 VDD.n3260 4.5005
R2750 VDD.n3511 VDD.n3260 4.5005
R2751 VDD.n3021 VDD.n677 4.5005
R2752 VDD.n663 VDD.n657 4.5005
R2753 VDD.n662 VDD.n657 4.5005
R2754 VDD.n3018 VDD.n676 4.5005
R2755 VDD.n2507 VDD.n2506 4.5005
R2756 VDD.n1887 VDD.n1225 4.5005
R2757 VDD.n1902 VDD.n1901 4.5005
R2758 VDD.n1830 VDD.n1247 4.5005
R2759 VDD.n1824 VDD.n1823 4.5005
R2760 VDD.n3012 VDD.n3011 4.5005
R2761 VDD.n2570 VDD.n770 4.5005
R2762 VDD.n1359 VDD.n1356 4.5005
R2763 VDD.n1362 VDD.n1356 4.5005
R2764 VDD.n1632 VDD.n1631 4.5005
R2765 VDD.n1515 VDD.n1514 4.5005
R2766 VDD.n1514 VDD.n1405 4.5005
R2767 VDD.n1524 VDD.n1523 4.5005
R2768 VDD.n1523 VDD.n1400 4.5005
R2769 VDD.n1533 VDD.n1532 4.5005
R2770 VDD.n1532 VDD.n1395 4.5005
R2771 VDD.n1554 VDD.n1346 4.5005
R2772 VDD.n1560 VDD.n1351 4.5005
R2773 VDD.n1563 VDD.n1383 4.5005
R2774 VDD.n1564 VDD.n1563 4.5005
R2775 VDD.n1617 VDD.n1363 4.5005
R2776 VDD.n1621 VDD.n1618 4.5005
R2777 VDD.n1622 VDD.n1621 4.5005
R2778 VDD.n1822 VDD.n1821 4.5005
R2779 VDD.n1822 VDD.n1250 4.5005
R2780 VDD.n1833 VDD.n1248 4.5005
R2781 VDD.n1834 VDD.n1833 4.5005
R2782 VDD.n1221 VDD.n1218 4.5005
R2783 VDD.n1224 VDD.n1218 4.5005
R2784 VDD.n1891 VDD.n1888 4.5005
R2785 VDD.n1892 VDD.n1891 4.5005
R2786 VDD.n2505 VDD.n2504 4.5005
R2787 VDD.n2505 VDD.n795 4.5005
R2788 VDD.n2516 VDD.n793 4.5005
R2789 VDD.n2517 VDD.n2516 4.5005
R2790 VDD.n3756 VDD.n3755 4.5005
R2791 VDD.n3022 VDD.n3021 4.5005
R2792 VDD.n3474 VDD.n3473 4.5005
R2793 VDD.n3480 VDD.n3278 4.5005
R2794 VDD.n3516 VDD.n3515 4.5005
R2795 VDD.n2515 VDD.n2514 4.5005
R2796 VDD.n1535 VDD.n1396 4.5005
R2797 VDD.n1526 VDD.n1401 4.5005
R2798 VDD.n1517 VDD.n1406 4.5005
R2799 VDD.n1503 VDD.n1411 4.5005
R2800 VDD.n1512 VDD.n1412 4.5005
R2801 VDD.n1513 VDD.n1512 4.5005
R2802 VDD.n1544 VDD.n1391 4.5005
R2803 VDD.n1548 VDD.n1392 4.5005
R2804 VDD.n1549 VDD.n1548 4.5005
R2805 VDD.n1557 VDD.n1387 4.5005
R2806 VDD.n1558 VDD.n1557 4.5005
R2807 VDD.n2569 VDD.n771 4.5005
R2808 VDD.n771 VDD.n684 4.5005
R2809 VDD.n3015 VDD.n681 4.5005
R2810 VDD.n3016 VDD.n3015 4.5005
R2811 VDD.n3477 VDD.n3283 4.5005
R2812 VDD.n3478 VDD.n3477 4.5005
R2813 VDD.n3280 VDD.n3276 4.5005
R2814 VDD.n3280 VDD.n3277 4.5005
R2815 VDD.n3512 VDD.n3264 4.5005
R2816 VDD.n678 VDD.n674 4.5005
R2817 VDD.n3752 VDD.n660 4.5005
R2818 VDD.n3752 VDD.n3751 4.5005
R2819 VDD.n3020 VDD.n3019 4.5005
R2820 VDD.n801 VDD.n796 4.5005
R2821 VDD.n1890 VDD.n1889 4.5005
R2822 VDD.n1900 VDD.n1899 4.5005
R2823 VDD.n1832 VDD.n1831 4.5005
R2824 VDD.n1256 VDD.n1251 4.5005
R2825 VDD.n685 VDD.n680 4.5005
R2826 VDD.n2573 VDD.n2572 4.5005
R2827 VDD.n1628 VDD.n1360 4.5005
R2828 VDD.n1628 VDD.n1627 4.5005
R2829 VDD.n1630 VDD.n1629 4.5005
R2830 VDD.n1521 VDD.n1407 4.5005
R2831 VDD.n1522 VDD.n1521 4.5005
R2832 VDD.n1530 VDD.n1402 4.5005
R2833 VDD.n1531 VDD.n1530 4.5005
R2834 VDD.n1539 VDD.n1397 4.5005
R2835 VDD.n1540 VDD.n1539 4.5005
R2836 VDD.n1553 VDD.n1386 4.5005
R2837 VDD.n1562 VDD.n1561 4.5005
R2838 VDD.n1384 VDD.n1381 4.5005
R2839 VDD.n1384 VDD.n1382 4.5005
R2840 VDD.n1620 VDD.n1619 4.5005
R2841 VDD.n1616 VDD.n1364 4.5005
R2842 VDD.n1364 VDD.n1255 4.5005
R2843 VDD.n1827 VDD.n1252 4.5005
R2844 VDD.n1828 VDD.n1827 4.5005
R2845 VDD.n1249 VDD.n1243 4.5005
R2846 VDD.n1249 VDD.n1244 4.5005
R2847 VDD.n1898 VDD.n1222 4.5005
R2848 VDD.n1898 VDD.n1897 4.5005
R2849 VDD.n1886 VDD.n1226 4.5005
R2850 VDD.n1226 VDD.n800 4.5005
R2851 VDD.n2510 VDD.n797 4.5005
R2852 VDD.n2511 VDD.n2510 4.5005
R2853 VDD.n794 VDD.n788 4.5005
R2854 VDD.n794 VDD.n789 4.5005
R2855 VDD.n3754 VDD.n3753 4.5005
R2856 VDD.n678 VDD.n675 4.5005
R2857 VDD.n3300 VDD.n3282 4.5005
R2858 VDD.n3482 VDD.n3481 4.5005
R2859 VDD.n3514 VDD.n3513 4.5005
R2860 VDD.n2512 VDD.n786 4.5005
R2861 VDD.n1538 VDD.n1537 4.5005
R2862 VDD.n1529 VDD.n1528 4.5005
R2863 VDD.n1520 VDD.n1519 4.5005
R2864 VDD.n1506 VDD.n1502 4.5005
R2865 VDD.n1502 VDD.n1501 4.5005
R2866 VDD.n1547 VDD.n1546 4.5005
R2867 VDD.n1543 VDD.n1394 4.5005
R2868 VDD.n1394 VDD.n1393 4.5005
R2869 VDD.n1552 VDD.n1389 4.5005
R2870 VDD.n1389 VDD.n1388 4.5005
R2871 VDD.n2577 VDD.n772 4.5005
R2872 VDD.n2577 VDD.n2576 4.5005
R2873 VDD.n3008 VDD.n683 4.5005
R2874 VDD.n683 VDD.n682 4.5005
R2875 VDD.n3470 VDD.n3299 4.5005
R2876 VDD.n3299 VDD.n3298 4.5005
R2877 VDD.n3486 VDD.n3275 4.5005
R2878 VDD.n3486 VDD.n3485 4.5005
R2879 VDD.n3509 VDD.n3262 4.5005
R2880 VDD.n3510 VDD.n3509 4.5005
R2881 VDD.n3024 VDD.n673 4.5005
R2882 VDD.n3750 VDD.n3749 4.5005
R2883 VDD.n3749 VDD.n659 4.5005
R2884 VDD.n3017 VDD.n672 4.5005
R2885 VDD.n2509 VDD.n2508 4.5005
R2886 VDD.n1896 VDD.n1895 4.5005
R2887 VDD.n1223 VDD.n1219 4.5005
R2888 VDD.n1829 VDD.n1241 4.5005
R2889 VDD.n1826 VDD.n1825 4.5005
R2890 VDD.n3014 VDD.n3013 4.5005
R2891 VDD.n2579 VDD.n2578 4.5005
R2892 VDD.n1578 VDD.n1358 4.5005
R2893 VDD.n1578 VDD.n1577 4.5005
R2894 VDD.n1361 VDD.n1357 4.5005
R2895 VDD.n1516 VDD.n1409 4.5005
R2896 VDD.n1409 VDD.n1408 4.5005
R2897 VDD.n1525 VDD.n1404 4.5005
R2898 VDD.n1404 VDD.n1403 4.5005
R2899 VDD.n1534 VDD.n1399 4.5005
R2900 VDD.n1399 VDD.n1398 4.5005
R2901 VDD.n1556 VDD.n1555 4.5005
R2902 VDD.n1559 VDD.n1379 4.5005
R2903 VDD.n1566 VDD.n1380 4.5005
R2904 VDD.n1566 VDD.n1565 4.5005
R2905 VDD.n1626 VDD.n1625 4.5005
R2906 VDD.n1624 VDD.n1365 4.5005
R2907 VDD.n1624 VDD.n1623 4.5005
R2908 VDD.n1820 VDD.n1254 4.5005
R2909 VDD.n1254 VDD.n1253 4.5005
R2910 VDD.n1836 VDD.n1242 4.5005
R2911 VDD.n1836 VDD.n1835 4.5005
R2912 VDD.n1848 VDD.n1220 4.5005
R2913 VDD.n1848 VDD.n1847 4.5005
R2914 VDD.n1894 VDD.n1227 4.5005
R2915 VDD.n1894 VDD.n1893 4.5005
R2916 VDD.n2503 VDD.n799 4.5005
R2917 VDD.n799 VDD.n798 4.5005
R2918 VDD.n2519 VDD.n787 4.5005
R2919 VDD.n2519 VDD.n2518 4.5005
R2920 VDD.n661 VDD.n658 4.5005
R2921 VDD.n3024 VDD.n3023 4.5005
R2922 VDD.n3476 VDD.n3475 4.5005
R2923 VDD.n3479 VDD.n3274 4.5005
R2924 VDD.n3265 VDD.n3261 4.5005
R2925 VDD.n2585 VDD.n2584 4.5005
R2926 VDD.n766 VDD.n763 4.5005
R2927 VDD.n769 VDD.n763 4.5005
R2928 VDD.n2583 VDD.n2582 4.5005
R2929 VDD.n2581 VDD.n767 4.5005
R2930 VDD.n2581 VDD.n2580 4.5005
R2931 VDD.n768 VDD.n764 4.5005
R2932 VDD.n2531 VDD.n765 4.5005
R2933 VDD.n2531 VDD.n2530 4.5005
R2934 VDD.n2587 VDD.n760 4.5005
R2935 VDD.n2591 VDD.n2588 4.5005
R2936 VDD.n2592 VDD.n2591 4.5005
R2937 VDD.n2590 VDD.n2589 4.5005
R2938 VDD.n2586 VDD.n761 4.5005
R2939 VDD.n761 VDD.n698 4.5005
R2940 VDD.n2596 VDD.n2595 4.5005
R2941 VDD.n2594 VDD.n762 4.5005
R2942 VDD.n2594 VDD.n2593 4.5005
R2943 VDD.n2978 VDD.n2977 4.5005
R2944 VDD.n2976 VDD.n2975 4.5005
R2945 VDD.n2976 VDD.n707 4.5005
R2946 VDD.n713 VDD.n708 4.5005
R2947 VDD.n2981 VDD.n709 4.5005
R2948 VDD.n2982 VDD.n2981 4.5005
R2949 VDD.n2980 VDD.n2979 4.5005
R2950 VDD.n2974 VDD.n711 4.5005
R2951 VDD.n711 VDD.n710 4.5005
R2952 VDD.n2967 VDD.n718 4.5005
R2953 VDD.n2970 VDD.n719 4.5005
R2954 VDD.n2971 VDD.n2970 4.5005
R2955 VDD.n2969 VDD.n2968 4.5005
R2956 VDD.n720 VDD.n716 4.5005
R2957 VDD.n720 VDD.n717 4.5005
R2958 VDD.n2966 VDD.n714 4.5005
R2959 VDD.n2973 VDD.n715 4.5005
R2960 VDD.n2973 VDD.n2972 4.5005
R2961 VDD.n2854 VDD.n2853 4.5005
R2962 VDD.n2693 VDD.n2690 4.5005
R2963 VDD.n2698 VDD.n2690 4.5005
R2964 VDD.n2852 VDD.n2851 4.5005
R2965 VDD.n2850 VDD.n2694 4.5005
R2966 VDD.n2850 VDD.n2849 4.5005
R2967 VDD.n2695 VDD.n2691 4.5005
R2968 VDD.n2696 VDD.n2692 4.5005
R2969 VDD.n2697 VDD.n2696 4.5005
R2970 VDD.n2687 VDD.n496 4.5005
R2971 VDD.n2860 VDD.n2857 4.5005
R2972 VDD.n2861 VDD.n2860 4.5005
R2973 VDD.n2859 VDD.n2858 4.5005
R2974 VDD.n2855 VDD.n2688 4.5005
R2975 VDD.n2856 VDD.n2688 4.5005
R2976 VDD.n2865 VDD.n2864 4.5005
R2977 VDD.n2863 VDD.n2689 4.5005
R2978 VDD.n2863 VDD.n2862 4.5005
R2979 VDD.n3902 VDD.n492 4.5005
R2980 VDD.n3902 VDD.n3901 4.5005
R2981 VDD.n497 VDD.n493 4.5005
R2982 VDD.n3900 VDD.n3899 4.5005
R2983 VDD.n3898 VDD.n3897 4.5005
R2984 VDD.n3907 VDD.n488 4.5005
R2985 VDD.n3908 VDD.n3907 4.5005
R2986 VDD.n3906 VDD.n3905 4.5005
R2987 VDD.n489 VDD.n487 4.5005
R2988 VDD.n3904 VDD.n3903 4.5005
R2989 VDD.n2536 VDD.n2535 4.5005
R2990 VDD.n2524 VDD.n2523 4.5005
R2991 VDD.n1463 VDD.n1429 4.5005
R2992 VDD.n1474 VDD.n1425 4.5005
R2993 VDD.n1485 VDD.n1421 4.5005
R2994 VDD.n1500 VDD.n1499 4.5005
R2995 VDD.n1416 VDD.n1413 4.5005
R2996 VDD.n1420 VDD.n1413 4.5005
R2997 VDD.n1452 VDD.n1433 4.5005
R2998 VDD.n1456 VDD.n1453 4.5005
R2999 VDD.n1457 VDD.n1456 4.5005
R3000 VDD.n1445 VDD.n1442 4.5005
R3001 VDD.n1446 VDD.n1445 4.5005
R3002 VDD.n2543 VDD.n773 4.5005
R3003 VDD.n2548 VDD.n773 4.5005
R3004 VDD.n2557 VDD.n2554 4.5005
R3005 VDD.n2558 VDD.n2557 4.5005
R3006 VDD.n3287 VDD.n3284 4.5005
R3007 VDD.n3289 VDD.n3284 4.5005
R3008 VDD.n3489 VDD.n3488 4.5005
R3009 VDD.n3489 VDD.n3267 4.5005
R3010 VDD.n3498 VDD.n3266 4.5005
R3011 VDD.n3503 VDD.n3266 4.5005
R3012 VDD.n3027 VDD.n3026 4.5005
R3013 VDD.n3740 VDD.n664 4.5005
R3014 VDD.n3739 VDD.n664 4.5005
R3015 VDD.n3029 VDD.n3028 4.5005
R3016 VDD.n1870 VDD.n1866 4.5005
R3017 VDD.n1885 VDD.n1884 4.5005
R3018 VDD.n1853 VDD.n1852 4.5005
R3019 VDD.n1841 VDD.n1840 4.5005
R3020 VDD.n1600 VDD.n1596 4.5005
R3021 VDD.n2553 VDD.n2549 4.5005
R3022 VDD.n2568 VDD.n2567 4.5005
R3023 VDD.n1581 VDD.n1580 4.5005
R3024 VDD.n1581 VDD.n1367 4.5005
R3025 VDD.n1583 VDD.n1582 4.5005
R3026 VDD.n1489 VDD.n1486 4.5005
R3027 VDD.n1490 VDD.n1489 4.5005
R3028 VDD.n1478 VDD.n1475 4.5005
R3029 VDD.n1479 VDD.n1478 4.5005
R3030 VDD.n1467 VDD.n1464 4.5005
R3031 VDD.n1468 VDD.n1467 4.5005
R3032 VDD.n1441 VDD.n1437 4.5005
R3033 VDD.n1571 VDD.n1570 4.5005
R3034 VDD.n1569 VDD.n1568 4.5005
R3035 VDD.n1569 VDD.n1372 4.5005
R3036 VDD.n1615 VDD.n1614 4.5005
R3037 VDD.n1590 VDD.n1366 4.5005
R3038 VDD.n1595 VDD.n1366 4.5005
R3039 VDD.n1604 VDD.n1601 4.5005
R3040 VDD.n1605 VDD.n1604 4.5005
R3041 VDD.n1839 VDD.n1838 4.5005
R3042 VDD.n1839 VDD.n1234 4.5005
R3043 VDD.n1851 VDD.n1850 4.5005
R3044 VDD.n1851 VDD.n1229 4.5005
R3045 VDD.n1860 VDD.n1228 4.5005
R3046 VDD.n1865 VDD.n1228 4.5005
R3047 VDD.n1874 VDD.n1871 4.5005
R3048 VDD.n1875 VDD.n1874 4.5005
R3049 VDD.n2522 VDD.n2521 4.5005
R3050 VDD.n2522 VDD.n779 4.5005
R3051 VDD.n2534 VDD.n2533 4.5005
R3052 VDD.n2534 VDD.n774 4.5005
R3053 VDD.n3748 VDD.n3747 4.5005
R3054 VDD.n3027 VDD.n665 4.5005
R3055 VDD.n3297 VDD.n3296 4.5005
R3056 VDD.n3491 VDD.n3490 4.5005
R3057 VDD.n3508 VDD.n3507 4.5005
R3058 VDD.n2529 VDD.n775 4.5005
R3059 VDD.n785 VDD.n780 4.5005
R3060 VDD.n1466 VDD.n1465 4.5005
R3061 VDD.n1477 VDD.n1476 4.5005
R3062 VDD.n1488 VDD.n1487 4.5005
R3063 VDD.n1498 VDD.n1497 4.5005
R3064 VDD.n1496 VDD.n1417 4.5005
R3065 VDD.n1496 VDD.n1495 4.5005
R3066 VDD.n1455 VDD.n1454 4.5005
R3067 VDD.n1436 VDD.n1434 4.5005
R3068 VDD.n1451 VDD.n1434 4.5005
R3069 VDD.n1440 VDD.n1438 4.5005
R3070 VDD.n1438 VDD.n1377 4.5005
R3071 VDD.n2564 VDD.n2544 4.5005
R3072 VDD.n2564 VDD.n2563 4.5005
R3073 VDD.n2552 VDD.n2550 4.5005
R3074 VDD.n2550 VDD.n670 4.5005
R3075 VDD.n3293 VDD.n3288 4.5005
R3076 VDD.n3293 VDD.n3272 4.5005
R3077 VDD.n3494 VDD.n3269 4.5005
R3078 VDD.n3495 VDD.n3494 4.5005
R3079 VDD.n3504 VDD.n3499 4.5005
R3080 VDD.n3032 VDD.n667 4.5005
R3081 VDD.n3744 VDD.n3737 4.5005
R3082 VDD.n3744 VDD.n3743 4.5005
R3083 VDD.n671 VDD.n666 4.5005
R3084 VDD.n1873 VDD.n1872 4.5005
R3085 VDD.n1883 VDD.n1882 4.5005
R3086 VDD.n1846 VDD.n1230 4.5005
R3087 VDD.n1240 VDD.n1235 4.5005
R3088 VDD.n1603 VDD.n1602 4.5005
R3089 VDD.n2556 VDD.n2555 4.5005
R3090 VDD.n2566 VDD.n2565 4.5005
R3091 VDD.n1586 VDD.n1369 4.5005
R3092 VDD.n1587 VDD.n1586 4.5005
R3093 VDD.n1576 VDD.n1368 4.5005
R3094 VDD.n1424 VDD.n1422 4.5005
R3095 VDD.n1484 VDD.n1422 4.5005
R3096 VDD.n1428 VDD.n1426 4.5005
R3097 VDD.n1473 VDD.n1426 4.5005
R3098 VDD.n1432 VDD.n1430 4.5005
R3099 VDD.n1462 VDD.n1430 4.5005
R3100 VDD.n1444 VDD.n1443 4.5005
R3101 VDD.n1378 VDD.n1373 4.5005
R3102 VDD.n1574 VDD.n1374 4.5005
R3103 VDD.n1575 VDD.n1574 4.5005
R3104 VDD.n1613 VDD.n1612 4.5005
R3105 VDD.n1611 VDD.n1591 4.5005
R3106 VDD.n1611 VDD.n1610 4.5005
R3107 VDD.n1599 VDD.n1597 4.5005
R3108 VDD.n1597 VDD.n1239 4.5005
R3109 VDD.n1844 VDD.n1236 4.5005
R3110 VDD.n1845 VDD.n1844 4.5005
R3111 VDD.n1856 VDD.n1231 4.5005
R3112 VDD.n1857 VDD.n1856 4.5005
R3113 VDD.n1881 VDD.n1861 4.5005
R3114 VDD.n1881 VDD.n1880 4.5005
R3115 VDD.n1869 VDD.n1867 4.5005
R3116 VDD.n1867 VDD.n784 4.5005
R3117 VDD.n2527 VDD.n781 4.5005
R3118 VDD.n2528 VDD.n2527 4.5005
R3119 VDD.n2539 VDD.n776 4.5005
R3120 VDD.n2540 VDD.n2539 4.5005
R3121 VDD.n3746 VDD.n3745 4.5005
R3122 VDD.n3033 VDD.n3032 4.5005
R3123 VDD.n3295 VDD.n3294 4.5005
R3124 VDD.n3273 VDD.n3268 4.5005
R3125 VDD.n3506 VDD.n3505 4.5005
R3126 VDD.n2538 VDD.n2537 4.5005
R3127 VDD.n2526 VDD.n2525 4.5005
R3128 VDD.n1472 VDD.n1471 4.5005
R3129 VDD.n1483 VDD.n1482 4.5005
R3130 VDD.n1494 VDD.n1493 4.5005
R3131 VDD.n1418 VDD.n1415 4.5005
R3132 VDD.n1419 VDD.n1418 4.5005
R3133 VDD.n1461 VDD.n1460 4.5005
R3134 VDD.n1459 VDD.n1435 4.5005
R3135 VDD.n1459 VDD.n1458 4.5005
R3136 VDD.n1448 VDD.n1439 4.5005
R3137 VDD.n1448 VDD.n1447 4.5005
R3138 VDD.n2546 VDD.n2542 4.5005
R3139 VDD.n2547 VDD.n2546 4.5005
R3140 VDD.n2560 VDD.n2551 4.5005
R3141 VDD.n2560 VDD.n2559 4.5005
R3142 VDD.n3291 VDD.n3286 4.5005
R3143 VDD.n3291 VDD.n3290 4.5005
R3144 VDD.n3487 VDD.n3271 4.5005
R3145 VDD.n3271 VDD.n3270 4.5005
R3146 VDD.n3501 VDD.n3497 4.5005
R3147 VDD.n3502 VDD.n3501 4.5005
R3148 VDD.n3025 VDD.n669 4.5005
R3149 VDD.n3742 VDD.n3741 4.5005
R3150 VDD.n3741 VDD.n3035 4.5005
R3151 VDD.n3031 VDD.n3030 4.5005
R3152 VDD.n1879 VDD.n1878 4.5005
R3153 VDD.n1862 VDD.n1858 4.5005
R3154 VDD.n1855 VDD.n1854 4.5005
R3155 VDD.n1843 VDD.n1842 4.5005
R3156 VDD.n1609 VDD.n1608 4.5005
R3157 VDD.n2562 VDD.n2561 4.5005
R3158 VDD.n2545 VDD.n2541 4.5005
R3159 VDD.n1579 VDD.n1371 4.5005
R3160 VDD.n1371 VDD.n1370 4.5005
R3161 VDD.n1585 VDD.n1584 4.5005
R3162 VDD.n1492 VDD.n1423 4.5005
R3163 VDD.n1492 VDD.n1491 4.5005
R3164 VDD.n1481 VDD.n1427 4.5005
R3165 VDD.n1481 VDD.n1480 4.5005
R3166 VDD.n1470 VDD.n1431 4.5005
R3167 VDD.n1470 VDD.n1469 4.5005
R3168 VDD.n1450 VDD.n1449 4.5005
R3169 VDD.n1573 VDD.n1572 4.5005
R3170 VDD.n1567 VDD.n1376 4.5005
R3171 VDD.n1376 VDD.n1375 4.5005
R3172 VDD.n1592 VDD.n1588 4.5005
R3173 VDD.n1593 VDD.n1589 4.5005
R3174 VDD.n1594 VDD.n1593 4.5005
R3175 VDD.n1607 VDD.n1598 4.5005
R3176 VDD.n1607 VDD.n1606 4.5005
R3177 VDD.n1837 VDD.n1238 4.5005
R3178 VDD.n1238 VDD.n1237 4.5005
R3179 VDD.n1849 VDD.n1233 4.5005
R3180 VDD.n1233 VDD.n1232 4.5005
R3181 VDD.n1863 VDD.n1859 4.5005
R3182 VDD.n1864 VDD.n1863 4.5005
R3183 VDD.n1877 VDD.n1868 4.5005
R3184 VDD.n1877 VDD.n1876 4.5005
R3185 VDD.n2520 VDD.n783 4.5005
R3186 VDD.n783 VDD.n782 4.5005
R3187 VDD.n2532 VDD.n778 4.5005
R3188 VDD.n778 VDD.n777 4.5005
R3189 VDD.n3738 VDD.n3034 4.5005
R3190 VDD.n669 VDD.n668 4.5005
R3191 VDD.n3292 VDD.n3285 4.5005
R3192 VDD.n3493 VDD.n3492 4.5005
R3193 VDD.n3500 VDD.n3496 4.5005
R3194 VDD.n3731 VDD.n3728 4.5005
R3195 VDD.n3732 VDD.n3731 4.5005
R3196 VDD.n3727 VDD.n3036 4.5005
R3197 VDD.n3039 VDD.n3037 4.5005
R3198 VDD.n3040 VDD.n3037 4.5005
R3199 VDD.n3730 VDD.n3729 4.5005
R3200 VDD.n3734 VDD.n3038 4.5005
R3201 VDD.n3734 VDD.n3733 4.5005
R3202 VDD.n3736 VDD.n3735 4.5005
R3203 VDD.n3723 VDD.n3717 4.5005
R3204 VDD.n3724 VDD.n3723 4.5005
R3205 VDD.n3720 VDD.n3716 4.5005
R3206 VDD.n3718 VDD.n3043 4.5005
R3207 VDD.n3718 VDD.n3044 4.5005
R3208 VDD.n3722 VDD.n3721 4.5005
R3209 VDD.n3726 VDD.n3042 4.5005
R3210 VDD.n3726 VDD.n3725 4.5005
R3211 VDD.n3719 VDD.n3041 4.5005
R3212 VDD.n3712 VDD.n3706 4.5005
R3213 VDD.n3713 VDD.n3712 4.5005
R3214 VDD.n3709 VDD.n3705 4.5005
R3215 VDD.n3707 VDD.n3047 4.5005
R3216 VDD.n3707 VDD.n3048 4.5005
R3217 VDD.n3711 VDD.n3710 4.5005
R3218 VDD.n3715 VDD.n3046 4.5005
R3219 VDD.n3715 VDD.n3714 4.5005
R3220 VDD.n3708 VDD.n3045 4.5005
R3221 VDD.n3701 VDD.n3695 4.5005
R3222 VDD.n3702 VDD.n3701 4.5005
R3223 VDD.n3698 VDD.n3694 4.5005
R3224 VDD.n3696 VDD.n3051 4.5005
R3225 VDD.n3696 VDD.n3052 4.5005
R3226 VDD.n3700 VDD.n3699 4.5005
R3227 VDD.n3704 VDD.n3050 4.5005
R3228 VDD.n3704 VDD.n3703 4.5005
R3229 VDD.n3697 VDD.n3049 4.5005
R3230 VDD.n3690 VDD.n3684 4.5005
R3231 VDD.n3691 VDD.n3690 4.5005
R3232 VDD.n3687 VDD.n3683 4.5005
R3233 VDD.n3685 VDD.n3055 4.5005
R3234 VDD.n3685 VDD.n3056 4.5005
R3235 VDD.n3689 VDD.n3688 4.5005
R3236 VDD.n3693 VDD.n3054 4.5005
R3237 VDD.n3693 VDD.n3692 4.5005
R3238 VDD.n3686 VDD.n3053 4.5005
R3239 VDD.n3679 VDD.n3673 4.5005
R3240 VDD.n3680 VDD.n3679 4.5005
R3241 VDD.n3676 VDD.n3672 4.5005
R3242 VDD.n3674 VDD.n3059 4.5005
R3243 VDD.n3674 VDD.n3060 4.5005
R3244 VDD.n3678 VDD.n3677 4.5005
R3245 VDD.n3682 VDD.n3058 4.5005
R3246 VDD.n3682 VDD.n3681 4.5005
R3247 VDD.n3675 VDD.n3057 4.5005
R3248 VDD.n3668 VDD.n3662 4.5005
R3249 VDD.n3669 VDD.n3668 4.5005
R3250 VDD.n3665 VDD.n3661 4.5005
R3251 VDD.n3663 VDD.n3063 4.5005
R3252 VDD.n3663 VDD.n3064 4.5005
R3253 VDD.n3667 VDD.n3666 4.5005
R3254 VDD.n3671 VDD.n3062 4.5005
R3255 VDD.n3671 VDD.n3670 4.5005
R3256 VDD.n3664 VDD.n3061 4.5005
R3257 VDD.n3191 VDD.n3067 4.5005
R3258 VDD.n3192 VDD.n3191 4.5005
R3259 VDD.n3190 VDD.n3066 4.5005
R3260 VDD.n3193 VDD.n3065 4.5005
R3261 VDD.n3660 VDD.n3659 4.5005
R3262 VDD.n1011 VDD.n1009 4.42344
R3263 VDD.n952 VDD.n950 4.42344
R3264 VDD.t139 VDD.t477 4.21712
R3265 VDD.t622 VDD.t623 4.21712
R3266 VDD.t239 VDD.t237 4.10876
R3267 VDD.t95 VDD.t99 4.10876
R3268 VDD.n1084 VDD.n874 4.01905
R3269 VDD.n586 VDD.n585 3.57445
R3270 VDD.n562 VDD.n561 3.57445
R3271 VDD.n1031 VDD.n1003 3.36999
R3272 VDD.n961 VDD.n944 3.36881
R3273 VDD.n2478 VDD.n2477 3.28265
R3274 VDD.n2491 VDD.n816 3.28265
R3275 VDD.n1897 VDD.n1896 3.28265
R3276 VDD.n1858 VDD.n1857 3.28265
R3277 VDD.n586 VDD.n581 3.26774
R3278 VDD.n562 VDD.n557 3.26774
R3279 VDD.n1081 VDD 3.20261
R3280 VDD.n1001 VDD.n997 3.20024
R3281 VDD.n942 VDD.n938 3.20024
R3282 VDD.n2208 VDD.t466 3.09954
R3283 VDD.n581 VDD.t242 3.09525
R3284 VDD.n573 VDD.t176 3.09525
R3285 VDD.n579 VDD.t671 3.09525
R3286 VDD.n557 VDD.t156 3.09525
R3287 VDD.n549 VDD.t109 3.09525
R3288 VDD.n544 VDD.t98 3.09525
R3289 VDD.n568 VDD.t23 3.09288
R3290 VDD.n555 VDD.t544 3.09288
R3291 VDD.n1025 VDD.n1003 3.01099
R3292 VDD.n2292 VDD.n2291 2.86459
R3293 VDD.n2035 VDD.n2034 2.86393
R3294 VDD.n2132 VDD.n2131 2.86393
R3295 VDD.n6 VDD.n0 2.67326
R3296 VDD.n13 VDD.n7 2.67326
R3297 VDD.n943 VDD.n903 2.58281
R3298 VDD.n2209 VDD.n2208 2.50629
R3299 VDD.n2210 VDD.n2209 2.50629
R3300 VDD.n2211 VDD.n2210 2.50629
R3301 VDD.n2212 VDD.n2211 2.50629
R3302 VDD.n2213 VDD.n2212 2.50629
R3303 VDD.n2214 VDD.n2213 2.50629
R3304 VDD.n2215 VDD.n2214 2.50629
R3305 VDD VDD.n4181 2.43997
R3306 VDD.n1002 VDD.n962 2.43819
R3307 VDD.n897 VDD.t363 2.34072
R3308 VDD.n866 VDD.t362 2.34072
R3309 VDD.n2097 VDD.n2005 2.2492
R3310 VDD.n2206 VDD.n2205 2.2492
R3311 VDD.n2296 VDD.n2295 2.24717
R3312 VDD.n1107 VDD.n1106 2.2325
R3313 VDD.n4009 VDD.n4008 2.23205
R3314 VDD.n856 VDD.n835 2.23175
R3315 VDD.n2047 VDD.n2046 2.1965
R3316 VDD.n2145 VDD.n2144 2.1965
R3317 VDD.n2280 VDD.n2279 2.1965
R3318 VDD.n2098 VDD.n2097 2.17394
R3319 VDD.n2205 VDD.n2204 2.17394
R3320 VDD.n2296 VDD.n1976 2.17394
R3321 VDD.n2216 VDD.n2215 2.07879
R3322 VDD.n592 VDD.n563 1.89167
R3323 VDD.n864 VDD.n863 1.63116
R3324 VDD.n873 VDD.n858 1.62997
R3325 VDD.n869 VDD.n868 1.60881
R3326 VDD.t361 VDD.n897 1.50685
R3327 VDD.t364 VDD.n866 1.50685
R3328 VDD.n259 VDD.n256 1.49261
R3329 VDD.n283 VDD.n282 1.49261
R3330 VDD.n373 VDD.n372 1.49261
R3331 VDD.n386 VDD.n385 1.49261
R3332 VDD.n476 VDD.n472 1.49261
R3333 VDD.n3095 VDD.n3094 1.49261
R3334 VDD.n3176 VDD.n3170 1.49261
R3335 VDD.n3212 VDD.n3208 1.49261
R3336 VDD.n3558 VDD.n3557 1.49261
R3337 VDD.n287 VDD.n286 1.48195
R3338 VDD.n279 VDD.n278 1.48195
R3339 VDD.n391 VDD.n389 1.48195
R3340 VDD.n469 VDD.n463 1.48195
R3341 VDD.n3919 VDD.n3918 1.48195
R3342 VDD.n3161 VDD.n3160 1.48195
R3343 VDD.n3180 VDD.n3179 1.48195
R3344 VDD.n3645 VDD.n3644 1.48195
R3345 VDD.n2663 VDD.n2655 1.42739
R3346 VDD.n4181 VDD.n4178 1.418
R3347 VDD.n991 VDD.n981 1.39471
R3348 VDD.n932 VDD.n922 1.39471
R3349 VDD.n3964 VDD.n149 1.37655
R3350 VDD.n153 VDD.n152 1.37537
R3351 VDD.n3961 VDD.n156 1.37537
R3352 VDD.n156 VDD.n153 1.31853
R3353 VDD.n2642 VDD.n149 1.31853
R3354 VDD.n1018 VDD.n1015 1.31734
R3355 VDD.n1066 VDD.n1061 1.31734
R3356 VDD.n1076 VDD.n1071 1.31734
R3357 VDD.n3976 VDD.n3973 1.31734
R3358 VDD.n29 VDD.n26 1.31734
R3359 VDD.n39 VDD.n36 1.31734
R3360 VDD.n25 VDD 1.3166
R3361 VDD.n46 VDD 1.3166
R3362 VDD.n2060 VDD.n2059 1.24507
R3363 VDD.n2085 VDD.n2084 1.24507
R3364 VDD.n2159 VDD.n2158 1.24507
R3365 VDD.n2185 VDD.n2184 1.24507
R3366 VDD.n2268 VDD.n2266 1.24507
R3367 VDD.n2242 VDD.n2241 1.24507
R3368 VDD.n539 VDD.n536 1.23536
R3369 VDD.n2914 VDD.n2676 1.18336
R3370 VDD.n1806 VDD.n1802 1.176
R3371 VDD.n1645 VDD.n1288 1.176
R3372 VDD.n1634 VDD.n1283 1.176
R3373 VDD.n1263 VDD.n1262 1.176
R3374 VDD.n1928 VDD.n1919 1.176
R3375 VDD.n1904 VDD.n829 1.176
R3376 VDD.n2782 VDD.n2781 1.176
R3377 VDD.n2723 VDD.n690 1.176
R3378 VDD.n3525 VDD.n3524 1.176
R3379 VDD.n3346 VDD.n3345 1.176
R3380 VDD.n3459 VDD.n3458 1.176
R3381 VDD.n808 VDD.n807 1.176
R3382 VDD.n3765 VDD.n3764 1.176
R3383 VDD.n2489 VDD.n2485 1.176
R3384 VDD.n2994 VDD.n2990 1.176
R3385 VDD.n1656 VDD.n1293 1.176
R3386 VDD.n1667 VDD.n1298 1.176
R3387 VDD.n1717 VDD.n1715 1.176
R3388 VDD.n1700 VDD.n1313 1.176
R3389 VDD.n1689 VDD.n1308 1.176
R3390 VDD.n1678 VDD.n1303 1.176
R3391 VDD.n2611 VDD.n2602 1.176
R3392 VDD.n2587 VDD.n711 1.176
R3393 VDD.n3705 VDD.n3704 1.176
R3394 VDD.n5 VDD.n3 1.1735
R3395 VDD.n12 VDD.n10 1.1735
R3396 VDD.n2921 VDD.n2920 1.17348
R3397 VDD.n2102 VDD.n2096 1.14736
R3398 VDD.n2199 VDD.n2198 1.14736
R3399 VDD.n2230 VDD.n2228 1.14736
R3400 VDD VDD.n1965 1.13024
R3401 VDD.n1052 VDD.n1044 1.1221
R3402 VDD.n1060 VDD.n1052 1.10385
R3403 VDD.n1624 VDD.n1615 1.0869
R3404 VDD.n1570 VDD.n1566 1.0869
R3405 VDD.n1582 VDD.n1578 1.0869
R3406 VDD.n1600 VDD.n1254 1.0869
R3407 VDD.n1840 VDD.n1836 1.0869
R3408 VDD.n1852 VDD.n1848 1.0869
R3409 VDD.n3028 VDD.n3024 1.0869
R3410 VDD.n2553 VDD.n683 1.0869
R3411 VDD.n3509 VDD.n3508 1.0869
R3412 VDD.n3490 VDD.n3486 1.0869
R3413 VDD.n3299 VDD.n3297 1.0869
R3414 VDD.n1870 VDD.n799 1.0869
R3415 VDD.n3749 VDD.n3748 1.0869
R3416 VDD.n1894 VDD.n1885 1.0869
R3417 VDD.n2577 VDD.n2568 1.0869
R3418 VDD.n1441 VDD.n1389 1.0869
R3419 VDD.n1452 VDD.n1394 1.0869
R3420 VDD.n1502 VDD.n1500 1.0869
R3421 VDD.n1485 VDD.n1409 1.0869
R3422 VDD.n1474 VDD.n1404 1.0869
R3423 VDD.n1463 VDD.n1399 1.0869
R3424 VDD.n2523 VDD.n2519 1.0869
R3425 VDD.n2535 VDD.n2531 1.0869
R3426 VDD.n3727 VDD.n3726 1.0869
R3427 VDD.n1103 VDD.n1102 1.05035
R3428 VDD.n3987 VDD.n3986 1.05005
R3429 VDD.n4005 VDD.n4004 1.0496
R3430 VDD.n1082 VDD.n1060 1.04272
R3431 VDD.n4046 VDD.n114 1.0295
R3432 VDD.n4066 VDD.n104 1.0295
R3433 VDD.n4056 VDD.n109 1.0295
R3434 VDD.n4036 VDD.n119 1.0295
R3435 VDD.n4026 VDD.n124 1.0295
R3436 VDD.n4016 VDD.n129 1.0295
R3437 VDD.n2816 VDD.n2815 1.0295
R3438 VDD.n3871 VDD.n520 1.0295
R3439 VDD.n3618 VDD.n3548 1.0295
R3440 VDD.n3368 VDD.n3367 1.0295
R3441 VDD.n3426 VDD.n3425 1.0295
R3442 VDD.n2943 VDD.n2939 1.0295
R3443 VDD.n3789 VDD.n3788 1.0295
R3444 VDD.n3995 VDD.n3994 1.0295
R3445 VDD.n2839 VDD.n2838 1.0295
R3446 VDD.n4076 VDD.n99 1.0295
R3447 VDD.n4086 VDD.n94 1.0295
R3448 VDD.n4132 VDD.n4128 1.0295
R3449 VDD.n4116 VDD.n66 1.0295
R3450 VDD.n4106 VDD.n84 1.0295
R3451 VDD.n4096 VDD.n89 1.0295
R3452 VDD.n2684 VDD.n732 1.0295
R3453 VDD.n2863 VDD.n2854 1.0295
R3454 VDD.n3672 VDD.n3671 1.0295
R3455 VDD.n2216 VDD.t502 1.02125
R3456 VDD.n4168 VDD.n4167 0.985763
R3457 VDD.n1956 VDD.n1193 0.9748
R3458 VDD.n2328 VDD.n1183 0.9748
R3459 VDD.n2317 VDD.n1188 0.9748
R3460 VDD.n1945 VDD.n1936 0.9748
R3461 VDD.n1921 VDD.n843 0.9748
R3462 VDD.n2472 VDD.n2468 0.9748
R3463 VDD.n2791 VDD.n2790 0.9748
R3464 VDD.n2756 VDD.n2752 0.9748
R3465 VDD.n3533 VDD.n3532 0.9748
R3466 VDD.n3355 VDD.n3354 0.9748
R3467 VDD.n3448 VDD.n3447 0.9748
R3468 VDD.n2622 VDD.n2619 0.9748
R3469 VDD.n3773 VDD.n3772 0.9748
R3470 VDD.n1100 VDD.n822 0.9748
R3471 VDD.n2735 VDD.n704 0.9748
R3472 VDD.n2339 VDD.n1178 0.9748
R3473 VDD.n2350 VDD.n1173 0.9748
R3474 VDD.n1724 VDD.n1720 0.9748
R3475 VDD.n4152 VDD.n59 0.9748
R3476 VDD.n1744 VDD.n1740 0.9748
R3477 VDD.n2361 VDD.n1168 0.9748
R3478 VDD.n2604 VDD.n725 0.9748
R3479 VDD.n2977 VDD.n2973 0.9748
R3480 VDD.n3694 VDD.n3693 0.9748
R3481 VDD.n502 VDD.n501 0.972122
R3482 VDD.n887 VDD.n886 0.967782
R3483 VDD.n1949 VDD.n1129 0.9411
R3484 VDD.n2321 VDD.n1139 0.9411
R3485 VDD.n1938 VDD.n1124 0.9411
R3486 VDD.n2455 VDD.n2451 0.9411
R3487 VDD.n1114 VDD.n836 0.9411
R3488 VDD.n2823 VDD.n2799 0.9411
R3489 VDD.n2833 VDD.n2707 0.9411
R3490 VDD.n3541 VDD.n3540 0.9411
R3491 VDD.n3375 VDD.n3363 0.9411
R3492 VDD.n3437 VDD.n3436 0.9411
R3493 VDD.n2630 VDD.n2628 0.9411
R3494 VDD.n3781 VDD.n3780 0.9411
R3495 VDD.n4002 VDD.n138 0.9411
R3496 VDD.n2846 VDD.n2702 0.9411
R3497 VDD.n2332 VDD.n1144 0.9411
R3498 VDD.n2343 VDD.n1149 0.9411
R3499 VDD.n4145 VDD.n4144 0.9411
R3500 VDD.n2371 VDD.n2369 0.9411
R3501 VDD.n2354 VDD.n1154 0.9411
R3502 VDD.n2960 VDD.n2956 0.9411
R3503 VDD.n2696 VDD.n718 0.9411
R3504 VDD.n3683 VDD.n3682 0.9411
R3505 VDD.n2298 VDD.n1974 0.934842
R3506 VDD.n881 VDD.n880 0.927587
R3507 VDD.n2041 VDD.n2040 0.9185
R3508 VDD.n2054 VDD.n2053 0.9185
R3509 VDD.n2066 VDD.n2065 0.9185
R3510 VDD.n2073 VDD.n2072 0.9185
R3511 VDD.n2079 VDD.n2078 0.9185
R3512 VDD.n2091 VDD.n2090 0.9185
R3513 VDD.n2138 VDD.n2137 0.9185
R3514 VDD.n2152 VDD.n2151 0.9185
R3515 VDD.n2165 VDD.n2164 0.9185
R3516 VDD.n2172 VDD.n2171 0.9185
R3517 VDD.n2179 VDD.n2178 0.9185
R3518 VDD.n2192 VDD.n2191 0.9185
R3519 VDD.n2286 VDD.n2285 0.9185
R3520 VDD.n2274 VDD.n1991 0.9185
R3521 VDD.n2261 VDD.n2260 0.9185
R3522 VDD.n2255 VDD.n1996 0.9185
R3523 VDD.n2249 VDD.n2247 0.9185
R3524 VDD.n2236 VDD.n2001 0.9185
R3525 VDD.n1617 VDD.n1270 0.9174
R3526 VDD.n1652 VDD.n1351 0.9174
R3527 VDD.n1641 VDD.n1632 0.9174
R3528 VDD.n1823 VDD.n1819 0.9174
R3529 VDD.n1247 VDD.n1246 0.9174
R3530 VDD.n1911 VDD.n1902 0.9174
R3531 VDD.n2773 VDD.n676 0.9174
R3532 VDD.n3011 VDD.n3007 0.9174
R3533 VDD.n3517 VDD.n3516 0.9174
R3534 VDD.n3337 VDD.n3278 0.9174
R3535 VDD.n3473 VDD.n3469 0.9174
R3536 VDD.n2506 VDD.n2502 0.9174
R3537 VDD.n3757 VDD.n3756 0.9174
R3538 VDD.n1887 VDD.n815 0.9174
R3539 VDD.n2570 VDD.n697 0.9174
R3540 VDD.n1663 VDD.n1346 0.9174
R3541 VDD.n1674 VDD.n1341 0.9174
R3542 VDD.n1509 VDD.n1505 0.9174
R3543 VDD.n1707 VDD.n1326 0.9174
R3544 VDD.n1696 VDD.n1331 0.9174
R3545 VDD.n1685 VDD.n1336 0.9174
R3546 VDD.n792 VDD.n791 0.9174
R3547 VDD.n2594 VDD.n2585 0.9174
R3548 VDD.n3716 VDD.n3715 0.9174
R3549 VDD.n3895 VDD.n3894 0.915695
R3550 VDD.n295 VDD.n220 0.876816
R3551 VDD.n314 VDD.n214 0.876816
R3552 VDD.n311 VDD.n215 0.876816
R3553 VDD.n334 VDD.n210 0.876816
R3554 VDD.n331 VDD.n211 0.876816
R3555 VDD.n370 VDD.n369 0.876816
R3556 VDD.n351 VDD.n207 0.876816
R3557 VDD.n401 VDD.n198 0.876816
R3558 VDD.n397 VDD.n396 0.876816
R3559 VDD.n420 VDD.n192 0.876816
R3560 VDD.n417 VDD.n193 0.876816
R3561 VDD.n461 VDD.n460 0.876816
R3562 VDD.n435 VDD.n188 0.876816
R3563 VDD.n3947 VDD.n164 0.876816
R3564 VDD.n3950 VDD.n163 0.876816
R3565 VDD.n3922 VDD.n3921 0.876816
R3566 VDD.n3925 VDD.n176 0.876816
R3567 VDD.n3913 VDD.n3912 0.876816
R3568 VDD.n3916 VDD.n482 0.876816
R3569 VDD.n3158 VDD.n3157 0.876816
R3570 VDD.n3116 VDD.n3099 0.876816
R3571 VDD.n3843 VDD.n602 0.876816
R3572 VDD.n3167 VDD.n3086 0.876816
R3573 VDD.n3814 VDD.n612 0.876816
R3574 VDD.n3817 VDD.n611 0.876816
R3575 VDD.n3206 VDD.n3205 0.876816
R3576 VDD.n3187 VDD.n3184 0.876816
R3577 VDD.n3648 VDD.n3647 0.876816
R3578 VDD.n3651 VDD.n3071 0.876816
R3579 VDD.n3639 VDD.n3638 0.876816
R3580 VDD.n3642 VDD.n3218 0.876816
R3581 VDD.n3605 VDD.n3554 0.876816
R3582 VDD.n3591 VDD.n3566 0.876816
R3583 VDD.n291 VDD.n290 0.876816
R3584 VDD.n254 VDD.n253 0.876816
R3585 VDD.n235 VDD.n232 0.876816
R3586 VDD.n25 VDD 0.865435
R3587 VDD.n46 VDD 0.865435
R3588 VDD.n3415 VDD.n3414 0.8106
R3589 VDD.n3661 VDD.n3660 0.8105
R3590 VDD.n3825 VDD.n610 0.8103
R3591 VDD.n3630 VDD.n3626 0.8098
R3592 VDD.n3611 VDD.n3610 0.8095
R3593 VDD.n3799 VDD.n3796 0.8092
R3594 VDD.n1081 VDD 0.793921
R3595 VDD.n2310 VDD.n2309 0.7913
R3596 VDD.n2218 VDD.n2217 0.7775
R3597 VDD.n2221 VDD 0.77
R3598 VDD.n2921 VDD 0.746553
R3599 VDD.n4161 VDD.n4160 0.7194
R3600 VDD.n249 VDD.n237 0.716947
R3601 VDD.n300 VDD.n298 0.716947
R3602 VDD.n321 VDD.n320 0.716947
R3603 VDD.n341 VDD.n340 0.716947
R3604 VDD.n365 VDD.n353 0.716947
R3605 VDD.n406 VDD.n404 0.716947
R3606 VDD.n424 VDD.n190 0.716947
R3607 VDD.n456 VDD.n437 0.716947
R3608 VDD.n3943 VDD.n165 0.716947
R3609 VDD.n3146 VDD.n3124 0.716947
R3610 VDD.n3840 VDD.n3839 0.716947
R3611 VDD.n3810 VDD.n613 0.716947
R3612 VDD.n3574 VDD.n3573 0.716947
R3613 VDD.n3602 VDD.n3601 0.716947
R3614 VDD.n2666 VDD 0.709842
R3615 VDD VDD.n2662 0.709842
R3616 VDD.n2048 VDD.n2009 0.692527
R3617 VDD.n2142 VDD.n2124 0.692527
R3618 VDD.n2278 VDD.n1985 0.6905
R3619 VDD.n3104 VDD.n3101 0.679053
R3620 VDD.n2105 VDD.n2005 0.663658
R3621 VDD.n2105 VDD.n2104 0.663658
R3622 VDD.n2105 VDD.n2014 0.663658
R3623 VDD.n2105 VDD.n2013 0.663658
R3624 VDD.n2105 VDD.n2012 0.663658
R3625 VDD.n2105 VDD.n2011 0.663658
R3626 VDD.n2105 VDD.n2010 0.663658
R3627 VDD.n2105 VDD.n2009 0.663658
R3628 VDD.n2105 VDD.n2008 0.663658
R3629 VDD.n2105 VDD.n2007 0.663658
R3630 VDD.n2206 VDD.n2106 0.663658
R3631 VDD.n2196 VDD.n2106 0.663658
R3632 VDD.n2189 VDD.n2106 0.663658
R3633 VDD.n2176 VDD.n2106 0.663658
R3634 VDD.n2169 VDD.n2106 0.663658
R3635 VDD.n2156 VDD.n2106 0.663658
R3636 VDD.n2149 VDD.n2106 0.663658
R3637 VDD.n2142 VDD.n2106 0.663658
R3638 VDD.n2130 VDD.n2106 0.663658
R3639 VDD.n2129 VDD.n2106 0.663658
R3640 VDD.n2295 VDD.n2294 0.663658
R3641 VDD.n2294 VDD.n1982 0.663658
R3642 VDD.n2294 VDD.n1981 0.663658
R3643 VDD.n2294 VDD.n1983 0.663658
R3644 VDD.n2294 VDD.n1980 0.663658
R3645 VDD.n2294 VDD.n1984 0.663658
R3646 VDD.n2294 VDD.n1979 0.663658
R3647 VDD.n2294 VDD.n1985 0.663658
R3648 VDD.n2294 VDD.n1978 0.663658
R3649 VDD.n2294 VDD.n2293 0.663658
R3650 VDD.n1965 VDD 0.660105
R3651 VDD.n530 VDD.n529 0.650632
R3652 VDD.n1013 VDD.n1012 0.632262
R3653 VDD.n954 VDD.n953 0.632262
R3654 VDD.n3880 VDD.n3879 0.6104
R3655 VDD.n3864 VDD.n3863 0.6103
R3656 VDD.n3969 VDD.n3968 0.6086
R3657 VDD.n2929 VDD.n2928 0.6081
R3658 VDD.n2872 VDD.n2871 0.6075
R3659 VDD.n3898 VDD.n496 0.6074
R3660 VDD.n2293 VDD.t670 0.593749
R3661 VDD.n1978 VDD.t258 0.593749
R3662 VDD.n1985 VDD.t257 0.593749
R3663 VDD.n1979 VDD.t296 0.593749
R3664 VDD.n1984 VDD.t259 0.593749
R3665 VDD.n1980 VDD.t687 0.593749
R3666 VDD.n1983 VDD.t260 0.593749
R3667 VDD.n1981 VDD.t688 0.593749
R3668 VDD.n1982 VDD.t591 0.593749
R3669 VDD.n2295 VDD.t261 0.593749
R3670 VDD.n2129 VDD.t503 0.593749
R3671 VDD.n2130 VDD.t509 0.593749
R3672 VDD.n2142 VDD.t508 0.593749
R3673 VDD.n2149 VDD.t469 0.593749
R3674 VDD.n2156 VDD.t462 0.593749
R3675 VDD.n2169 VDD.t504 0.593749
R3676 VDD.n2176 VDD.t463 0.593749
R3677 VDD.n2189 VDD.t505 0.593749
R3678 VDD.n2196 VDD.t470 0.593749
R3679 VDD.n2206 VDD.t464 0.593749
R3680 VDD.n2007 VDD.t280 0.593749
R3681 VDD.n2008 VDD.t398 0.593749
R3682 VDD.n2009 VDD.t448 0.593749
R3683 VDD.n2010 VDD.t278 0.593749
R3684 VDD.n2011 VDD.t275 0.593749
R3685 VDD.n2012 VDD.t281 0.593749
R3686 VDD.n2013 VDD.t276 0.593749
R3687 VDD.n2014 VDD.t447 0.593749
R3688 VDD.n2104 VDD.t279 0.593749
R3689 VDD.n2005 VDD.t277 0.593749
R3690 VDD.n2208 VDD.t693 0.593749
R3691 VDD.n2209 VDD.t471 0.593749
R3692 VDD.n2210 VDD.t506 0.593749
R3693 VDD.n2211 VDD.t500 0.593749
R3694 VDD.n2212 VDD.t467 0.593749
R3695 VDD.n2213 VDD.t501 0.593749
R3696 VDD.n2214 VDD.t468 0.593749
R3697 VDD.n2215 VDD.t507 0.593749
R3698 VDD.n2292 VDD.n1978 0.57287
R3699 VDD.n2924 VDD 0.572474
R3700 VDD.n2034 VDD.n2008 0.571505
R3701 VDD.n2131 VDD.n2130 0.571505
R3702 VDD.n2925 VDD.n2924 0.570105
R3703 VDD VDD.n229 0.560632
R3704 VDD.n225 VDD 0.560632
R3705 VDD.n258 VDD 0.560632
R3706 VDD VDD.n261 0.560632
R3707 VDD VDD.n263 0.560632
R3708 VDD VDD.n267 0.560632
R3709 VDD VDD.n269 0.560632
R3710 VDD VDD.n273 0.560632
R3711 VDD.n277 VDD 0.560632
R3712 VDD.n203 VDD 0.560632
R3713 VDD VDD.n374 0.560632
R3714 VDD.n393 VDD 0.560632
R3715 VDD VDD.n376 0.560632
R3716 VDD VDD.n380 0.560632
R3717 VDD.n384 VDD 0.560632
R3718 VDD.n184 VDD 0.560632
R3719 VDD.n468 VDD 0.560632
R3720 VDD.n464 VDD 0.560632
R3721 VDD.n475 VDD 0.560632
R3722 VDD VDD.n478 0.560632
R3723 VDD VDD.n480 0.560632
R3724 VDD VDD.n484 0.560632
R3725 VDD VDD.n3096 0.560632
R3726 VDD.n3089 VDD 0.560632
R3727 VDD VDD.n3162 0.560632
R3728 VDD.n3164 VDD 0.560632
R3729 VDD.n3175 VDD 0.560632
R3730 VDD.n3171 VDD 0.560632
R3731 VDD VDD.n3181 0.560632
R3732 VDD.n3078 VDD 0.560632
R3733 VDD.n3211 VDD 0.560632
R3734 VDD VDD.n3214 0.560632
R3735 VDD VDD.n3216 0.560632
R3736 VDD VDD.n3220 0.560632
R3737 VDD VDD.n3559 0.560632
R3738 VDD.n3563 VDD 0.560632
R3739 VDD VDD.n228 0.560632
R3740 VDD.n251 VDD 0.560632
R3741 VDD VDD.n221 0.560632
R3742 VDD.n293 VDD 0.560632
R3743 VDD.n309 VDD 0.560632
R3744 VDD VDD.n316 0.560632
R3745 VDD.n329 VDD 0.560632
R3746 VDD VDD.n336 0.560632
R3747 VDD VDD.n206 0.560632
R3748 VDD.n367 VDD 0.560632
R3749 VDD VDD.n199 0.560632
R3750 VDD.n399 VDD 0.560632
R3751 VDD.n415 VDD 0.560632
R3752 VDD VDD.n422 0.560632
R3753 VDD VDD.n187 0.560632
R3754 VDD.n458 VDD 0.560632
R3755 VDD.n3945 VDD 0.560632
R3756 VDD.n178 VDD 0.560632
R3757 VDD VDD.n179 0.560632
R3758 VDD VDD.n2883 0.560632
R3759 VDD.n3910 VDD 0.560632
R3760 VDD VDD.n3092 0.560632
R3761 VDD VDD.n601 0.560632
R3762 VDD.n3812 VDD 0.560632
R3763 VDD.n3083 VDD 0.560632
R3764 VDD.n3203 VDD 0.560632
R3765 VDD.n3073 VDD 0.560632
R3766 VDD VDD.n3074 0.560632
R3767 VDD VDD.n3400 0.560632
R3768 VDD.n3582 VDD 0.560632
R3769 VDD VDD.n3553 0.560632
R3770 VDD.n3411 VDD.n3410 0.547605
R3771 VDD VDD.n304 0.546421
R3772 VDD.n345 VDD 0.546421
R3773 VDD VDD.n410 0.546421
R3774 VDD.n452 VDD 0.546421
R3775 VDD VDD.n2880 0.546421
R3776 VDD.n3142 VDD 0.546421
R3777 VDD.n3806 VDD 0.546421
R3778 VDD VDD.n3396 0.546421
R3779 VDD.n3961 VDD.n3960 0.538132
R3780 VDD VDD.n3137 0.499053
R3781 VDD.n593 VDD.n535 0.490763
R3782 VDD.n2669 VDD.n2654 0.486595
R3783 VDD.n2670 VDD.n2669 0.485457
R3784 VDD.n1012 VDD.n1011 0.484059
R3785 VDD.n953 VDD.n952 0.484059
R3786 VDD.n594 VDD.n593 0.482474
R3787 VDD.n307 VDD.n216 0.470632
R3788 VDD.n348 VDD.n346 0.470632
R3789 VDD.n413 VDD.n194 0.470632
R3790 VDD.n451 VDD.n450 0.470632
R3791 VDD.n2885 VDD.n2878 0.470632
R3792 VDD.n3141 VDD.n3140 0.470632
R3793 VDD.n3402 VDD.n3398 0.470632
R3794 VDD.n3201 VDD.n3189 0.456421
R3795 VDD.n1033 VDD.n1032 0.455885
R3796 VDD.n3853 VDD.n3852 0.454053
R3797 VDD.n1018 VDD.n1017 0.442211
R3798 VDD.n1062 VDD.n1061 0.442211
R3799 VDD.n1072 VDD.n1071 0.442211
R3800 VDD.n3976 VDD.n3975 0.442211
R3801 VDD.n2304 VDD.n1972 0.442211
R3802 VDD.n231 VDD.n226 0.442211
R3803 VDD.n260 VDD.n222 0.442211
R3804 VDD.n266 VDD.n265 0.442211
R3805 VDD.n272 VDD.n271 0.442211
R3806 VDD.n275 VDD.n204 0.442211
R3807 VDD.n395 VDD.n394 0.442211
R3808 VDD.n379 VDD.n378 0.442211
R3809 VDD.n382 VDD.n185 0.442211
R3810 VDD.n466 VDD.n465 0.442211
R3811 VDD.n473 VDD.n180 0.442211
R3812 VDD.n3915 VDD.n3914 0.442211
R3813 VDD.n3098 VDD.n3090 0.442211
R3814 VDD.n3166 VDD.n3165 0.442211
R3815 VDD.n3173 VDD.n3172 0.442211
R3816 VDD.n3183 VDD.n3079 0.442211
R3817 VDD.n3209 VDD.n3075 0.442211
R3818 VDD.n3641 VDD.n3640 0.442211
R3819 VDD.n3565 VDD.n3564 0.442211
R3820 VDD.n534 VDD.n530 0.442211
R3821 VDD.n3859 VDD.n527 0.442211
R3822 VDD.n32 VDD.n26 0.442211
R3823 VDD.n42 VDD.n36 0.442211
R3824 VDD.n1021 VDD.n1015 0.441026
R3825 VDD.n1066 VDD.n1065 0.441026
R3826 VDD.n1076 VDD.n1075 0.441026
R3827 VDD.n3982 VDD.n3973 0.441026
R3828 VDD.n29 VDD.n28 0.441026
R3829 VDD.n39 VDD.n38 0.441026
R3830 VDD.n4069 VDD.n4068 0.4403
R3831 VDD.n2808 VDD.n522 0.4403
R3832 VDD.n2413 VDD.n2407 0.4403
R3833 VDD.n2826 VDD.n2825 0.4403
R3834 VDD.n2331 VDD.n2330 0.4403
R3835 VDD.n2728 VDD.n2713 0.4403
R3836 VDD.n1782 VDD.n1776 0.4403
R3837 VDD.n2762 VDD.n2761 0.4403
R3838 VDD.n1655 VDD.n1654 0.4403
R3839 VDD.n2768 VDD.n689 0.4403
R3840 VDD.n1559 VDD.n1558 0.4403
R3841 VDD.n3017 VDD.n3016 0.4403
R3842 VDD.n1572 VDD.n1377 0.4403
R3843 VDD.n3030 VDD.n670 0.4403
R3844 VDD.n3889 VDD.n3888 0.439842
R3845 VDD.n3853 VDD.n595 0.439842
R3846 VDD.n2676 VDD.n2650 0.435305
R3847 VDD.n3894 VDD.n499 0.435305
R3848 VDD.n874 VDD.n857 0.423934
R3849 VDD.n4089 VDD.n4088 0.41735
R3850 VDD.n2856 VDD.n511 0.41735
R3851 VDD.n2395 VDD.n2389 0.41735
R3852 VDD.n2849 VDD.n2848 0.41735
R3853 VDD.n2353 VDD.n2352 0.41735
R3854 VDD.n2741 VDD.n717 0.41735
R3855 VDD.n1764 VDD.n1758 0.41735
R3856 VDD.n2983 VDD.n2982 0.41735
R3857 VDD.n1677 VDD.n1676 0.41735
R3858 VDD.n2996 VDD.n698 0.41735
R3859 VDD.n1546 VDD.n1540 0.41735
R3860 VDD.n2580 VDD.n2579 0.41735
R3861 VDD.n1462 VDD.n1461 0.41735
R3862 VDD.n2541 VDD.n2540 0.41735
R3863 VDD.n4049 VDD.n4048 0.4154
R3864 VDD.n3664 VDD.n625 0.4154
R3865 VDD.n2431 VDD.n2425 0.4154
R3866 VDD.n3675 VDD.n632 0.4154
R3867 VDD.n1959 VDD.n1958 0.4154
R3868 VDD.n3686 VDD.n639 0.4154
R3869 VDD.n1795 VDD.n1794 0.4154
R3870 VDD.n3697 VDD.n646 0.4154
R3871 VDD.n1808 VDD.n1271 0.4154
R3872 VDD.n3708 VDD.n653 0.4154
R3873 VDD.n1627 VDD.n1626 0.4154
R3874 VDD.n3719 VDD.n660 0.4154
R3875 VDD.n1588 VDD.n1587 0.4154
R3876 VDD.n3737 VDD.n3736 0.4154
R3877 VDD.n4119 VDD.n4118 0.41495
R3878 VDD.n4099 VDD.n4098 0.41495
R3879 VDD.n4079 VDD.n4078 0.41495
R3880 VDD.n4059 VDD.n4058 0.41495
R3881 VDD.n4039 VDD.n4038 0.41495
R3882 VDD.n4019 VDD.n4018 0.41495
R3883 VDD.n2932 VDD.n144 0.41495
R3884 VDD.n2866 VDD.n2865 0.41495
R3885 VDD.n3874 VDD.n3873 0.41495
R3886 VDD.n2805 VDD.n623 0.41495
R3887 VDD.n3418 VDD.n3064 0.41495
R3888 VDD.n3621 VDD.n3620 0.41495
R3889 VDD.n4137 VDD.n4136 0.41495
R3890 VDD.n2386 VDD.n2380 0.41495
R3891 VDD.n2404 VDD.n2398 0.41495
R3892 VDD.n2422 VDD.n2416 0.41495
R3893 VDD.n2440 VDD.n2434 0.41495
R3894 VDD.n1117 VDD.n1116 0.41495
R3895 VDD.n2945 VDD.n140 0.41495
R3896 VDD.n2691 VDD.n731 0.41495
R3897 VDD.n2836 VDD.n2835 0.41495
R3898 VDD.n2801 VDD.n630 0.41495
R3899 VDD.n3429 VDD.n3060 0.41495
R3900 VDD.n3365 VDD.n3237 0.41495
R3901 VDD.n4155 VDD.n4154 0.41495
R3902 VDD.n2364 VDD.n2363 0.41495
R3903 VDD.n2342 VDD.n2341 0.41495
R3904 VDD.n2320 VDD.n2319 0.41495
R3905 VDD.n1948 VDD.n1947 0.41495
R3906 VDD.n2461 VDD.n2460 0.41495
R3907 VDD.n1093 VDD.n739 0.41495
R3908 VDD.n2966 VDD.n2965 0.41495
R3909 VDD.n2745 VDD.n2744 0.41495
R3910 VDD.n2794 VDD.n637 0.41495
R3911 VDD.n3440 VDD.n3056 0.41495
R3912 VDD.n3358 VDD.n3243 0.41495
R3913 VDD.n1734 VDD.n1728 0.41495
R3914 VDD.n1755 VDD.n1749 0.41495
R3915 VDD.n1773 VDD.n1767 0.41495
R3916 VDD.n1791 VDD.n1785 0.41495
R3917 VDD.n1276 VDD.n1199 0.41495
R3918 VDD.n2474 VDD.n830 0.41495
R3919 VDD.n821 VDD.n744 0.41495
R3920 VDD.n2979 VDD.n712 0.41495
R3921 VDD.n2758 VDD.n703 0.41495
R3922 VDD.n2785 VDD.n644 0.41495
R3923 VDD.n3451 VDD.n3052 0.41495
R3924 VDD.n3349 VDD.n3249 0.41495
R3925 VDD.n1710 VDD.n1709 0.41495
R3926 VDD.n1688 VDD.n1687 0.41495
R3927 VDD.n1666 VDD.n1665 0.41495
R3928 VDD.n1644 VDD.n1643 0.41495
R3929 VDD.n1812 VDD.n1811 0.41495
R3930 VDD.n1914 VDD.n1913 0.41495
R3931 VDD.n2495 VDD.n2494 0.41495
R3932 VDD.n2597 VDD.n2596 0.41495
R3933 VDD.n3000 VDD.n2999 0.41495
R3934 VDD.n2776 VDD.n651 0.41495
R3935 VDD.n3462 VDD.n3048 0.41495
R3936 VDD.n3340 VDD.n3255 0.41495
R3937 VDD.n1519 VDD.n1513 0.41495
R3938 VDD.n1537 VDD.n1531 0.41495
R3939 VDD.n1555 VDD.n1549 0.41495
R3940 VDD.n1382 VDD.n1357 0.41495
R3941 VDD.n1825 VDD.n1255 0.41495
R3942 VDD.n1244 VDD.n1219 0.41495
R3943 VDD.n2508 VDD.n800 0.41495
R3944 VDD.n789 VDD.n764 0.41495
R3945 VDD.n3013 VDD.n684 0.41495
R3946 VDD.n675 VDD.n658 0.41495
R3947 VDD.n3475 VDD.n3044 0.41495
R3948 VDD.n3277 VDD.n3261 0.41495
R3949 VDD.n1495 VDD.n1494 0.41495
R3950 VDD.n1473 VDD.n1472 0.41495
R3951 VDD.n1451 VDD.n1450 0.41495
R3952 VDD.n1584 VDD.n1575 0.41495
R3953 VDD.n1610 VDD.n1609 0.41495
R3954 VDD.n1854 VDD.n1845 0.41495
R3955 VDD.n1880 VDD.n1879 0.41495
R3956 VDD.n2537 VDD.n2528 0.41495
R3957 VDD.n2563 VDD.n2562 0.41495
R3958 VDD.n3034 VDD.n3033 0.41495
R3959 VDD.n3285 VDD.n3040 0.41495
R3960 VDD.n3496 VDD.n3495 0.41495
R3961 VDD.n4109 VDD.n4108 0.4148
R3962 VDD.n4029 VDD.n4028 0.4148
R3963 VDD.n2679 VDD.n2635 0.4148
R3964 VDD.n3382 VDD.n3227 0.4148
R3965 VDD.n2377 VDD.n65 0.4148
R3966 VDD.n2444 VDD.n2443 0.4148
R3967 VDD.n2949 VDD.n2948 0.4148
R3968 VDD.n3378 VDD.n3377 0.4148
R3969 VDD.n1159 VDD.n61 0.4148
R3970 VDD.n2457 VDD.n844 0.4148
R3971 VDD.n2962 VDD.n726 0.4148
R3972 VDD.n3320 VDD.n3312 0.4148
R3973 VDD.n1746 VDD.n1737 0.4148
R3974 VDD.n1931 VDD.n1930 0.4148
R3975 VDD.n2614 VDD.n2613 0.4148
R3976 VDD.n3326 VDD.n3308 0.4148
R3977 VDD.n1699 VDD.n1698 0.4148
R3978 VDD.n1260 VDD.n1209 0.4148
R3979 VDD.n805 VDD.n754 0.4148
R3980 VDD.n3332 VDD.n3304 0.4148
R3981 VDD.n1528 VDD.n1522 0.4148
R3982 VDD.n1829 VDD.n1828 0.4148
R3983 VDD.n2512 VDD.n2511 0.4148
R3984 VDD.n3479 VDD.n3478 0.4148
R3985 VDD.n1484 VDD.n1483 0.4148
R3986 VDD.n1842 VDD.n1239 0.4148
R3987 VDD.n2525 VDD.n784 0.4148
R3988 VDD.n3492 VDD.n3272 0.4148
R3989 VDD.n230 VDD 0.412605
R3990 VDD VDD.n223 0.412605
R3991 VDD VDD.n257 0.412605
R3992 VDD.n262 VDD 0.412605
R3993 VDD.n264 VDD 0.412605
R3994 VDD.n268 VDD 0.412605
R3995 VDD.n270 VDD 0.412605
R3996 VDD.n274 VDD 0.412605
R3997 VDD VDD.n276 0.412605
R3998 VDD VDD.n201 0.412605
R3999 VDD.n375 VDD 0.412605
R4000 VDD VDD.n392 0.412605
R4001 VDD.n377 VDD 0.412605
R4002 VDD.n381 VDD 0.412605
R4003 VDD VDD.n383 0.412605
R4004 VDD VDD.n182 0.412605
R4005 VDD VDD.n467 0.412605
R4006 VDD VDD.n181 0.412605
R4007 VDD VDD.n474 0.412605
R4008 VDD.n479 VDD 0.412605
R4009 VDD.n483 VDD 0.412605
R4010 VDD.n3093 VDD 0.412605
R4011 VDD.n3097 VDD 0.412605
R4012 VDD VDD.n3087 0.412605
R4013 VDD.n3163 VDD 0.412605
R4014 VDD VDD.n3085 0.412605
R4015 VDD VDD.n3174 0.412605
R4016 VDD VDD.n3084 0.412605
R4017 VDD.n3182 VDD 0.412605
R4018 VDD VDD.n3076 0.412605
R4019 VDD VDD.n3210 0.412605
R4020 VDD.n3215 VDD 0.412605
R4021 VDD.n3219 VDD 0.412605
R4022 VDD.n3556 VDD 0.412605
R4023 VDD.n3560 VDD 0.412605
R4024 VDD VDD.n3562 0.412605
R4025 VDD.n233 VDD 0.412605
R4026 VDD VDD.n250 0.412605
R4027 VDD.n242 VDD 0.412605
R4028 VDD VDD.n218 0.412605
R4029 VDD VDD.n308 0.412605
R4030 VDD.n317 VDD 0.412605
R4031 VDD VDD.n328 0.412605
R4032 VDD.n337 VDD 0.412605
R4033 VDD.n347 VDD 0.412605
R4034 VDD VDD.n366 0.412605
R4035 VDD.n355 VDD 0.412605
R4036 VDD VDD.n196 0.412605
R4037 VDD VDD.n414 0.412605
R4038 VDD.n423 VDD 0.412605
R4039 VDD.n431 VDD 0.412605
R4040 VDD VDD.n457 0.412605
R4041 VDD VDD.n3944 0.412605
R4042 VDD VDD.n177 0.412605
R4043 VDD.n2888 VDD 0.412605
R4044 VDD.n2884 VDD 0.412605
R4045 VDD.n3112 VDD 0.412605
R4046 VDD VDD.n3147 0.412605
R4047 VDD.n3138 VDD 0.412605
R4048 VDD.n604 VDD 0.412605
R4049 VDD VDD.n3811 0.412605
R4050 VDD VDD.n3202 0.412605
R4051 VDD VDD.n3072 0.412605
R4052 VDD.n3401 VDD 0.412605
R4053 VDD.n3570 VDD 0.412605
R4054 VDD VDD.n3581 0.412605
R4055 VDD.n3593 VDD 0.412605
R4056 VDD.n2086 VDD.n2020 0.392932
R4057 VDD.n2183 VDD.n2112 0.392932
R4058 VDD.n2240 VDD.n1999 0.392932
R4059 VDD.n1974 VDD.n1972 0.383
R4060 VDD.n3860 VDD.n3859 0.375895
R4061 VDD VDD.n574 0.364413
R4062 VDD.n556 VDD 0.364413
R4063 VDD.n885 VDD.n884 0.361684
R4064 VDD.n891 VDD.n890 0.359331
R4065 VDD VDD.n3082 0.356947
R4066 VDD.n879 VDD.n878 0.347474
R4067 VDD.n1033 VDD 0.344346
R4068 VDD.n2671 VDD.n494 0.334786
R4069 VDD.n3831 VDD.n3830 0.333263
R4070 VDD.n2297 VDD.n1975 0.329711
R4071 VDD.n2643 VDD.n2642 0.316684
R4072 VDD VDD.n589 0.316152
R4073 VDD.n538 VDD 0.316152
R4074 VDD.n2896 VDD.n2895 0.311947
R4075 VDD.n2306 VDD.n1971 0.310763
R4076 VDD.n580 VDD 0.305717
R4077 VDD VDD.n550 0.305717
R4078 VDD VDD.n241 0.303658
R4079 VDD.n318 VDD 0.303658
R4080 VDD.n361 VDD 0.303658
R4081 VDD VDD.n428 0.303658
R4082 VDD VDD.n3109 0.303658
R4083 VDD VDD.n605 0.303658
R4084 VDD.n3571 VDD 0.303658
R4085 VDD.n48 VDD.n47 0.300105
R4086 VDD.n3965 VDD.n3964 0.291816
R4087 VDD.n2039 VDD.n2031 0.289959
R4088 VDD.n2052 VDD.n2028 0.289959
R4089 VDD.n2067 VDD.n2025 0.289959
R4090 VDD.n2071 VDD.n2023 0.289959
R4091 VDD.n2092 VDD.n2018 0.289959
R4092 VDD.n2136 VDD.n2126 0.289959
R4093 VDD.n2150 VDD.n2122 0.289959
R4094 VDD.n2163 VDD.n2118 0.289959
R4095 VDD.n2170 VDD.n2116 0.289959
R4096 VDD.n2190 VDD.n2110 0.289959
R4097 VDD.n2284 VDD.n1987 0.289959
R4098 VDD.n2273 VDD.n2272 0.289959
R4099 VDD.n2259 VDD.n1994 0.289959
R4100 VDD.n2254 VDD.n2253 0.289959
R4101 VDD.n2235 VDD.n2234 0.289959
R4102 VDD.n3953 VDD.n3952 0.285895
R4103 VDD.n3387 VDD 0.265763
R4104 VDD.n2036 VDD.n2035 0.262786
R4105 VDD.n2036 VDD.n2032 0.262786
R4106 VDD.n2040 VDD.n2032 0.262786
R4107 VDD.n2042 VDD.n2041 0.262786
R4108 VDD.n2042 VDD.n2030 0.262786
R4109 VDD.n2046 VDD.n2030 0.262786
R4110 VDD.n2047 VDD.n2029 0.262786
R4111 VDD.n2051 VDD.n2029 0.262786
R4112 VDD.n2053 VDD.n2051 0.262786
R4113 VDD.n2055 VDD.n2054 0.262786
R4114 VDD.n2055 VDD.n2027 0.262786
R4115 VDD.n2059 VDD.n2027 0.262786
R4116 VDD.n2060 VDD.n2026 0.262786
R4117 VDD.n2064 VDD.n2026 0.262786
R4118 VDD.n2065 VDD.n2064 0.262786
R4119 VDD.n2066 VDD.n2024 0.262786
R4120 VDD.n2070 VDD.n2024 0.262786
R4121 VDD.n2072 VDD.n2070 0.262786
R4122 VDD.n2074 VDD.n2073 0.262786
R4123 VDD.n2074 VDD.n2022 0.262786
R4124 VDD.n2078 VDD.n2022 0.262786
R4125 VDD.n2079 VDD.n2021 0.262786
R4126 VDD.n2083 VDD.n2021 0.262786
R4127 VDD.n2084 VDD.n2083 0.262786
R4128 VDD.n2085 VDD.n2019 0.262786
R4129 VDD.n2089 VDD.n2019 0.262786
R4130 VDD.n2090 VDD.n2089 0.262786
R4131 VDD.n2091 VDD.n2017 0.262786
R4132 VDD.n2095 VDD.n2017 0.262786
R4133 VDD.n2096 VDD.n2095 0.262786
R4134 VDD.n2102 VDD.n2101 0.262786
R4135 VDD.n2101 VDD.n2100 0.262786
R4136 VDD.n2100 VDD.n2098 0.262786
R4137 VDD.n2133 VDD.n2132 0.262786
R4138 VDD.n2133 VDD.n2127 0.262786
R4139 VDD.n2137 VDD.n2127 0.262786
R4140 VDD.n2139 VDD.n2138 0.262786
R4141 VDD.n2139 VDD.n2125 0.262786
R4142 VDD.n2144 VDD.n2125 0.262786
R4143 VDD.n2146 VDD.n2145 0.262786
R4144 VDD.n2146 VDD.n2123 0.262786
R4145 VDD.n2151 VDD.n2123 0.262786
R4146 VDD.n2153 VDD.n2152 0.262786
R4147 VDD.n2153 VDD.n2121 0.262786
R4148 VDD.n2158 VDD.n2121 0.262786
R4149 VDD.n2160 VDD.n2159 0.262786
R4150 VDD.n2160 VDD.n2119 0.262786
R4151 VDD.n2164 VDD.n2119 0.262786
R4152 VDD.n2166 VDD.n2165 0.262786
R4153 VDD.n2166 VDD.n2117 0.262786
R4154 VDD.n2171 VDD.n2117 0.262786
R4155 VDD.n2173 VDD.n2172 0.262786
R4156 VDD.n2173 VDD.n2115 0.262786
R4157 VDD.n2178 VDD.n2115 0.262786
R4158 VDD.n2180 VDD.n2179 0.262786
R4159 VDD.n2180 VDD.n2113 0.262786
R4160 VDD.n2184 VDD.n2113 0.262786
R4161 VDD.n2186 VDD.n2185 0.262786
R4162 VDD.n2186 VDD.n2111 0.262786
R4163 VDD.n2191 VDD.n2111 0.262786
R4164 VDD.n2193 VDD.n2192 0.262786
R4165 VDD.n2193 VDD.n2109 0.262786
R4166 VDD.n2198 VDD.n2109 0.262786
R4167 VDD.n2200 VDD.n2199 0.262786
R4168 VDD.n2200 VDD.n2107 0.262786
R4169 VDD.n2204 VDD.n2107 0.262786
R4170 VDD.n2291 VDD.n1986 0.262786
R4171 VDD.n2287 VDD.n1986 0.262786
R4172 VDD.n2287 VDD.n2286 0.262786
R4173 VDD.n2285 VDD.n1988 0.262786
R4174 VDD.n2281 VDD.n1988 0.262786
R4175 VDD.n2281 VDD.n2280 0.262786
R4176 VDD.n2279 VDD.n1990 0.262786
R4177 VDD.n2275 VDD.n1990 0.262786
R4178 VDD.n2275 VDD.n2274 0.262786
R4179 VDD.n2270 VDD.n1991 0.262786
R4180 VDD.n2270 VDD.n2269 0.262786
R4181 VDD.n2269 VDD.n2268 0.262786
R4182 VDD.n2266 VDD.n1993 0.262786
R4183 VDD.n2262 VDD.n1993 0.262786
R4184 VDD.n2262 VDD.n2261 0.262786
R4185 VDD.n2260 VDD.n1995 0.262786
R4186 VDD.n2256 VDD.n1995 0.262786
R4187 VDD.n2256 VDD.n2255 0.262786
R4188 VDD.n2251 VDD.n1996 0.262786
R4189 VDD.n2251 VDD.n2250 0.262786
R4190 VDD.n2250 VDD.n2249 0.262786
R4191 VDD.n2247 VDD.n1998 0.262786
R4192 VDD.n2243 VDD.n1998 0.262786
R4193 VDD.n2243 VDD.n2242 0.262786
R4194 VDD.n2241 VDD.n2000 0.262786
R4195 VDD.n2237 VDD.n2000 0.262786
R4196 VDD.n2237 VDD.n2236 0.262786
R4197 VDD.n2232 VDD.n2001 0.262786
R4198 VDD.n2232 VDD.n2231 0.262786
R4199 VDD.n2231 VDD.n2230 0.262786
R4200 VDD.n2228 VDD.n2003 0.262786
R4201 VDD.n2224 VDD.n2003 0.262786
R4202 VDD.n2224 VDD.n1976 0.262786
R4203 VDD.n2034 VDD.n2007 0.261434
R4204 VDD.n2131 VDD.n2129 0.261434
R4205 VDD.n3804 VDD.n618 0.261026
R4206 VDD.n2293 VDD.n2292 0.26033
R4207 VDD.n244 VDD.n243 0.253921
R4208 VDD.n327 VDD.n212 0.253921
R4209 VDD.n360 VDD.n356 0.253921
R4210 VDD.n432 VDD.n430 0.253921
R4211 VDD.n3113 VDD.n3111 0.253921
R4212 VDD.n3833 VDD.n3832 0.253921
R4213 VDD.n3656 VDD.n3069 0.253921
R4214 VDD.n3580 VDD.n3567 0.253921
R4215 VDD.n3953 VDD.n162 0.252737
R4216 VDD.n3148 VDD.n3123 0.252737
R4217 VDD.n3821 VDD.n3820 0.252737
R4218 VDD.n3569 VDD.n3222 0.252737
R4219 VDD.n3965 VDD.n148 0.252737
R4220 VDD.n2925 VDD.n2647 0.252737
R4221 VDD.n529 VDD.n503 0.252737
R4222 VDD.n3860 VDD.n526 0.252737
R4223 VDD.n48 VDD.n15 0.252737
R4224 VDD.n592 VDD.n591 0.251799
R4225 VDD.n3895 VDD.n498 0.249461
R4226 VDD.n2267 VDD.n1984 0.2405
R4227 VDD.n2248 VDD.n1983 0.2405
R4228 VDD.n2229 VDD.n1982 0.2405
R4229 VDD.n2058 VDD.n2011 0.238473
R4230 VDD.n2077 VDD.n2013 0.238473
R4231 VDD.n2104 VDD.n2015 0.238473
R4232 VDD.n2157 VDD.n2156 0.238473
R4233 VDD.n2177 VDD.n2176 0.238473
R4234 VDD.n2197 VDD.n2196 0.238473
R4235 VDD.n2895 VDD.n2889 0.237342
R4236 VDD.n3909 VDD.n486 0.237342
R4237 VDD.n3195 VDD.n3189 0.237342
R4238 VDD.n3635 VDD.n3222 0.237342
R4239 VDD.n3960 VDD.n148 0.237342
R4240 VDD.n2647 VDD.n2643 0.237342
R4241 VDD.n3886 VDD.n503 0.237342
R4242 VDD.n3852 VDD.n526 0.237342
R4243 VDD.n4167 VDD.n15 0.237342
R4244 VDD.n890 VDD.t137 0.236659
R4245 VDD.n888 VDD.t135 0.236659
R4246 VDD.n889 VDD.t134 0.236659
R4247 VDD.n882 VDD.t217 0.236659
R4248 VDD.n884 VDD.t219 0.236659
R4249 VDD.n883 VDD.t220 0.236659
R4250 VDD.n876 VDD.t589 0.236659
R4251 VDD.n878 VDD.t119 0.236659
R4252 VDD.n877 VDD.t587 0.236659
R4253 VDD.n2649 VDD.n2648 0.234266
R4254 VDD.n3939 VDD.n3938 0.226684
R4255 VDD.n252 VDD 0.221947
R4256 VDD VDD.n292 0.221947
R4257 VDD.n294 VDD 0.221947
R4258 VDD.n310 VDD 0.221947
R4259 VDD.n315 VDD 0.221947
R4260 VDD.n330 VDD 0.221947
R4261 VDD.n335 VDD 0.221947
R4262 VDD VDD.n352 0.221947
R4263 VDD.n368 VDD 0.221947
R4264 VDD VDD.n398 0.221947
R4265 VDD.n400 VDD 0.221947
R4266 VDD.n416 VDD 0.221947
R4267 VDD.n421 VDD 0.221947
R4268 VDD VDD.n436 0.221947
R4269 VDD.n459 VDD 0.221947
R4270 VDD.n3951 VDD 0.221947
R4271 VDD.n3946 VDD 0.221947
R4272 VDD.n3924 VDD 0.221947
R4273 VDD VDD.n3923 0.221947
R4274 VDD.n2882 VDD 0.221947
R4275 VDD.n3911 VDD 0.221947
R4276 VDD VDD.n3117 0.221947
R4277 VDD.n3156 VDD 0.221947
R4278 VDD.n3818 VDD 0.221947
R4279 VDD.n3813 VDD 0.221947
R4280 VDD VDD.n3188 0.221947
R4281 VDD.n3204 VDD 0.221947
R4282 VDD.n3650 VDD 0.221947
R4283 VDD VDD.n3649 0.221947
R4284 VDD.n3399 VDD 0.221947
R4285 VDD.n3637 VDD 0.221947
R4286 VDD.n3657 VDD 0.219579
R4287 VDD.n2223 VDD.n2222 0.217797
R4288 VDD.n3131 VDD 0.217211
R4289 VDD.n2220 VDD.n2004 0.21577
R4290 VDD.n2203 VDD.n2006 0.215365
R4291 VDD.n447 VDD 0.214842
R4292 VDD.n3805 VDD.n3804 0.210105
R4293 VDD.n4165 VDD.n17 0.2094
R4294 VDD.n872 VDD.n871 0.203726
R4295 VDD.n871 VDD.n858 0.203726
R4296 VDD.n870 VDD.n869 0.203726
R4297 VDD.n870 VDD.n860 0.203726
R4298 VDD.n862 VDD.n861 0.203726
R4299 VDD.n864 VDD.n861 0.203726
R4300 VDD.n902 VDD.n901 0.201862
R4301 VDD.n448 VDD.n447 0.198263
R4302 VDD.n3850 VDD.n3848 0.1902
R4303 VDD.n3884 VDD.n505 0.19
R4304 VDD.n3903 VDD.n3902 0.1893
R4305 VDD.n2911 VDD.n2905 0.1888
R4306 VDD.n3933 VDD.n170 0.1887
R4307 VDD.n3958 VDD.n3956 0.1882
R4308 VDD.n3845 VDD.n3844 0.186421
R4309 VDD.n1971 VDD.n1970 0.179316
R4310 VDD.n3888 VDD.n3886 0.179316
R4311 VDD.n3983 VDD.n3982 0.173395
R4312 VDD.n231 VDD.n230 0.173395
R4313 VDD.n256 VDD.n223 0.173395
R4314 VDD.n257 VDD.n222 0.173395
R4315 VDD.n287 VDD.n262 0.173395
R4316 VDD.n265 VDD.n264 0.173395
R4317 VDD.n283 VDD.n268 0.173395
R4318 VDD.n271 VDD.n270 0.173395
R4319 VDD.n279 VDD.n274 0.173395
R4320 VDD.n276 VDD.n275 0.173395
R4321 VDD.n372 VDD.n201 0.173395
R4322 VDD.n395 VDD.n375 0.173395
R4323 VDD.n392 VDD.n391 0.173395
R4324 VDD.n378 VDD.n377 0.173395
R4325 VDD.n386 VDD.n381 0.173395
R4326 VDD.n383 VDD.n382 0.173395
R4327 VDD.n463 VDD.n182 0.173395
R4328 VDD.n467 VDD.n466 0.173395
R4329 VDD.n472 VDD.n181 0.173395
R4330 VDD.n474 VDD.n473 0.173395
R4331 VDD.n3919 VDD.n479 0.173395
R4332 VDD.n3915 VDD.n483 0.173395
R4333 VDD.n3094 VDD.n3093 0.173395
R4334 VDD.n3098 VDD.n3097 0.173395
R4335 VDD.n3160 VDD.n3087 0.173395
R4336 VDD.n3166 VDD.n3163 0.173395
R4337 VDD.n3170 VDD.n3085 0.173395
R4338 VDD.n3174 VDD.n3173 0.173395
R4339 VDD.n3179 VDD.n3084 0.173395
R4340 VDD.n3183 VDD.n3182 0.173395
R4341 VDD.n3208 VDD.n3076 0.173395
R4342 VDD.n3210 VDD.n3209 0.173395
R4343 VDD.n3645 VDD.n3215 0.173395
R4344 VDD.n3641 VDD.n3219 0.173395
R4345 VDD.n3557 VDD.n3556 0.173395
R4346 VDD.n3565 VDD.n3560 0.173395
R4347 VDD.n250 VDD.n249 0.173395
R4348 VDD.n243 VDD.n242 0.173395
R4349 VDD.n298 VDD.n218 0.173395
R4350 VDD.n308 VDD.n307 0.173395
R4351 VDD.n321 VDD.n317 0.173395
R4352 VDD.n328 VDD.n327 0.173395
R4353 VDD.n341 VDD.n337 0.173395
R4354 VDD.n348 VDD.n347 0.173395
R4355 VDD.n366 VDD.n365 0.173395
R4356 VDD.n356 VDD.n355 0.173395
R4357 VDD.n404 VDD.n196 0.173395
R4358 VDD.n414 VDD.n413 0.173395
R4359 VDD.n424 VDD.n423 0.173395
R4360 VDD.n432 VDD.n431 0.173395
R4361 VDD.n457 VDD.n456 0.173395
R4362 VDD.n450 VDD.n448 0.173395
R4363 VDD.n3944 VDD.n3943 0.173395
R4364 VDD.n2896 VDD.n2888 0.173395
R4365 VDD.n2885 VDD.n2884 0.173395
R4366 VDD.n3105 VDD.n3103 0.173395
R4367 VDD.n3113 VDD.n3112 0.173395
R4368 VDD.n3147 VDD.n3146 0.173395
R4369 VDD.n3140 VDD.n3138 0.173395
R4370 VDD.n3840 VDD.n604 0.173395
R4371 VDD.n3832 VDD.n3831 0.173395
R4372 VDD.n3811 VDD.n3810 0.173395
R4373 VDD.n3081 VDD.n618 0.173395
R4374 VDD.n3202 VDD.n3201 0.173395
R4375 VDD.n3072 VDD.n3069 0.173395
R4376 VDD.n3402 VDD.n3401 0.173395
R4377 VDD.n3574 VDD.n3570 0.173395
R4378 VDD.n3581 VDD.n3580 0.173395
R4379 VDD.n3602 VDD.n3593 0.173395
R4380 VDD.n4178 VDD.n4168 0.173395
R4381 VDD.n1009 VDD.n1008 0.173103
R4382 VDD.n1010 VDD.n1005 0.173103
R4383 VDD.n1030 VDD.n1029 0.173103
R4384 VDD.n950 VDD.n949 0.173103
R4385 VDD.n951 VDD.n946 0.173103
R4386 VDD.n960 VDD.n959 0.173103
R4387 VDD.n2920 VDD.n2919 0.172318
R4388 VDD.n2671 VDD.n2670 0.172318
R4389 VDD.n3889 VDD.n502 0.172211
R4390 VDD.n535 VDD.n534 0.172211
R4391 VDD.n595 VDD.n594 0.172211
R4392 VDD.n2654 VDD.n2650 0.171149
R4393 VDD.n501 VDD.n499 0.171149
R4394 VDD.n2305 VDD.n2304 0.171026
R4395 VDD.n226 VDD.n225 0.171026
R4396 VDD.n259 VDD.n258 0.171026
R4397 VDD.n261 VDD.n260 0.171026
R4398 VDD.n286 VDD.n263 0.171026
R4399 VDD.n267 VDD.n266 0.171026
R4400 VDD.n282 VDD.n269 0.171026
R4401 VDD.n273 VDD.n272 0.171026
R4402 VDD.n278 VDD.n277 0.171026
R4403 VDD.n204 VDD.n203 0.171026
R4404 VDD.n374 VDD.n373 0.171026
R4405 VDD.n394 VDD.n393 0.171026
R4406 VDD.n389 VDD.n376 0.171026
R4407 VDD.n380 VDD.n379 0.171026
R4408 VDD.n385 VDD.n384 0.171026
R4409 VDD.n185 VDD.n184 0.171026
R4410 VDD.n469 VDD.n468 0.171026
R4411 VDD.n465 VDD.n464 0.171026
R4412 VDD.n476 VDD.n475 0.171026
R4413 VDD.n478 VDD.n180 0.171026
R4414 VDD.n3918 VDD.n480 0.171026
R4415 VDD.n3914 VDD.n484 0.171026
R4416 VDD.n3096 VDD.n3095 0.171026
R4417 VDD.n3090 VDD.n3089 0.171026
R4418 VDD.n3162 VDD.n3161 0.171026
R4419 VDD.n3165 VDD.n3164 0.171026
R4420 VDD.n3176 VDD.n3175 0.171026
R4421 VDD.n3172 VDD.n3171 0.171026
R4422 VDD.n3181 VDD.n3180 0.171026
R4423 VDD.n3079 VDD.n3078 0.171026
R4424 VDD.n3212 VDD.n3211 0.171026
R4425 VDD.n3214 VDD.n3075 0.171026
R4426 VDD.n3644 VDD.n3216 0.171026
R4427 VDD.n3640 VDD.n3220 0.171026
R4428 VDD.n3559 VDD.n3558 0.171026
R4429 VDD.n3564 VDD.n3563 0.171026
R4430 VDD.n236 VDD.n228 0.171026
R4431 VDD.n252 VDD.n251 0.171026
R4432 VDD.n292 VDD.n221 0.171026
R4433 VDD.n294 VDD.n293 0.171026
R4434 VDD.n310 VDD.n309 0.171026
R4435 VDD.n316 VDD.n315 0.171026
R4436 VDD.n330 VDD.n329 0.171026
R4437 VDD.n336 VDD.n335 0.171026
R4438 VDD.n352 VDD.n206 0.171026
R4439 VDD.n368 VDD.n367 0.171026
R4440 VDD.n398 VDD.n199 0.171026
R4441 VDD.n400 VDD.n399 0.171026
R4442 VDD.n416 VDD.n415 0.171026
R4443 VDD.n422 VDD.n421 0.171026
R4444 VDD.n436 VDD.n187 0.171026
R4445 VDD.n459 VDD.n458 0.171026
R4446 VDD.n3952 VDD.n3951 0.171026
R4447 VDD.n3946 VDD.n3945 0.171026
R4448 VDD.n3924 VDD.n178 0.171026
R4449 VDD.n3923 VDD.n179 0.171026
R4450 VDD.n2883 VDD.n2882 0.171026
R4451 VDD.n3911 VDD.n3910 0.171026
R4452 VDD.n3117 VDD.n3092 0.171026
R4453 VDD.n3130 VDD.n3129 0.171026
R4454 VDD.n3844 VDD.n601 0.171026
R4455 VDD.n3819 VDD.n3818 0.171026
R4456 VDD.n3813 VDD.n3812 0.171026
R4457 VDD.n3188 VDD.n3083 0.171026
R4458 VDD.n3204 VDD.n3203 0.171026
R4459 VDD.n3650 VDD.n3073 0.171026
R4460 VDD.n3649 VDD.n3074 0.171026
R4461 VDD.n3400 VDD.n3399 0.171026
R4462 VDD.n3637 VDD.n3636 0.171026
R4463 VDD.n3606 VDD.n3553 0.171026
R4464 VDD.n3411 VDD.n3394 0.169842
R4465 VDD.n2889 VDD.n2877 0.168658
R4466 VDD.n3929 VDD.n3928 0.167474
R4467 VDD.n3607 VDD 0.166289
R4468 VDD VDD.n236 0.161553
R4469 VDD.n3821 VDD 0.158
R4470 VDD.n3123 VDD.n3118 0.156816
R4471 VDD.n997 VDD.t608 0.156216
R4472 VDD.n996 VDD.t617 0.156216
R4473 VDD.n995 VDD.t618 0.156216
R4474 VDD.n994 VDD.t615 0.156216
R4475 VDD.n993 VDD.t609 0.156216
R4476 VDD.n992 VDD.t616 0.156216
R4477 VDD.n990 VDD.t584 0.156216
R4478 VDD.n989 VDD.t597 0.156216
R4479 VDD.n988 VDD.t583 0.156216
R4480 VDD.n987 VDD.t186 0.156216
R4481 VDD.n986 VDD.t586 0.156216
R4482 VDD.n985 VDD.t596 0.156216
R4483 VDD.n984 VDD.t582 0.156216
R4484 VDD.n983 VDD.t600 0.156216
R4485 VDD.n982 VDD.t594 0.156216
R4486 VDD.n980 VDD.t344 0.156216
R4487 VDD.n979 VDD.t327 0.156216
R4488 VDD.n978 VDD.t346 0.156216
R4489 VDD.n977 VDD.t340 0.156216
R4490 VDD.n976 VDD.t341 0.156216
R4491 VDD.n975 VDD.t328 0.156216
R4492 VDD.n974 VDD.t322 0.156216
R4493 VDD.n973 VDD.t324 0.156216
R4494 VDD.n972 VDD.t333 0.156216
R4495 VDD.n971 VDD.t332 0.156216
R4496 VDD.n970 VDD.t338 0.156216
R4497 VDD.n969 VDD.t334 0.156216
R4498 VDD.n968 VDD.t330 0.156216
R4499 VDD.n967 VDD.t331 0.156216
R4500 VDD.n966 VDD.t339 0.156216
R4501 VDD.n965 VDD.t335 0.156216
R4502 VDD.n964 VDD.t337 0.156216
R4503 VDD.n963 VDD.t345 0.156216
R4504 VDD.n1000 VDD.t614 0.156216
R4505 VDD.n999 VDD.t606 0.156216
R4506 VDD.n998 VDD.t604 0.156216
R4507 VDD.n938 VDD.t174 0.156216
R4508 VDD.n937 VDD.t524 0.156216
R4509 VDD.n936 VDD.t525 0.156216
R4510 VDD.n935 VDD.t522 0.156216
R4511 VDD.n934 VDD.t689 0.156216
R4512 VDD.n933 VDD.t523 0.156216
R4513 VDD.n931 VDD.t191 0.156216
R4514 VDD.n930 VDD.t184 0.156216
R4515 VDD.n929 VDD.t190 0.156216
R4516 VDD.n928 VDD.t592 0.156216
R4517 VDD.n927 VDD.t192 0.156216
R4518 VDD.n926 VDD.t585 0.156216
R4519 VDD.n925 VDD.t189 0.156216
R4520 VDD.n924 VDD.t188 0.156216
R4521 VDD.n923 VDD.t598 0.156216
R4522 VDD.n921 VDD.t62 0.156216
R4523 VDD.n920 VDD.t230 0.156216
R4524 VDD.n919 VDD.t59 0.156216
R4525 VDD.n918 VDD.t91 0.156216
R4526 VDD.n917 VDD.t89 0.156216
R4527 VDD.n916 VDD.t229 0.156216
R4528 VDD.n915 VDD.t58 0.156216
R4529 VDD.n914 VDD.t232 0.156216
R4530 VDD.n913 VDD.t704 0.156216
R4531 VDD.n912 VDD.t702 0.156216
R4532 VDD.n911 VDD.t92 0.156216
R4533 VDD.n910 VDD.t80 0.156216
R4534 VDD.n909 VDD.t705 0.156216
R4535 VDD.n908 VDD.t703 0.156216
R4536 VDD.n907 VDD.t90 0.156216
R4537 VDD.n906 VDD.t79 0.156216
R4538 VDD.n905 VDD.t94 0.156216
R4539 VDD.n904 VDD.t233 0.156216
R4540 VDD.n941 VDD.t520 0.156216
R4541 VDD.n940 VDD.t528 0.156216
R4542 VDD.n939 VDD.t526 0.156216
R4543 VDD.n2061 VDD.n2011 0.154959
R4544 VDD.n2156 VDD.n2120 0.154959
R4545 VDD.n2265 VDD.n1984 0.152932
R4546 VDD.n3148 VDD 0.152079
R4547 VDD.n3820 VDD.n3819 0.150895
R4548 VDD.n301 VDD.n216 0.149711
R4549 VDD.n346 VDD.n208 0.149711
R4550 VDD.n407 VDD.n194 0.149711
R4551 VDD.n451 VDD.n441 0.149711
R4552 VDD.n2901 VDD.n2878 0.149711
R4553 VDD.n3141 VDD.n3128 0.149711
R4554 VDD.n3805 VDD.n617 0.149711
R4555 VDD.n3398 VDD.n3395 0.149711
R4556 VDD.n3387 VDD.n3386 0.147342
R4557 VDD.n2295 VDD.n1977 0.147257
R4558 VDD.n2219 VDD.n2005 0.146851
R4559 VDD.n2207 VDD.n2206 0.146851
R4560 VDD.n241 VDD.n237 0.144974
R4561 VDD.n301 VDD.n300 0.144974
R4562 VDD.n320 VDD.n318 0.144974
R4563 VDD.n340 VDD.n208 0.144974
R4564 VDD.n361 VDD.n353 0.144974
R4565 VDD.n407 VDD.n406 0.144974
R4566 VDD.n428 VDD.n190 0.144974
R4567 VDD.n441 VDD.n437 0.144974
R4568 VDD.n3939 VDD.n165 0.144974
R4569 VDD.n3109 VDD.n3101 0.144974
R4570 VDD.n3128 VDD.n3124 0.144974
R4571 VDD.n3839 VDD.n605 0.144974
R4572 VDD.n617 VDD.n613 0.144974
R4573 VDD.n3196 VDD.n3068 0.144974
R4574 VDD.n3410 VDD.n3395 0.144974
R4575 VDD.n3573 VDD.n3571 0.144974
R4576 VDD.n3601 VDD.n3594 0.144974
R4577 VDD.n1968 VDD.n1134 0.1375
R4578 VDD.n585 VDD.t244 0.135905
R4579 VDD.n584 VDD.t243 0.135905
R4580 VDD.n583 VDD.t250 0.135905
R4581 VDD.n582 VDD.t238 0.135905
R4582 VDD.n567 VDD.t25 0.135905
R4583 VDD.n566 VDD.t24 0.135905
R4584 VDD.n565 VDD.t45 0.135905
R4585 VDD.n564 VDD.t43 0.135905
R4586 VDD.n572 VDD.t179 0.135905
R4587 VDD.n571 VDD.t178 0.135905
R4588 VDD.n570 VDD.t162 0.135905
R4589 VDD.n569 VDD.t180 0.135905
R4590 VDD.n578 VDD.t251 0.135905
R4591 VDD.n577 VDD.t673 0.135905
R4592 VDD.n576 VDD.t241 0.135905
R4593 VDD.n575 VDD.t252 0.135905
R4594 VDD.n561 VDD.t158 0.135905
R4595 VDD.n560 VDD.t157 0.135905
R4596 VDD.n559 VDD.t177 0.135905
R4597 VDD.n558 VDD.t159 0.135905
R4598 VDD.n554 VDD.t546 0.135905
R4599 VDD.n553 VDD.t545 0.135905
R4600 VDD.n552 VDD.t723 0.135905
R4601 VDD.n551 VDD.t547 0.135905
R4602 VDD.n548 VDD.t111 0.135905
R4603 VDD.n547 VDD.t110 0.135905
R4604 VDD.n546 VDD.t692 0.135905
R4605 VDD.n545 VDD.t112 0.135905
R4606 VDD.n543 VDD.t691 0.135905
R4607 VDD.n542 VDD.t690 0.135905
R4608 VDD.n541 VDD.t97 0.135905
R4609 VDD.n540 VDD.t521 0.135905
R4610 VDD.n3590 VDD.n3589 0.1355
R4611 VDD.n2651 VDD.n498 0.134916
R4612 VDD VDD.n3909 0.134316
R4613 VDD.n892 VDD.n887 0.134189
R4614 VDD.n2915 VDD.n2649 0.133747
R4615 VDD.n886 VDD.n881 0.132442
R4616 VDD.n2207 VDD.n2006 0.125365
R4617 VDD.n2220 VDD.n2219 0.124959
R4618 VDD.n2222 VDD.n1977 0.124554
R4619 VDD.n2104 VDD.n2103 0.124149
R4620 VDD.n2196 VDD.n2108 0.124149
R4621 VDD VDD.n324 0.122534
R4622 VDD.n359 VDD 0.122534
R4623 VDD.n429 VDD 0.122534
R4624 VDD VDD.n173 0.122534
R4625 VDD.n3110 VDD 0.122534
R4626 VDD VDD.n3834 0.122534
R4627 VDD.n3655 VDD 0.122534
R4628 VDD VDD.n3577 0.122534
R4629 VDD VDD.n245 0.122534
R4630 VDD.n2227 VDD.n1982 0.122122
R4631 VDD.n2217 VDD 0.122
R4632 VDD.n2915 VDD.n2914 0.116214
R4633 VDD.n962 VDD.n943 0.115885
R4634 VDD.n1032 VDD.n1002 0.114346
R4635 VDD.n2298 VDD.n2297 0.111816
R4636 VDD.n304 VDD.n303 0.108658
R4637 VDD.n345 VDD.n209 0.108658
R4638 VDD.n410 VDD.n409 0.108658
R4639 VDD.n453 VDD.n452 0.108658
R4640 VDD.n2899 VDD.n2880 0.108658
R4641 VDD.n3143 VDD.n3142 0.108658
R4642 VDD.n3807 VDD.n3806 0.108658
R4643 VDD.n3407 VDD.n3396 0.108658
R4644 VDD.n0 VDD.t171 0.108357
R4645 VDD.n1 VDD.t215 0.108357
R4646 VDD.n2 VDD.t212 0.108357
R4647 VDD.n4 VDD.t254 0.108357
R4648 VDD.n7 VDD.t308 0.108357
R4649 VDD.n8 VDD.t15 0.108357
R4650 VDD.n9 VDD.t167 0.108357
R4651 VDD.n11 VDD.t310 0.108357
R4652 VDD.n3191 VDD 0.1062
R4653 VDD.n1036 VDD 0.103526
R4654 VDD.n3590 VDD.n3583 0.102342
R4655 VDD.n2306 VDD.n2305 0.0999737
R4656 VDD.n2651 VDD.n494 0.0998506
R4657 VDD.n3985 VDD.n3984 0.0963235
R4658 VDD.n4006 VDD.n133 0.0963235
R4659 VDD.n1104 VDD.n855 0.0963235
R4660 VDD.n3595 VDD 0.0952368
R4661 VDD.n3156 VDD.n3155 0.0905
R4662 VDD.n3393 VDD.n3386 0.0905
R4663 VDD.n177 VDD.n172 0.0881316
R4664 VDD.n3929 VDD.n171 0.0869474
R4665 VDD.n3589 VDD 0.0869474
R4666 VDD.n3984 VDD.n132 0.0867941
R4667 VDD.n854 VDD.n133 0.0867941
R4668 VDD.n1086 VDD.n855 0.0867941
R4669 VDD.n3928 VDD.n172 0.0857632
R4670 VDD.n2902 VDD.n2877 0.084579
R4671 VDD.n3657 VDD.n3068 0.084579
R4672 VDD.n3394 VDD.n3393 0.0833947
R4673 VDD.n2037 VDD.n2033 0.0832027
R4674 VDD.n2038 VDD.n2037 0.0832027
R4675 VDD.n2039 VDD.n2038 0.0832027
R4676 VDD.n2043 VDD.n2031 0.0832027
R4677 VDD.n2044 VDD.n2043 0.0832027
R4678 VDD.n2045 VDD.n2044 0.0832027
R4679 VDD.n2049 VDD.n2048 0.0832027
R4680 VDD.n2050 VDD.n2049 0.0832027
R4681 VDD.n2056 VDD.n2028 0.0832027
R4682 VDD.n2057 VDD.n2056 0.0832027
R4683 VDD.n2058 VDD.n2057 0.0832027
R4684 VDD.n2062 VDD.n2061 0.0832027
R4685 VDD.n2063 VDD.n2062 0.0832027
R4686 VDD.n2063 VDD.n2025 0.0832027
R4687 VDD.n2068 VDD.n2067 0.0832027
R4688 VDD.n2069 VDD.n2068 0.0832027
R4689 VDD.n2075 VDD.n2023 0.0832027
R4690 VDD.n2076 VDD.n2075 0.0832027
R4691 VDD.n2077 VDD.n2076 0.0832027
R4692 VDD.n2081 VDD.n2080 0.0832027
R4693 VDD.n2082 VDD.n2081 0.0832027
R4694 VDD.n2082 VDD.n2020 0.0832027
R4695 VDD.n2087 VDD.n2086 0.0832027
R4696 VDD.n2088 VDD.n2087 0.0832027
R4697 VDD.n2093 VDD.n2092 0.0832027
R4698 VDD.n2094 VDD.n2093 0.0832027
R4699 VDD.n2094 VDD.n2015 0.0832027
R4700 VDD.n2103 VDD.n2016 0.0832027
R4701 VDD.n2099 VDD.n2016 0.0832027
R4702 VDD.n2099 VDD.n2004 0.0832027
R4703 VDD.n2134 VDD.n2128 0.0832027
R4704 VDD.n2135 VDD.n2134 0.0832027
R4705 VDD.n2136 VDD.n2135 0.0832027
R4706 VDD.n2140 VDD.n2126 0.0832027
R4707 VDD.n2141 VDD.n2140 0.0832027
R4708 VDD.n2143 VDD.n2141 0.0832027
R4709 VDD.n2147 VDD.n2124 0.0832027
R4710 VDD.n2148 VDD.n2147 0.0832027
R4711 VDD.n2154 VDD.n2122 0.0832027
R4712 VDD.n2155 VDD.n2154 0.0832027
R4713 VDD.n2157 VDD.n2155 0.0832027
R4714 VDD.n2161 VDD.n2120 0.0832027
R4715 VDD.n2162 VDD.n2161 0.0832027
R4716 VDD.n2163 VDD.n2162 0.0832027
R4717 VDD.n2167 VDD.n2118 0.0832027
R4718 VDD.n2168 VDD.n2167 0.0832027
R4719 VDD.n2174 VDD.n2116 0.0832027
R4720 VDD.n2175 VDD.n2174 0.0832027
R4721 VDD.n2177 VDD.n2175 0.0832027
R4722 VDD.n2181 VDD.n2114 0.0832027
R4723 VDD.n2182 VDD.n2181 0.0832027
R4724 VDD.n2183 VDD.n2182 0.0832027
R4725 VDD.n2187 VDD.n2112 0.0832027
R4726 VDD.n2188 VDD.n2187 0.0832027
R4727 VDD.n2194 VDD.n2110 0.0832027
R4728 VDD.n2195 VDD.n2194 0.0832027
R4729 VDD.n2197 VDD.n2195 0.0832027
R4730 VDD.n2201 VDD.n2108 0.0832027
R4731 VDD.n2202 VDD.n2201 0.0832027
R4732 VDD.n2203 VDD.n2202 0.0832027
R4733 VDD.n2290 VDD.n2289 0.0832027
R4734 VDD.n2289 VDD.n2288 0.0832027
R4735 VDD.n2288 VDD.n1987 0.0832027
R4736 VDD.n2284 VDD.n2283 0.0832027
R4737 VDD.n2283 VDD.n2282 0.0832027
R4738 VDD.n2282 VDD.n1989 0.0832027
R4739 VDD.n2278 VDD.n2277 0.0832027
R4740 VDD.n2277 VDD.n2276 0.0832027
R4741 VDD.n2272 VDD.n2271 0.0832027
R4742 VDD.n2271 VDD.n1992 0.0832027
R4743 VDD.n2267 VDD.n1992 0.0832027
R4744 VDD.n2265 VDD.n2264 0.0832027
R4745 VDD.n2264 VDD.n2263 0.0832027
R4746 VDD.n2263 VDD.n1994 0.0832027
R4747 VDD.n2259 VDD.n2258 0.0832027
R4748 VDD.n2258 VDD.n2257 0.0832027
R4749 VDD.n2253 VDD.n2252 0.0832027
R4750 VDD.n2252 VDD.n1997 0.0832027
R4751 VDD.n2248 VDD.n1997 0.0832027
R4752 VDD.n2246 VDD.n2245 0.0832027
R4753 VDD.n2245 VDD.n2244 0.0832027
R4754 VDD.n2244 VDD.n1999 0.0832027
R4755 VDD.n2240 VDD.n2239 0.0832027
R4756 VDD.n2239 VDD.n2238 0.0832027
R4757 VDD.n2234 VDD.n2233 0.0832027
R4758 VDD.n2233 VDD.n2002 0.0832027
R4759 VDD.n2229 VDD.n2002 0.0832027
R4760 VDD.n2227 VDD.n2226 0.0832027
R4761 VDD.n2226 VDD.n2225 0.0832027
R4762 VDD.n2225 VDD.n2223 0.0832027
R4763 VDD.n2052 VDD.n2010 0.0827973
R4764 VDD.n2071 VDD.n2012 0.0827973
R4765 VDD.n2018 VDD.n2014 0.0827973
R4766 VDD.n2150 VDD.n2149 0.0827973
R4767 VDD.n2170 VDD.n2169 0.0827973
R4768 VDD.n2190 VDD.n2189 0.0827973
R4769 VDD.n3155 VDD.n3118 0.0810263
R4770 VDD.n2273 VDD.n1979 0.0807703
R4771 VDD.n2254 VDD.n1980 0.0807703
R4772 VDD.n2235 VDD.n1981 0.0807703
R4773 VDD.n4007 VDD.n132 0.0799118
R4774 VDD.n1105 VDD.n854 0.0799118
R4775 VDD.n1086 VDD.n1085 0.0799118
R4776 VDD.n3830 VDD 0.0798421
R4777 VDD.n3597 VDD 0.0786579
R4778 VDD.n3938 VDD 0.0774737
R4779 VDD.n1966 VDD.n1961 0.0771116
R4780 VDD.n3797 VDD.n619 0.0771116
R4781 VDD.n244 VDD 0.0739211
R4782 VDD VDD.n212 0.0739211
R4783 VDD VDD.n360 0.0739211
R4784 VDD.n430 VDD 0.0739211
R4785 VDD.n171 VDD 0.0739211
R4786 VDD.n3111 VDD 0.0739211
R4787 VDD.n3833 VDD 0.0739211
R4788 VDD VDD.n3656 0.0739211
R4789 VDD VDD.n3567 0.0739211
R4790 VDD.n2033 VDD.n2008 0.0722568
R4791 VDD.n2130 VDD.n2128 0.0722568
R4792 VDD.n2290 VDD.n1978 0.0702297
R4793 VDD.n3583 VDD.n3582 0.0691842
R4794 VDD.n2919 VDD.n2648 0.0671234
R4795 VDD.n3137 VDD.n3129 0.0620789
R4796 VDD.n3636 VDD.n3635 0.0620789
R4797 VDD.n2902 VDD.n2901 0.0608947
R4798 VDD.n3082 VDD.n3081 0.0561579
R4799 VDD.n3607 VDD.n3606 0.0561579
R4800 VDD.n1042 VDD 0.0549737
R4801 VDD VDD.n238 0.0549737
R4802 VDD.n299 VDD 0.0549737
R4803 VDD.n319 VDD 0.0549737
R4804 VDD.n339 VDD 0.0549737
R4805 VDD VDD.n354 0.0549737
R4806 VDD.n405 VDD 0.0549737
R4807 VDD VDD.n191 0.0549737
R4808 VDD VDD.n439 0.0549737
R4809 VDD VDD.n166 0.0549737
R4810 VDD VDD.n2879 0.0549737
R4811 VDD VDD.n3102 0.0549737
R4812 VDD VDD.n3126 0.0549737
R4813 VDD.n3838 VDD 0.0549737
R4814 VDD VDD.n615 0.0549737
R4815 VDD VDD.n3197 0.0549737
R4816 VDD.n3409 VDD 0.0549737
R4817 VDD.n3572 VDD 0.0549737
R4818 VDD.n3600 VDD 0.0549737
R4819 VDD.n2080 VDD.n2013 0.0519865
R4820 VDD.n2176 VDD.n2114 0.0519865
R4821 VDD.n1039 VDD 0.0502368
R4822 VDD.n2246 VDD.n1983 0.0499595
R4823 VDD.n1970 VDD 0.0490526
R4824 VDD.n1050 VDD 0.0466842
R4825 VDD.n1047 VDD 0.0455
R4826 VDD.n239 VDD 0.0423421
R4827 VDD.n302 VDD 0.0423421
R4828 VDD VDD.n213 0.0423421
R4829 VDD VDD.n338 0.0423421
R4830 VDD.n362 VDD 0.0423421
R4831 VDD.n408 VDD 0.0423421
R4832 VDD.n427 VDD 0.0423421
R4833 VDD.n440 VDD 0.0423421
R4834 VDD.n3940 VDD 0.0423421
R4835 VDD.n2900 VDD 0.0423421
R4836 VDD.n3108 VDD 0.0423421
R4837 VDD.n3127 VDD 0.0423421
R4838 VDD VDD.n3837 0.0423421
R4839 VDD.n616 VDD 0.0423421
R4840 VDD.n3198 VDD 0.0423421
R4841 VDD VDD.n3408 0.0423421
R4842 VDD VDD.n3568 0.0423421
R4843 VDD VDD.n3599 0.0423421
R4844 VDD.n3103 VDD.n486 0.0419474
R4845 VDD.n2308 VDD.n2307 0.0402934
R4846 VDD.n3897 VDD.n3896 0.0402934
R4847 VDD.n2913 VDD.n2677 0.0402934
R4848 VDD.n3824 VDD.n609 0.0402934
R4849 VDD.n3862 VDD.n3861 0.0402934
R4850 VDD.n3847 VDD.n3846 0.0402934
R4851 VDD.n3150 VDD.n3149 0.0402934
R4852 VDD.n3609 VDD.n3608 0.0402934
R4853 VDD.n3629 VDD.n3225 0.0402934
R4854 VDD.n3413 VDD.n3412 0.0402934
R4855 VDD.n3904 VDD.n491 0.0402934
R4856 VDD.n2927 VDD.n2926 0.0402934
R4857 VDD.n3932 VDD.n169 0.0402934
R4858 VDD.n3798 VDD.n621 0.0402934
R4859 VDD.n2904 VDD.n2903 0.0402934
R4860 VDD.n3659 VDD.n3658 0.0402934
R4861 VDD.n3955 VDD.n3954 0.0402934
R4862 VDD.n3967 VDD.n3966 0.0402934
R4863 VDD.n3881 VDD.n509 0.0402934
R4864 VDD.n4162 VDD.n49 0.0402934
R4865 VDD.n3900 VDD.n495 0.0391777
R4866 VDD.n2909 VDD.n2908 0.0391777
R4867 VDD.n3822 VDD.n607 0.0391777
R4868 VDD.n597 VDD.n596 0.0391777
R4869 VDD.n3133 VDD.n3132 0.0391777
R4870 VDD.n3122 VDD.n3119 0.0391777
R4871 VDD.n3588 VDD.n3587 0.0391777
R4872 VDD.n3627 VDD.n3223 0.0391777
R4873 VDD.n3392 VDD.n3391 0.0391777
R4874 VDD.n490 VDD.n487 0.0391777
R4875 VDD.n2646 VDD.n2645 0.0391777
R4876 VDD.n3930 VDD.n167 0.0391777
R4877 VDD.n2891 VDD.n2890 0.0391777
R4878 VDD.n3194 VDD.n3193 0.0391777
R4879 VDD.n443 VDD.n442 0.0391777
R4880 VDD.n158 VDD.n157 0.0391777
R4881 VDD.n508 VDD.n504 0.0391777
R4882 VDD.n20 VDD.n16 0.0391777
R4883 VDD.n497 VDD.n495 0.0384339
R4884 VDD.n2908 VDD.n2907 0.0384339
R4885 VDD.n3823 VDD.n3822 0.0384339
R4886 VDD.n596 VDD.n524 0.0384339
R4887 VDD.n3132 VDD.n599 0.0384339
R4888 VDD.n3151 VDD.n3122 0.0384339
R4889 VDD.n3588 VDD.n3551 0.0384339
R4890 VDD.n3628 VDD.n3627 0.0384339
R4891 VDD.n3392 VDD.n3384 0.0384339
R4892 VDD.n3905 VDD.n490 0.0384339
R4893 VDD.n2646 VDD.n2638 0.0384339
R4894 VDD.n3931 VDD.n3930 0.0384339
R4895 VDD.n2890 VDD.n2875 0.0384339
R4896 VDD.n3194 VDD.n3066 0.0384339
R4897 VDD.n442 VDD.n160 0.0384339
R4898 VDD.n157 VDD.n146 0.0384339
R4899 VDD.n3882 VDD.n508 0.0384339
R4900 VDD.n4163 VDD.n20 0.0384339
R4901 VDD.n3105 VDD.n3104 0.0383947
R4902 VDD.n3845 VDD 0.0360263
R4903 VDD.n4123 VDD.n75 0.03215
R4904 VDD.n4127 VDD.n76 0.03215
R4905 VDD.n4111 VDD.n79 0.03215
R4906 VDD.n4115 VDD.n80 0.03215
R4907 VDD.n4101 VDD.n83 0.03215
R4908 VDD.n4105 VDD.n85 0.03215
R4909 VDD.n4091 VDD.n88 0.03215
R4910 VDD.n4095 VDD.n90 0.03215
R4911 VDD.n4081 VDD.n93 0.03215
R4912 VDD.n4085 VDD.n95 0.03215
R4913 VDD.n4070 VDD.n98 0.03215
R4914 VDD.n4075 VDD.n100 0.03215
R4915 VDD.n4061 VDD.n103 0.03215
R4916 VDD.n4065 VDD.n105 0.03215
R4917 VDD.n4050 VDD.n108 0.03215
R4918 VDD.n4055 VDD.n110 0.03215
R4919 VDD.n4041 VDD.n113 0.03215
R4920 VDD.n4045 VDD.n115 0.03215
R4921 VDD.n4031 VDD.n118 0.03215
R4922 VDD.n4035 VDD.n120 0.03215
R4923 VDD.n4021 VDD.n123 0.03215
R4924 VDD.n4025 VDD.n125 0.03215
R4925 VDD.n4011 VDD.n128 0.03215
R4926 VDD.n4015 VDD.n130 0.03215
R4927 VDD.n3989 VDD.n142 0.03215
R4928 VDD.n3993 VDD.n143 0.03215
R4929 VDD.n2934 VDD.n2633 0.03215
R4930 VDD.n2938 VDD.n2634 0.03215
R4931 VDD.n2869 VDD.n2680 0.03215
R4932 VDD.n2685 VDD.n2682 0.03215
R4933 VDD.n2858 VDD.n2689 0.03215
R4934 VDD.n2862 VDD.n2855 0.03215
R4935 VDD.n3877 VDD.n512 0.03215
R4936 VDD.n2837 VDD.n514 0.03215
R4937 VDD.n3866 VDD.n519 0.03215
R4938 VDD.n3870 VDD.n521 0.03215
R4939 VDD.n2810 VDD.n2803 0.03215
R4940 VDD.n2814 VDD.n2804 0.03215
R4941 VDD.n3794 VDD.n624 0.03215
R4942 VDD.n3791 VDD.n3790 0.03215
R4943 VDD.n3666 VDD.n3062 0.03215
R4944 VDD.n3670 VDD.n3063 0.03215
R4945 VDD.n3420 VDD.n3380 0.03215
R4946 VDD.n3424 VDD.n3381 0.03215
R4947 VDD.n3624 VDD.n3228 0.03215
R4948 VDD.n3366 VDD.n3230 0.03215
R4949 VDD.n3613 VDD.n3235 0.03215
R4950 VDD.n3617 VDD.n3549 0.03215
R4951 VDD.n4129 VDD.n73 0.03215
R4952 VDD.n72 VDD.n71 0.03215
R4953 VDD.n4139 VDD.n63 0.03215
R4954 VDD.n4143 VDD.n64 0.03215
R4955 VDD.n2375 VDD.n2374 0.03215
R4956 VDD.n2370 VDD.n1157 0.03215
R4957 VDD.n2384 VDD.n2383 0.03215
R4958 VDD.n1153 VDD.n1152 0.03215
R4959 VDD.n2393 VDD.n2392 0.03215
R4960 VDD.n1148 VDD.n1147 0.03215
R4961 VDD.n2402 VDD.n2401 0.03215
R4962 VDD.n1143 VDD.n1142 0.03215
R4963 VDD.n2411 VDD.n2410 0.03215
R4964 VDD.n1138 VDD.n1137 0.03215
R4965 VDD.n2420 VDD.n2419 0.03215
R4966 VDD.n1133 VDD.n1132 0.03215
R4967 VDD.n2429 VDD.n2428 0.03215
R4968 VDD.n1128 VDD.n1127 0.03215
R4969 VDD.n2438 VDD.n2437 0.03215
R4970 VDD.n1123 VDD.n1122 0.03215
R4971 VDD.n2446 VDD.n847 0.03215
R4972 VDD.n2450 VDD.n848 0.03215
R4973 VDD.n1109 VDD.n851 0.03215
R4974 VDD.n1113 VDD.n852 0.03215
R4975 VDD.n3997 VDD.n137 0.03215
R4976 VDD.n4001 VDD.n139 0.03215
R4977 VDD.n2940 VDD.n2631 0.03215
R4978 VDD.n2629 VDD.n737 0.03215
R4979 VDD.n2951 VDD.n729 0.03215
R4980 VDD.n2955 VDD.n730 0.03215
R4981 VDD.n2852 VDD.n2692 0.03215
R4982 VDD.n2697 VDD.n2694 0.03215
R4983 VDD.n2841 VDD.n2701 0.03215
R4984 VDD.n2845 VDD.n2703 0.03215
R4985 VDD.n2828 VDD.n2706 0.03215
R4986 VDD.n2832 VDD.n2708 0.03215
R4987 VDD.n2818 VDD.n2711 0.03215
R4988 VDD.n2822 VDD.n2800 0.03215
R4989 VDD.n3786 VDD.n631 0.03215
R4990 VDD.n3783 VDD.n3782 0.03215
R4991 VDD.n3677 VDD.n3058 0.03215
R4992 VDD.n3681 VDD.n3059 0.03215
R4993 VDD.n3431 VDD.n3314 0.03215
R4994 VDD.n3435 VDD.n3315 0.03215
R4995 VDD.n3370 VDD.n3318 0.03215
R4996 VDD.n3374 VDD.n3364 0.03215
R4997 VDD.n3546 VDD.n3238 0.03215
R4998 VDD.n3542 VDD.n3240 0.03215
R4999 VDD.n4158 VDD.n52 0.03215
R5000 VDD.n1719 VDD.n54 0.03215
R5001 VDD.n4147 VDD.n58 0.03215
R5002 VDD.n4151 VDD.n60 0.03215
R5003 VDD.n2367 VDD.n1160 0.03215
R5004 VDD.n1739 VDD.n1162 0.03215
R5005 VDD.n2356 VDD.n1167 0.03215
R5006 VDD.n2360 VDD.n1169 0.03215
R5007 VDD.n2345 VDD.n1172 0.03215
R5008 VDD.n2349 VDD.n1174 0.03215
R5009 VDD.n2334 VDD.n1177 0.03215
R5010 VDD.n2338 VDD.n1179 0.03215
R5011 VDD.n2323 VDD.n1182 0.03215
R5012 VDD.n2327 VDD.n1184 0.03215
R5013 VDD.n2312 VDD.n1187 0.03215
R5014 VDD.n2316 VDD.n1189 0.03215
R5015 VDD.n1951 VDD.n1192 0.03215
R5016 VDD.n1955 VDD.n1194 0.03215
R5017 VDD.n1940 VDD.n1197 0.03215
R5018 VDD.n1944 VDD.n1937 0.03215
R5019 VDD.n2452 VDD.n845 0.03215
R5020 VDD.n842 VDD.n841 0.03215
R5021 VDD.n2463 VDD.n833 0.03215
R5022 VDD.n2467 VDD.n834 0.03215
R5023 VDD.n1095 VDD.n1091 0.03215
R5024 VDD.n1099 VDD.n1092 0.03215
R5025 VDD.n2626 VDD.n740 0.03215
R5026 VDD.n2621 VDD.n742 0.03215
R5027 VDD.n2957 VDD.n727 0.03215
R5028 VDD.n724 VDD.n723 0.03215
R5029 VDD.n2968 VDD.n715 0.03215
R5030 VDD.n2972 VDD.n716 0.03215
R5031 VDD.n2739 VDD.n2738 0.03215
R5032 VDD.n2734 VDD.n2733 0.03215
R5033 VDD.n2747 VDD.n2726 0.03215
R5034 VDD.n2751 VDD.n2727 0.03215
R5035 VDD.n2797 VDD.n2714 0.03215
R5036 VDD.n2792 VDD.n2716 0.03215
R5037 VDD.n3778 VDD.n638 0.03215
R5038 VDD.n3775 VDD.n3774 0.03215
R5039 VDD.n3688 VDD.n3054 0.03215
R5040 VDD.n3692 VDD.n3055 0.03215
R5041 VDD.n3442 VDD.n3310 0.03215
R5042 VDD.n3446 VDD.n3311 0.03215
R5043 VDD.n3361 VDD.n3321 0.03215
R5044 VDD.n3356 VDD.n3323 0.03215
R5045 VDD.n3538 VDD.n3244 0.03215
R5046 VDD.n3534 VDD.n3246 0.03215
R5047 VDD.n1721 VDD.n1718 0.03215
R5048 VDD.n1716 VDD.n1316 0.03215
R5049 VDD.n1732 VDD.n1731 0.03215
R5050 VDD.n1312 VDD.n1311 0.03215
R5051 VDD.n1741 VDD.n1738 0.03215
R5052 VDD.n1307 VDD.n1306 0.03215
R5053 VDD.n1753 VDD.n1752 0.03215
R5054 VDD.n1302 VDD.n1301 0.03215
R5055 VDD.n1762 VDD.n1761 0.03215
R5056 VDD.n1297 VDD.n1296 0.03215
R5057 VDD.n1771 VDD.n1770 0.03215
R5058 VDD.n1292 VDD.n1291 0.03215
R5059 VDD.n1780 VDD.n1779 0.03215
R5060 VDD.n1287 VDD.n1286 0.03215
R5061 VDD.n1789 VDD.n1788 0.03215
R5062 VDD.n1282 VDD.n1281 0.03215
R5063 VDD.n1797 VDD.n1274 0.03215
R5064 VDD.n1801 VDD.n1275 0.03215
R5065 VDD.n1934 VDD.n1200 0.03215
R5066 VDD.n1261 VDD.n1202 0.03215
R5067 VDD.n1923 VDD.n1207 0.03215
R5068 VDD.n1927 VDD.n1920 0.03215
R5069 VDD.n2469 VDD.n831 0.03215
R5070 VDD.n828 VDD.n827 0.03215
R5071 VDD.n2480 VDD.n819 0.03215
R5072 VDD.n2484 VDD.n820 0.03215
R5073 VDD.n2617 VDD.n745 0.03215
R5074 VDD.n806 VDD.n747 0.03215
R5075 VDD.n2606 VDD.n752 0.03215
R5076 VDD.n2610 VDD.n2603 0.03215
R5077 VDD.n2974 VDD.n713 0.03215
R5078 VDD.n710 VDD.n709 0.03215
R5079 VDD.n2985 VDD.n701 0.03215
R5080 VDD.n2989 VDD.n702 0.03215
R5081 VDD.n2753 VDD.n2724 0.03215
R5082 VDD.n2722 VDD.n2721 0.03215
R5083 VDD.n2788 VDD.n2763 0.03215
R5084 VDD.n2783 VDD.n2765 0.03215
R5085 VDD.n3770 VDD.n645 0.03215
R5086 VDD.n3767 VDD.n3766 0.03215
R5087 VDD.n3699 VDD.n3050 0.03215
R5088 VDD.n3703 VDD.n3051 0.03215
R5089 VDD.n3453 VDD.n3306 0.03215
R5090 VDD.n3457 VDD.n3307 0.03215
R5091 VDD.n3352 VDD.n3327 0.03215
R5092 VDD.n3347 VDD.n3329 0.03215
R5093 VDD.n3530 VDD.n3250 0.03215
R5094 VDD.n3526 VDD.n3252 0.03215
R5095 VDD.n1713 VDD.n1319 0.03215
R5096 VDD.n1504 VDD.n1321 0.03215
R5097 VDD.n1702 VDD.n1325 0.03215
R5098 VDD.n1706 VDD.n1327 0.03215
R5099 VDD.n1691 VDD.n1330 0.03215
R5100 VDD.n1695 VDD.n1332 0.03215
R5101 VDD.n1680 VDD.n1335 0.03215
R5102 VDD.n1684 VDD.n1337 0.03215
R5103 VDD.n1669 VDD.n1340 0.03215
R5104 VDD.n1673 VDD.n1342 0.03215
R5105 VDD.n1658 VDD.n1345 0.03215
R5106 VDD.n1662 VDD.n1347 0.03215
R5107 VDD.n1647 VDD.n1350 0.03215
R5108 VDD.n1651 VDD.n1352 0.03215
R5109 VDD.n1636 VDD.n1355 0.03215
R5110 VDD.n1640 VDD.n1633 0.03215
R5111 VDD.n1803 VDD.n1272 0.03215
R5112 VDD.n1269 VDD.n1268 0.03215
R5113 VDD.n1814 VDD.n1258 0.03215
R5114 VDD.n1818 VDD.n1259 0.03215
R5115 VDD.n1917 VDD.n1210 0.03215
R5116 VDD.n1245 VDD.n1212 0.03215
R5117 VDD.n1906 VDD.n1217 0.03215
R5118 VDD.n1910 VDD.n1903 0.03215
R5119 VDD.n2486 VDD.n817 0.03215
R5120 VDD.n814 VDD.n813 0.03215
R5121 VDD.n2497 VDD.n803 0.03215
R5122 VDD.n2501 VDD.n804 0.03215
R5123 VDD.n2600 VDD.n755 0.03215
R5124 VDD.n790 VDD.n757 0.03215
R5125 VDD.n2589 VDD.n762 0.03215
R5126 VDD.n2593 VDD.n2586 0.03215
R5127 VDD.n2991 VDD.n699 0.03215
R5128 VDD.n696 VDD.n695 0.03215
R5129 VDD.n3002 VDD.n687 0.03215
R5130 VDD.n3006 VDD.n688 0.03215
R5131 VDD.n2779 VDD.n2769 0.03215
R5132 VDD.n2774 VDD.n2771 0.03215
R5133 VDD.n3762 VDD.n652 0.03215
R5134 VDD.n3759 VDD.n3758 0.03215
R5135 VDD.n3710 VDD.n3046 0.03215
R5136 VDD.n3714 VDD.n3047 0.03215
R5137 VDD.n3464 VDD.n3302 0.03215
R5138 VDD.n3468 VDD.n3303 0.03215
R5139 VDD.n3343 VDD.n3333 0.03215
R5140 VDD.n3338 VDD.n3335 0.03215
R5141 VDD.n3522 VDD.n3256 0.03215
R5142 VDD.n3518 VDD.n3258 0.03215
R5143 VDD.n1506 VDD.n1503 0.03215
R5144 VDD.n1501 VDD.n1412 0.03215
R5145 VDD.n1517 VDD.n1516 0.03215
R5146 VDD.n1408 VDD.n1407 0.03215
R5147 VDD.n1526 VDD.n1525 0.03215
R5148 VDD.n1403 VDD.n1402 0.03215
R5149 VDD.n1535 VDD.n1534 0.03215
R5150 VDD.n1398 VDD.n1397 0.03215
R5151 VDD.n1544 VDD.n1543 0.03215
R5152 VDD.n1393 VDD.n1392 0.03215
R5153 VDD.n1553 VDD.n1552 0.03215
R5154 VDD.n1388 VDD.n1387 0.03215
R5155 VDD.n1561 VDD.n1380 0.03215
R5156 VDD.n1565 VDD.n1381 0.03215
R5157 VDD.n1630 VDD.n1358 0.03215
R5158 VDD.n1577 VDD.n1360 0.03215
R5159 VDD.n1619 VDD.n1365 0.03215
R5160 VDD.n1623 VDD.n1616 0.03215
R5161 VDD.n1820 VDD.n1256 0.03215
R5162 VDD.n1253 VDD.n1252 0.03215
R5163 VDD.n1831 VDD.n1242 0.03215
R5164 VDD.n1835 VDD.n1243 0.03215
R5165 VDD.n1900 VDD.n1220 0.03215
R5166 VDD.n1847 VDD.n1222 0.03215
R5167 VDD.n1889 VDD.n1227 0.03215
R5168 VDD.n1893 VDD.n1886 0.03215
R5169 VDD.n2503 VDD.n801 0.03215
R5170 VDD.n798 VDD.n797 0.03215
R5171 VDD.n2514 VDD.n787 0.03215
R5172 VDD.n2518 VDD.n788 0.03215
R5173 VDD.n2583 VDD.n765 0.03215
R5174 VDD.n2530 VDD.n767 0.03215
R5175 VDD.n2572 VDD.n772 0.03215
R5176 VDD.n2576 VDD.n2569 0.03215
R5177 VDD.n3008 VDD.n685 0.03215
R5178 VDD.n682 VDD.n681 0.03215
R5179 VDD.n3019 VDD.n673 0.03215
R5180 VDD.n3023 VDD.n674 0.03215
R5181 VDD.n3754 VDD.n659 0.03215
R5182 VDD.n3751 VDD.n3750 0.03215
R5183 VDD.n3721 VDD.n3042 0.03215
R5184 VDD.n3725 VDD.n3043 0.03215
R5185 VDD.n3470 VDD.n3300 0.03215
R5186 VDD.n3298 VDD.n3283 0.03215
R5187 VDD.n3481 VDD.n3275 0.03215
R5188 VDD.n3485 VDD.n3276 0.03215
R5189 VDD.n3514 VDD.n3262 0.03215
R5190 VDD.n3510 VDD.n3264 0.03215
R5191 VDD.n1498 VDD.n1415 0.03215
R5192 VDD.n1419 VDD.n1417 0.03215
R5193 VDD.n1487 VDD.n1423 0.03215
R5194 VDD.n1491 VDD.n1424 0.03215
R5195 VDD.n1476 VDD.n1427 0.03215
R5196 VDD.n1480 VDD.n1428 0.03215
R5197 VDD.n1465 VDD.n1431 0.03215
R5198 VDD.n1469 VDD.n1432 0.03215
R5199 VDD.n1454 VDD.n1435 0.03215
R5200 VDD.n1458 VDD.n1436 0.03215
R5201 VDD.n1443 VDD.n1439 0.03215
R5202 VDD.n1447 VDD.n1440 0.03215
R5203 VDD.n1567 VDD.n1378 0.03215
R5204 VDD.n1375 VDD.n1374 0.03215
R5205 VDD.n1579 VDD.n1576 0.03215
R5206 VDD.n1370 VDD.n1369 0.03215
R5207 VDD.n1613 VDD.n1589 0.03215
R5208 VDD.n1594 VDD.n1591 0.03215
R5209 VDD.n1602 VDD.n1598 0.03215
R5210 VDD.n1606 VDD.n1599 0.03215
R5211 VDD.n1837 VDD.n1240 0.03215
R5212 VDD.n1237 VDD.n1236 0.03215
R5213 VDD.n1849 VDD.n1846 0.03215
R5214 VDD.n1232 VDD.n1231 0.03215
R5215 VDD.n1883 VDD.n1859 0.03215
R5216 VDD.n1864 VDD.n1861 0.03215
R5217 VDD.n1872 VDD.n1868 0.03215
R5218 VDD.n1876 VDD.n1869 0.03215
R5219 VDD.n2520 VDD.n785 0.03215
R5220 VDD.n782 VDD.n781 0.03215
R5221 VDD.n2532 VDD.n2529 0.03215
R5222 VDD.n777 VDD.n776 0.03215
R5223 VDD.n2566 VDD.n2542 0.03215
R5224 VDD.n2547 VDD.n2544 0.03215
R5225 VDD.n2555 VDD.n2551 0.03215
R5226 VDD.n2559 VDD.n2552 0.03215
R5227 VDD.n3025 VDD.n671 0.03215
R5228 VDD.n668 VDD.n667 0.03215
R5229 VDD.n3746 VDD.n3035 0.03215
R5230 VDD.n3743 VDD.n3742 0.03215
R5231 VDD.n3729 VDD.n3038 0.03215
R5232 VDD.n3733 VDD.n3039 0.03215
R5233 VDD.n3295 VDD.n3286 0.03215
R5234 VDD.n3290 VDD.n3288 0.03215
R5235 VDD.n3487 VDD.n3273 0.03215
R5236 VDD.n3270 VDD.n3269 0.03215
R5237 VDD.n3506 VDD.n3497 0.03215
R5238 VDD.n3502 VDD.n3499 0.03215
R5239 VDD.n3196 VDD.n3195 0.0241842
R5240 VDD VDD.n162 0.023
R5241 VDD.n1058 VDD 0.0206316
R5242 VDD.n4047 VDD.n112 0.0196
R5243 VDD.n2433 VDD.n2432 0.0196
R5244 VDD.n1957 VDD.n1191 0.0196
R5245 VDD.n1278 VDD.n1273 0.0196
R5246 VDD.n1810 VDD.n1809 0.0196
R5247 VDD.n1625 VDD.n1364 0.0196
R5248 VDD.n1611 VDD.n1592 0.0196
R5249 VDD.n4067 VDD.n102 0.0196
R5250 VDD.n2415 VDD.n2414 0.0196
R5251 VDD.n2329 VDD.n1181 0.0196
R5252 VDD.n1784 VDD.n1783 0.0196
R5253 VDD.n1653 VDD.n1349 0.0196
R5254 VDD.n1384 VDD.n1379 0.0196
R5255 VDD.n1574 VDD.n1573 0.0196
R5256 VDD.n4057 VDD.n107 0.0196
R5257 VDD.n2424 VDD.n2423 0.0196
R5258 VDD.n2318 VDD.n1186 0.0196
R5259 VDD.n1793 VDD.n1792 0.0196
R5260 VDD.n1642 VDD.n1354 0.0196
R5261 VDD.n1628 VDD.n1361 0.0196
R5262 VDD.n1586 VDD.n1585 0.0196
R5263 VDD.n4037 VDD.n117 0.0196
R5264 VDD.n2442 VDD.n2441 0.0196
R5265 VDD.n1946 VDD.n1196 0.0196
R5266 VDD.n1932 VDD.n1203 0.0196
R5267 VDD.n1265 VDD.n1257 0.0196
R5268 VDD.n1827 VDD.n1826 0.0196
R5269 VDD.n1608 VDD.n1597 0.0196
R5270 VDD.n4027 VDD.n122 0.0196
R5271 VDD.n1119 VDD.n846 0.0196
R5272 VDD.n2459 VDD.n2458 0.0196
R5273 VDD.n1929 VDD.n1206 0.0196
R5274 VDD.n1915 VDD.n1213 0.0196
R5275 VDD.n1249 VDD.n1241 0.0196
R5276 VDD.n1844 VDD.n1843 0.0196
R5277 VDD.n4017 VDD.n127 0.0196
R5278 VDD.n1115 VDD.n850 0.0196
R5279 VDD.n838 VDD.n832 0.0196
R5280 VDD.n2476 VDD.n2475 0.0196
R5281 VDD.n1912 VDD.n1216 0.0196
R5282 VDD.n1898 VDD.n1223 0.0196
R5283 VDD.n1856 VDD.n1855 0.0196
R5284 VDD.n2807 VDD.n2802 0.0196
R5285 VDD.n2824 VDD.n2710 0.0196
R5286 VDD.n2795 VDD.n2717 0.0196
R5287 VDD.n2786 VDD.n2766 0.0196
R5288 VDD.n2777 VDD.n2772 0.0196
R5289 VDD.n678 VDD.n672 0.0196
R5290 VDD.n3032 VDD.n3031 0.0196
R5291 VDD.n3872 VDD.n518 0.0196
R5292 VDD.n2834 VDD.n2705 0.0196
R5293 VDD.n2730 VDD.n2725 0.0196
R5294 VDD.n2760 VDD.n2759 0.0196
R5295 VDD.n692 VDD.n686 0.0196
R5296 VDD.n3015 VDD.n3014 0.0196
R5297 VDD.n2561 VDD.n2550 0.0196
R5298 VDD.n3619 VDD.n3234 0.0196
R5299 VDD.n3544 VDD.n3241 0.0196
R5300 VDD.n3536 VDD.n3247 0.0196
R5301 VDD.n3528 VDD.n3253 0.0196
R5302 VDD.n3520 VDD.n3259 0.0196
R5303 VDD.n3512 VDD.n3265 0.0196
R5304 VDD.n3504 VDD.n3500 0.0196
R5305 VDD.n3622 VDD.n3231 0.0196
R5306 VDD.n3376 VDD.n3317 0.0196
R5307 VDD.n3359 VDD.n3324 0.0196
R5308 VDD.n3350 VDD.n3330 0.0196
R5309 VDD.n3341 VDD.n3336 0.0196
R5310 VDD.n3280 VDD.n3274 0.0196
R5311 VDD.n3494 VDD.n3493 0.0196
R5312 VDD.n3417 VDD.n3379 0.0196
R5313 VDD.n3428 VDD.n3313 0.0196
R5314 VDD.n3439 VDD.n3309 0.0196
R5315 VDD.n3450 VDD.n3305 0.0196
R5316 VDD.n3461 VDD.n3301 0.0196
R5317 VDD.n3477 VDD.n3476 0.0196
R5318 VDD.n3293 VDD.n3292 0.0196
R5319 VDD.n2931 VDD.n2632 0.0196
R5320 VDD.n2947 VDD.n2946 0.0196
R5321 VDD.n2624 VDD.n2623 0.0196
R5322 VDD.n2615 VDD.n748 0.0196
R5323 VDD.n810 VDD.n802 0.0196
R5324 VDD.n2510 VDD.n2509 0.0196
R5325 VDD.n1878 VDD.n1867 0.0196
R5326 VDD.n3792 VDD.n626 0.0196
R5327 VDD.n3784 VDD.n633 0.0196
R5328 VDD.n3776 VDD.n640 0.0196
R5329 VDD.n3768 VDD.n647 0.0196
R5330 VDD.n3760 VDD.n654 0.0196
R5331 VDD.n3752 VDD.n661 0.0196
R5332 VDD.n3744 VDD.n3738 0.0196
R5333 VDD.n3971 VDD.n141 0.0196
R5334 VDD.n4003 VDD.n136 0.0196
R5335 VDD.n1101 VDD.n1090 0.0196
R5336 VDD.n824 VDD.n818 0.0196
R5337 VDD.n2493 VDD.n2492 0.0196
R5338 VDD.n1895 VDD.n1226 0.0196
R5339 VDD.n1881 VDD.n1862 0.0196
R5340 VDD.n3875 VDD.n515 0.0196
R5341 VDD.n2847 VDD.n2700 0.0196
R5342 VDD.n2743 VDD.n2742 0.0196
R5343 VDD.n706 VDD.n700 0.0196
R5344 VDD.n2998 VDD.n2997 0.0196
R5345 VDD.n2578 VDD.n771 0.0196
R5346 VDD.n2564 VDD.n2545 0.0196
R5347 VDD.n4077 VDD.n97 0.0196
R5348 VDD.n2406 VDD.n2405 0.0196
R5349 VDD.n2340 VDD.n1176 0.0196
R5350 VDD.n1775 VDD.n1774 0.0196
R5351 VDD.n1664 VDD.n1344 0.0196
R5352 VDD.n1557 VDD.n1556 0.0196
R5353 VDD.n1449 VDD.n1438 0.0196
R5354 VDD.n4087 VDD.n92 0.0196
R5355 VDD.n2397 VDD.n2396 0.0196
R5356 VDD.n2351 VDD.n1171 0.0196
R5357 VDD.n1766 VDD.n1765 0.0196
R5358 VDD.n1675 VDD.n1339 0.0196
R5359 VDD.n1548 VDD.n1547 0.0196
R5360 VDD.n1460 VDD.n1434 0.0196
R5361 VDD.n4122 VDD.n74 0.0196
R5362 VDD.n4135 VDD.n4134 0.0196
R5363 VDD.n4156 VDD.n51 0.0196
R5364 VDD.n1727 VDD.n1726 0.0196
R5365 VDD.n1711 VDD.n1318 0.0196
R5366 VDD.n1512 VDD.n1511 0.0196
R5367 VDD.n1496 VDD.n1414 0.0196
R5368 VDD.n4117 VDD.n78 0.0196
R5369 VDD.n68 VDD.n62 0.0196
R5370 VDD.n4153 VDD.n57 0.0196
R5371 VDD.n1736 VDD.n1735 0.0196
R5372 VDD.n1708 VDD.n1324 0.0196
R5373 VDD.n1521 VDD.n1520 0.0196
R5374 VDD.n1493 VDD.n1422 0.0196
R5375 VDD.n4107 VDD.n82 0.0196
R5376 VDD.n2379 VDD.n2378 0.0196
R5377 VDD.n2365 VDD.n1163 0.0196
R5378 VDD.n1748 VDD.n1747 0.0196
R5379 VDD.n1697 VDD.n1329 0.0196
R5380 VDD.n1530 VDD.n1529 0.0196
R5381 VDD.n1482 VDD.n1426 0.0196
R5382 VDD.n4097 VDD.n87 0.0196
R5383 VDD.n2388 VDD.n2387 0.0196
R5384 VDD.n2362 VDD.n1166 0.0196
R5385 VDD.n1757 VDD.n1756 0.0196
R5386 VDD.n1686 VDD.n1334 0.0196
R5387 VDD.n1539 VDD.n1538 0.0196
R5388 VDD.n1471 VDD.n1430 0.0196
R5389 VDD.n2867 VDD.n2683 0.0196
R5390 VDD.n734 VDD.n728 0.0196
R5391 VDD.n2964 VDD.n2963 0.0196
R5392 VDD.n2612 VDD.n751 0.0196
R5393 VDD.n2598 VDD.n758 0.0196
R5394 VDD.n794 VDD.n786 0.0196
R5395 VDD.n2527 VDD.n2526 0.0196
R5396 VDD.n2864 VDD.n2688 0.0196
R5397 VDD.n2850 VDD.n2695 0.0196
R5398 VDD.n720 VDD.n714 0.0196
R5399 VDD.n2981 VDD.n2980 0.0196
R5400 VDD.n2595 VDD.n761 0.0196
R5401 VDD.n2581 VDD.n768 0.0196
R5402 VDD.n2539 VDD.n2538 0.0196
R5403 VDD.n3663 VDD.n3061 0.0196
R5404 VDD.n3674 VDD.n3057 0.0196
R5405 VDD.n3685 VDD.n3053 0.0196
R5406 VDD.n3696 VDD.n3049 0.0196
R5407 VDD.n3707 VDD.n3045 0.0196
R5408 VDD.n3718 VDD.n3041 0.0196
R5409 VDD.n3735 VDD.n3037 0.0196
R5410 VDD.n4043 VDD.n4042 0.0189
R5411 VDD.n2426 VDD.n1126 0.0189
R5412 VDD.n1953 VDD.n1952 0.0189
R5413 VDD.n1799 VDD.n1798 0.0189
R5414 VDD.n1805 VDD.n1267 0.0189
R5415 VDD.n1621 VDD.n1620 0.0189
R5416 VDD.n1612 VDD.n1366 0.0189
R5417 VDD.n4063 VDD.n4062 0.0189
R5418 VDD.n2408 VDD.n1136 0.0189
R5419 VDD.n2325 VDD.n2324 0.0189
R5420 VDD.n1777 VDD.n1285 0.0189
R5421 VDD.n1649 VDD.n1648 0.0189
R5422 VDD.n1563 VDD.n1562 0.0189
R5423 VDD.n1569 VDD.n1373 0.0189
R5424 VDD.n4053 VDD.n4051 0.0189
R5425 VDD.n2417 VDD.n1131 0.0189
R5426 VDD.n2314 VDD.n2313 0.0189
R5427 VDD.n1786 VDD.n1280 0.0189
R5428 VDD.n1638 VDD.n1637 0.0189
R5429 VDD.n1629 VDD.n1356 0.0189
R5430 VDD.n1581 VDD.n1368 0.0189
R5431 VDD.n4033 VDD.n4032 0.0189
R5432 VDD.n2435 VDD.n1121 0.0189
R5433 VDD.n1942 VDD.n1941 0.0189
R5434 VDD.n1933 VDD.n1198 0.0189
R5435 VDD.n1816 VDD.n1815 0.0189
R5436 VDD.n1822 VDD.n1251 0.0189
R5437 VDD.n1604 VDD.n1603 0.0189
R5438 VDD.n4023 VDD.n4022 0.0189
R5439 VDD.n2448 VDD.n2447 0.0189
R5440 VDD.n2454 VDD.n840 0.0189
R5441 VDD.n1925 VDD.n1924 0.0189
R5442 VDD.n1916 VDD.n1208 0.0189
R5443 VDD.n1833 VDD.n1832 0.0189
R5444 VDD.n1839 VDD.n1235 0.0189
R5445 VDD.n4013 VDD.n4012 0.0189
R5446 VDD.n1111 VDD.n1110 0.0189
R5447 VDD.n2465 VDD.n2464 0.0189
R5448 VDD.n2471 VDD.n826 0.0189
R5449 VDD.n1908 VDD.n1907 0.0189
R5450 VDD.n1899 VDD.n1218 0.0189
R5451 VDD.n1851 VDD.n1230 0.0189
R5452 VDD.n2812 VDD.n2811 0.0189
R5453 VDD.n2820 VDD.n2819 0.0189
R5454 VDD.n2796 VDD.n2712 0.0189
R5455 VDD.n2787 VDD.n2718 0.0189
R5456 VDD.n2778 VDD.n2767 0.0189
R5457 VDD.n3021 VDD.n3020 0.0189
R5458 VDD.n3027 VDD.n666 0.0189
R5459 VDD.n3868 VDD.n3867 0.0189
R5460 VDD.n2830 VDD.n2829 0.0189
R5461 VDD.n2749 VDD.n2748 0.0189
R5462 VDD.n2755 VDD.n2720 0.0189
R5463 VDD.n3004 VDD.n3003 0.0189
R5464 VDD.n3010 VDD.n680 0.0189
R5465 VDD.n2557 VDD.n2556 0.0189
R5466 VDD.n3615 VDD.n3614 0.0189
R5467 VDD.n3545 VDD.n3236 0.0189
R5468 VDD.n3537 VDD.n3242 0.0189
R5469 VDD.n3529 VDD.n3248 0.0189
R5470 VDD.n3521 VDD.n3254 0.0189
R5471 VDD.n3513 VDD.n3260 0.0189
R5472 VDD.n3505 VDD.n3266 0.0189
R5473 VDD.n3623 VDD.n3226 0.0189
R5474 VDD.n3372 VDD.n3371 0.0189
R5475 VDD.n3360 VDD.n3319 0.0189
R5476 VDD.n3351 VDD.n3325 0.0189
R5477 VDD.n3342 VDD.n3331 0.0189
R5478 VDD.n3483 VDD.n3482 0.0189
R5479 VDD.n3489 VDD.n3268 0.0189
R5480 VDD.n3422 VDD.n3421 0.0189
R5481 VDD.n3433 VDD.n3432 0.0189
R5482 VDD.n3444 VDD.n3443 0.0189
R5483 VDD.n3455 VDD.n3454 0.0189
R5484 VDD.n3466 VDD.n3465 0.0189
R5485 VDD.n3472 VDD.n3282 0.0189
R5486 VDD.n3294 VDD.n3284 0.0189
R5487 VDD.n2936 VDD.n2935 0.0189
R5488 VDD.n2942 VDD.n736 0.0189
R5489 VDD.n2625 VDD.n738 0.0189
R5490 VDD.n2616 VDD.n743 0.0189
R5491 VDD.n2499 VDD.n2498 0.0189
R5492 VDD.n2505 VDD.n796 0.0189
R5493 VDD.n1874 VDD.n1873 0.0189
R5494 VDD.n3793 VDD.n622 0.0189
R5495 VDD.n3785 VDD.n629 0.0189
R5496 VDD.n3777 VDD.n636 0.0189
R5497 VDD.n3769 VDD.n643 0.0189
R5498 VDD.n3761 VDD.n650 0.0189
R5499 VDD.n3753 VDD.n657 0.0189
R5500 VDD.n3745 VDD.n664 0.0189
R5501 VDD.n3991 VDD.n3990 0.0189
R5502 VDD.n3999 VDD.n3998 0.0189
R5503 VDD.n1097 VDD.n1096 0.0189
R5504 VDD.n2482 VDD.n2481 0.0189
R5505 VDD.n2488 VDD.n812 0.0189
R5506 VDD.n1891 VDD.n1890 0.0189
R5507 VDD.n1882 VDD.n1228 0.0189
R5508 VDD.n3876 VDD.n510 0.0189
R5509 VDD.n2843 VDD.n2842 0.0189
R5510 VDD.n2736 VDD.n2732 0.0189
R5511 VDD.n2987 VDD.n2986 0.0189
R5512 VDD.n2993 VDD.n694 0.0189
R5513 VDD.n2574 VDD.n2573 0.0189
R5514 VDD.n2565 VDD.n773 0.0189
R5515 VDD.n4073 VDD.n4071 0.0189
R5516 VDD.n2399 VDD.n1141 0.0189
R5517 VDD.n2336 VDD.n2335 0.0189
R5518 VDD.n1768 VDD.n1290 0.0189
R5519 VDD.n1660 VDD.n1659 0.0189
R5520 VDD.n1550 VDD.n1386 0.0189
R5521 VDD.n1445 VDD.n1444 0.0189
R5522 VDD.n4083 VDD.n4082 0.0189
R5523 VDD.n2390 VDD.n1146 0.0189
R5524 VDD.n2347 VDD.n2346 0.0189
R5525 VDD.n1759 VDD.n1295 0.0189
R5526 VDD.n1671 VDD.n1670 0.0189
R5527 VDD.n1541 VDD.n1391 0.0189
R5528 VDD.n1456 VDD.n1455 0.0189
R5529 VDD.n4125 VDD.n4124 0.0189
R5530 VDD.n4131 VDD.n70 0.0189
R5531 VDD.n4157 VDD.n50 0.0189
R5532 VDD.n1723 VDD.n1315 0.0189
R5533 VDD.n1712 VDD.n1317 0.0189
R5534 VDD.n1508 VDD.n1411 0.0189
R5535 VDD.n1497 VDD.n1413 0.0189
R5536 VDD.n4113 VDD.n4112 0.0189
R5537 VDD.n4141 VDD.n4140 0.0189
R5538 VDD.n4149 VDD.n4148 0.0189
R5539 VDD.n1729 VDD.n1310 0.0189
R5540 VDD.n1704 VDD.n1703 0.0189
R5541 VDD.n1514 VDD.n1406 0.0189
R5542 VDD.n1489 VDD.n1488 0.0189
R5543 VDD.n4103 VDD.n4102 0.0189
R5544 VDD.n2372 VDD.n1156 0.0189
R5545 VDD.n2366 VDD.n1158 0.0189
R5546 VDD.n1743 VDD.n1305 0.0189
R5547 VDD.n1693 VDD.n1692 0.0189
R5548 VDD.n1523 VDD.n1401 0.0189
R5549 VDD.n1478 VDD.n1477 0.0189
R5550 VDD.n4093 VDD.n4092 0.0189
R5551 VDD.n2381 VDD.n1151 0.0189
R5552 VDD.n2358 VDD.n2357 0.0189
R5553 VDD.n1750 VDD.n1300 0.0189
R5554 VDD.n1682 VDD.n1681 0.0189
R5555 VDD.n1532 VDD.n1396 0.0189
R5556 VDD.n1467 VDD.n1466 0.0189
R5557 VDD.n2868 VDD.n2678 0.0189
R5558 VDD.n2953 VDD.n2952 0.0189
R5559 VDD.n2959 VDD.n722 0.0189
R5560 VDD.n2608 VDD.n2607 0.0189
R5561 VDD.n2599 VDD.n753 0.0189
R5562 VDD.n2516 VDD.n2515 0.0189
R5563 VDD.n2522 VDD.n780 0.0189
R5564 VDD.n2860 VDD.n2859 0.0189
R5565 VDD.n2851 VDD.n2690 0.0189
R5566 VDD.n2970 VDD.n2969 0.0189
R5567 VDD.n2976 VDD.n708 0.0189
R5568 VDD.n2591 VDD.n2590 0.0189
R5569 VDD.n2582 VDD.n763 0.0189
R5570 VDD.n2534 VDD.n775 0.0189
R5571 VDD.n3668 VDD.n3667 0.0189
R5572 VDD.n3679 VDD.n3678 0.0189
R5573 VDD.n3690 VDD.n3689 0.0189
R5574 VDD.n3701 VDD.n3700 0.0189
R5575 VDD.n3712 VDD.n3711 0.0189
R5576 VDD.n3723 VDD.n3722 0.0189
R5577 VDD.n3731 VDD.n3730 0.0189
R5578 VDD.n1055 VDD 0.0182632
R5579 VDD.n2307 VDD.n1962 0.0176074
R5580 VDD.n3896 VDD.n492 0.0176074
R5581 VDD.n2913 VDD.n2912 0.0176074
R5582 VDD.n3827 VDD.n609 0.0176074
R5583 VDD.n3861 VDD.n525 0.0176074
R5584 VDD.n3846 VDD.n600 0.0176074
R5585 VDD.n3149 VDD.n3120 0.0176074
R5586 VDD.n3608 VDD.n3552 0.0176074
R5587 VDD.n3632 VDD.n3225 0.0176074
R5588 VDD.n3412 VDD.n3385 0.0176074
R5589 VDD.n491 VDD.n488 0.0176074
R5590 VDD.n2926 VDD.n2639 0.0176074
R5591 VDD.n3935 VDD.n169 0.0176074
R5592 VDD.n3801 VDD.n621 0.0176074
R5593 VDD.n2903 VDD.n2876 0.0176074
R5594 VDD.n3658 VDD.n3067 0.0176074
R5595 VDD.n3954 VDD.n161 0.0176074
R5596 VDD.n3966 VDD.n147 0.0176074
R5597 VDD.n509 VDD.n506 0.0176074
R5598 VDD.n49 VDD.n18 0.0176074
R5599 VDD.n1967 VDD.n1960 0.0131
R5600 VDD.n3826 VDD.n608 0.0131
R5601 VDD.n3134 VDD.n598 0.0131
R5602 VDD.n3849 VDD.n523 0.0131
R5603 VDD.n3584 VDD.n3550 0.0131
R5604 VDD.n3631 VDD.n3224 0.0131
R5605 VDD.n3388 VDD.n3383 0.0131
R5606 VDD.n3934 VDD.n168 0.0131
R5607 VDD.n2637 VDD.n2636 0.0131
R5608 VDD.n3800 VDD.n620 0.0131
R5609 VDD.n444 VDD.n159 0.0131
R5610 VDD.n3957 VDD.n145 0.0131
R5611 VDD.n3152 VDD.n3121 0.0131
R5612 VDD.n3883 VDD.n507 0.0131
R5613 VDD.n4164 VDD.n19 0.0131
R5614 VDD.n2892 VDD.n2874 0.0131
R5615 VDD.n2906 VDD.n2873 0.0131
R5616 VDD.n3906 VDD.n489 0.0131
R5617 VDD.n3899 VDD.n493 0.0131
R5618 VDD.n3190 VDD.n3065 0.0131
R5619 VDD.n303 VDD.n302 0.0107632
R5620 VDD.n338 VDD.n209 0.0107632
R5621 VDD.n409 VDD.n408 0.0107632
R5622 VDD.n453 VDD.n440 0.0107632
R5623 VDD.n2900 VDD.n2899 0.0107632
R5624 VDD.n3143 VDD.n3127 0.0107632
R5625 VDD.n3807 VDD.n616 0.0107632
R5626 VDD.n3408 VDD.n3407 0.0107632
R5627 VDD VDD.n3569 0.00997368
R5628 VDD.n1019 VDD 0.00642105
R5629 VDD.n1057 VDD 0.00642105
R5630 VDD.n1054 VDD 0.00642105
R5631 VDD.n1049 VDD 0.00642105
R5632 VDD.n1046 VDD 0.00642105
R5633 VDD.n1041 VDD 0.00642105
R5634 VDD.n1038 VDD 0.00642105
R5635 VDD.n1035 VDD 0.00642105
R5636 VDD.n3977 VDD 0.00642105
R5637 VDD.n2301 VDD 0.00642105
R5638 VDD.n1963 VDD 0.00642105
R5639 VDD.n3893 VDD 0.00642105
R5640 VDD.n2675 VDD 0.00642105
R5641 VDD.n3858 VDD 0.00642105
R5642 VDD.n531 VDD 0.00642105
R5643 VDD.n2922 VDD 0.00642105
R5644 VDD.n2641 VDD 0.00642105
R5645 VDD.n3963 VDD 0.00642105
R5646 VDD.n155 VDD 0.00642105
R5647 VDD.n151 VDD 0.00642105
R5648 VDD.n21 VDD 0.00642105
R5649 VDD.n23 VDD 0.00642105
R5650 VDD.n4179 VDD 0.00642105
R5651 VDD.n900 VDD.n899 0.00638961
R5652 VDD.n895 VDD.n894 0.00632664
R5653 VDD.n1067 VDD 0.00523684
R5654 VDD.n1077 VDD 0.00523684
R5655 VDD.n1056 VDD 0.00523684
R5656 VDD.n1053 VDD 0.00523684
R5657 VDD.n1048 VDD 0.00523684
R5658 VDD.n1045 VDD 0.00523684
R5659 VDD.n1040 VDD 0.00523684
R5660 VDD.n1037 VDD 0.00523684
R5661 VDD.n1034 VDD 0.00523684
R5662 VDD.n3979 VDD 0.00523684
R5663 VDD.n2299 VDD 0.00523684
R5664 VDD.n1964 VDD 0.00523684
R5665 VDD.n2652 VDD 0.00523684
R5666 VDD.n2916 VDD 0.00523684
R5667 VDD.n2923 VDD 0.00523684
R5668 VDD.n2640 VDD 0.00523684
R5669 VDD.n3131 VDD.n3130 0.00523684
R5670 VDD.n30 VDD 0.00523684
R5671 VDD.n40 VDD 0.00523684
R5672 VDD.n3854 VDD 0.00405263
R5673 VDD.n3887 VDD 0.00405263
R5674 VDD.n3962 VDD 0.00405263
R5675 VDD.n154 VDD 0.00405263
R5676 VDD.n150 VDD 0.00405263
R5677 VDD.n1989 VDD.n1985 0.00293243
R5678 VDD.n2276 VDD.n1979 0.00293243
R5679 VDD.n2257 VDD.n1980 0.00293243
R5680 VDD.n2238 VDD.n1981 0.00293243
R5681 VDD VDD.n1070 0.00286842
R5682 VDD VDD.n1080 0.00286842
R5683 VDD VDD.n4180 0.00286842
R5684 VDD VDD.n1024 0.00283766
R5685 VDD VDD.n22 0.00283766
R5686 VDD VDD.n24 0.00283766
R5687 VDD VDD.n35 0.00283766
R5688 VDD VDD.n45 0.00283766
R5689 VDD.n1969 VDD.n1966 0.0019876
R5690 VDD.n2308 VDD.n1961 0.0019876
R5691 VDD.n3901 VDD.n3900 0.0019876
R5692 VDD.n3897 VDD.n497 0.0019876
R5693 VDD.n2910 VDD.n2909 0.0019876
R5694 VDD.n2907 VDD.n2677 0.0019876
R5695 VDD.n3829 VDD.n607 0.0019876
R5696 VDD.n3824 VDD.n3823 0.0019876
R5697 VDD.n3851 VDD.n597 0.0019876
R5698 VDD.n3862 VDD.n524 0.0019876
R5699 VDD.n3136 VDD.n3133 0.0019876
R5700 VDD.n3847 VDD.n599 0.0019876
R5701 VDD.n3154 VDD.n3119 0.0019876
R5702 VDD.n3151 VDD.n3150 0.0019876
R5703 VDD.n3587 VDD.n3586 0.0019876
R5704 VDD.n3609 VDD.n3551 0.0019876
R5705 VDD.n3634 VDD.n3223 0.0019876
R5706 VDD.n3629 VDD.n3628 0.0019876
R5707 VDD.n3391 VDD.n3390 0.0019876
R5708 VDD.n3413 VDD.n3384 0.0019876
R5709 VDD.n3908 VDD.n487 0.0019876
R5710 VDD.n3905 VDD.n3904 0.0019876
R5711 VDD.n2645 VDD.n2644 0.0019876
R5712 VDD.n2927 VDD.n2638 0.0019876
R5713 VDD.n3937 VDD.n167 0.0019876
R5714 VDD.n3932 VDD.n3931 0.0019876
R5715 VDD.n3803 VDD.n619 0.0019876
R5716 VDD.n3798 VDD.n3797 0.0019876
R5717 VDD.n2894 VDD.n2891 0.0019876
R5718 VDD.n2904 VDD.n2875 0.0019876
R5719 VDD.n3193 VDD.n3192 0.0019876
R5720 VDD.n3659 VDD.n3066 0.0019876
R5721 VDD.n446 VDD.n443 0.0019876
R5722 VDD.n3955 VDD.n160 0.0019876
R5723 VDD.n3959 VDD.n158 0.0019876
R5724 VDD.n3967 VDD.n146 0.0019876
R5725 VDD.n3885 VDD.n504 0.0019876
R5726 VDD.n3882 VDD.n3881 0.0019876
R5727 VDD.n4166 VDD.n16 0.0019876
R5728 VDD.n4163 VDD.n4162 0.0019876
R5729 VDD.n1028 VDD.n1027 0.00100998
R5730 VDD.n958 VDD.n957 0.00100998
R5731 VDD.n1014 VDD.n1013 0.00100986
R5732 VDD.n955 VDD.n954 0.00100986
R5733 VDD.n1029 VDD.n1003 0.00100986
R5734 VDD.n959 VDD.n944 0.00100986
R5735 VDD.n4123 VDD.n4120 0.00095
R5736 VDD.n4121 VDD.n76 0.00095
R5737 VDD.n4126 VDD.n4119 0.00095
R5738 VDD.n4111 VDD.n77 0.00095
R5739 VDD.n4110 VDD.n80 0.00095
R5740 VDD.n4114 VDD.n4109 0.00095
R5741 VDD.n4101 VDD.n81 0.00095
R5742 VDD.n4100 VDD.n85 0.00095
R5743 VDD.n4104 VDD.n4099 0.00095
R5744 VDD.n4091 VDD.n86 0.00095
R5745 VDD.n4090 VDD.n90 0.00095
R5746 VDD.n4094 VDD.n4089 0.00095
R5747 VDD.n4081 VDD.n91 0.00095
R5748 VDD.n4080 VDD.n95 0.00095
R5749 VDD.n4084 VDD.n4079 0.00095
R5750 VDD.n4070 VDD.n96 0.00095
R5751 VDD.n4072 VDD.n100 0.00095
R5752 VDD.n4074 VDD.n4069 0.00095
R5753 VDD.n4061 VDD.n101 0.00095
R5754 VDD.n4060 VDD.n105 0.00095
R5755 VDD.n4064 VDD.n4059 0.00095
R5756 VDD.n4050 VDD.n106 0.00095
R5757 VDD.n4052 VDD.n110 0.00095
R5758 VDD.n4054 VDD.n4049 0.00095
R5759 VDD.n4041 VDD.n111 0.00095
R5760 VDD.n4040 VDD.n115 0.00095
R5761 VDD.n4044 VDD.n4039 0.00095
R5762 VDD.n4031 VDD.n116 0.00095
R5763 VDD.n4030 VDD.n120 0.00095
R5764 VDD.n4034 VDD.n4029 0.00095
R5765 VDD.n4021 VDD.n121 0.00095
R5766 VDD.n4020 VDD.n125 0.00095
R5767 VDD.n4024 VDD.n4019 0.00095
R5768 VDD.n4011 VDD.n126 0.00095
R5769 VDD.n4010 VDD.n130 0.00095
R5770 VDD.n4014 VDD.n4009 0.00095
R5771 VDD.n3986 VDD.n3972 0.00095
R5772 VDD.n3989 VDD.n3988 0.00095
R5773 VDD.n3970 VDD.n143 0.00095
R5774 VDD.n3992 VDD.n144 0.00095
R5775 VDD.n2934 VDD.n2933 0.00095
R5776 VDD.n2930 VDD.n2634 0.00095
R5777 VDD.n2937 VDD.n2635 0.00095
R5778 VDD.n2870 VDD.n2869 0.00095
R5779 VDD.n2682 VDD.n2681 0.00095
R5780 VDD.n2866 VDD.n2686 0.00095
R5781 VDD.n2858 VDD.n2687 0.00095
R5782 VDD.n2857 VDD.n2855 0.00095
R5783 VDD.n2861 VDD.n2856 0.00095
R5784 VDD.n3878 VDD.n3877 0.00095
R5785 VDD.n514 VDD.n513 0.00095
R5786 VDD.n3874 VDD.n516 0.00095
R5787 VDD.n3866 VDD.n517 0.00095
R5788 VDD.n3865 VDD.n521 0.00095
R5789 VDD.n3869 VDD.n522 0.00095
R5790 VDD.n2810 VDD.n2809 0.00095
R5791 VDD.n2806 VDD.n2804 0.00095
R5792 VDD.n2813 VDD.n2805 0.00095
R5793 VDD.n3795 VDD.n3794 0.00095
R5794 VDD.n3791 VDD.n627 0.00095
R5795 VDD.n628 VDD.n625 0.00095
R5796 VDD.n3666 VDD.n3665 0.00095
R5797 VDD.n3662 VDD.n3063 0.00095
R5798 VDD.n3669 VDD.n3064 0.00095
R5799 VDD.n3420 VDD.n3419 0.00095
R5800 VDD.n3416 VDD.n3381 0.00095
R5801 VDD.n3423 VDD.n3382 0.00095
R5802 VDD.n3625 VDD.n3624 0.00095
R5803 VDD.n3230 VDD.n3229 0.00095
R5804 VDD.n3621 VDD.n3232 0.00095
R5805 VDD.n3613 VDD.n3233 0.00095
R5806 VDD.n3612 VDD.n3549 0.00095
R5807 VDD.n4133 VDD.n73 0.00095
R5808 VDD.n4130 VDD.n72 0.00095
R5809 VDD.n4136 VDD.n69 0.00095
R5810 VDD.n4139 VDD.n4138 0.00095
R5811 VDD.n67 VDD.n64 0.00095
R5812 VDD.n4142 VDD.n65 0.00095
R5813 VDD.n2376 VDD.n2375 0.00095
R5814 VDD.n2373 VDD.n1157 0.00095
R5815 VDD.n2380 VDD.n1155 0.00095
R5816 VDD.n2385 VDD.n2384 0.00095
R5817 VDD.n2382 VDD.n1152 0.00095
R5818 VDD.n2389 VDD.n1150 0.00095
R5819 VDD.n2394 VDD.n2393 0.00095
R5820 VDD.n2391 VDD.n1147 0.00095
R5821 VDD.n2398 VDD.n1145 0.00095
R5822 VDD.n2403 VDD.n2402 0.00095
R5823 VDD.n2400 VDD.n1142 0.00095
R5824 VDD.n2407 VDD.n1140 0.00095
R5825 VDD.n2412 VDD.n2411 0.00095
R5826 VDD.n2409 VDD.n1137 0.00095
R5827 VDD.n2416 VDD.n1135 0.00095
R5828 VDD.n2421 VDD.n2420 0.00095
R5829 VDD.n2418 VDD.n1132 0.00095
R5830 VDD.n2425 VDD.n1130 0.00095
R5831 VDD.n2430 VDD.n2429 0.00095
R5832 VDD.n2427 VDD.n1127 0.00095
R5833 VDD.n2434 VDD.n1125 0.00095
R5834 VDD.n2439 VDD.n2438 0.00095
R5835 VDD.n2436 VDD.n1122 0.00095
R5836 VDD.n2443 VDD.n1120 0.00095
R5837 VDD.n2446 VDD.n2445 0.00095
R5838 VDD.n1118 VDD.n848 0.00095
R5839 VDD.n2449 VDD.n1117 0.00095
R5840 VDD.n1109 VDD.n849 0.00095
R5841 VDD.n1108 VDD.n852 0.00095
R5842 VDD.n1112 VDD.n1107 0.00095
R5843 VDD.n4005 VDD.n134 0.00095
R5844 VDD.n3997 VDD.n135 0.00095
R5845 VDD.n3996 VDD.n139 0.00095
R5846 VDD.n4000 VDD.n140 0.00095
R5847 VDD.n2944 VDD.n2631 0.00095
R5848 VDD.n2941 VDD.n737 0.00095
R5849 VDD.n2948 VDD.n735 0.00095
R5850 VDD.n2951 VDD.n2950 0.00095
R5851 VDD.n733 VDD.n730 0.00095
R5852 VDD.n2954 VDD.n731 0.00095
R5853 VDD.n2853 VDD.n2852 0.00095
R5854 VDD.n2694 VDD.n2693 0.00095
R5855 VDD.n2849 VDD.n2698 0.00095
R5856 VDD.n2841 VDD.n2699 0.00095
R5857 VDD.n2840 VDD.n2703 0.00095
R5858 VDD.n2844 VDD.n2836 0.00095
R5859 VDD.n2828 VDD.n2704 0.00095
R5860 VDD.n2827 VDD.n2708 0.00095
R5861 VDD.n2831 VDD.n2826 0.00095
R5862 VDD.n2818 VDD.n2709 0.00095
R5863 VDD.n2817 VDD.n2800 0.00095
R5864 VDD.n2821 VDD.n2801 0.00095
R5865 VDD.n3787 VDD.n3786 0.00095
R5866 VDD.n3783 VDD.n634 0.00095
R5867 VDD.n635 VDD.n632 0.00095
R5868 VDD.n3677 VDD.n3676 0.00095
R5869 VDD.n3673 VDD.n3059 0.00095
R5870 VDD.n3680 VDD.n3060 0.00095
R5871 VDD.n3431 VDD.n3430 0.00095
R5872 VDD.n3427 VDD.n3315 0.00095
R5873 VDD.n3434 VDD.n3378 0.00095
R5874 VDD.n3370 VDD.n3316 0.00095
R5875 VDD.n3369 VDD.n3364 0.00095
R5876 VDD.n3373 VDD.n3365 0.00095
R5877 VDD.n3547 VDD.n3546 0.00095
R5878 VDD.n3240 VDD.n3239 0.00095
R5879 VDD.n4159 VDD.n4158 0.00095
R5880 VDD.n54 VDD.n53 0.00095
R5881 VDD.n4155 VDD.n55 0.00095
R5882 VDD.n4147 VDD.n56 0.00095
R5883 VDD.n4146 VDD.n60 0.00095
R5884 VDD.n4150 VDD.n61 0.00095
R5885 VDD.n2368 VDD.n2367 0.00095
R5886 VDD.n1162 VDD.n1161 0.00095
R5887 VDD.n2364 VDD.n1164 0.00095
R5888 VDD.n2356 VDD.n1165 0.00095
R5889 VDD.n2355 VDD.n1169 0.00095
R5890 VDD.n2359 VDD.n2353 0.00095
R5891 VDD.n2345 VDD.n1170 0.00095
R5892 VDD.n2344 VDD.n1174 0.00095
R5893 VDD.n2348 VDD.n2342 0.00095
R5894 VDD.n2334 VDD.n1175 0.00095
R5895 VDD.n2333 VDD.n1179 0.00095
R5896 VDD.n2337 VDD.n2331 0.00095
R5897 VDD.n2323 VDD.n1180 0.00095
R5898 VDD.n2322 VDD.n1184 0.00095
R5899 VDD.n2326 VDD.n2320 0.00095
R5900 VDD.n2312 VDD.n1185 0.00095
R5901 VDD.n2311 VDD.n1189 0.00095
R5902 VDD.n2315 VDD.n1959 0.00095
R5903 VDD.n1951 VDD.n1190 0.00095
R5904 VDD.n1950 VDD.n1194 0.00095
R5905 VDD.n1954 VDD.n1948 0.00095
R5906 VDD.n1940 VDD.n1195 0.00095
R5907 VDD.n1939 VDD.n1937 0.00095
R5908 VDD.n1943 VDD.n844 0.00095
R5909 VDD.n2456 VDD.n845 0.00095
R5910 VDD.n2453 VDD.n841 0.00095
R5911 VDD.n2460 VDD.n839 0.00095
R5912 VDD.n2463 VDD.n2462 0.00095
R5913 VDD.n837 VDD.n834 0.00095
R5914 VDD.n2466 VDD.n835 0.00095
R5915 VDD.n1103 VDD.n1088 0.00095
R5916 VDD.n1095 VDD.n1089 0.00095
R5917 VDD.n1094 VDD.n1092 0.00095
R5918 VDD.n1098 VDD.n1093 0.00095
R5919 VDD.n2627 VDD.n2626 0.00095
R5920 VDD.n742 VDD.n741 0.00095
R5921 VDD.n2620 VDD.n726 0.00095
R5922 VDD.n2961 VDD.n727 0.00095
R5923 VDD.n2958 VDD.n723 0.00095
R5924 VDD.n2965 VDD.n721 0.00095
R5925 VDD.n2968 VDD.n2967 0.00095
R5926 VDD.n719 VDD.n716 0.00095
R5927 VDD.n2971 VDD.n717 0.00095
R5928 VDD.n2740 VDD.n2739 0.00095
R5929 VDD.n2737 VDD.n2733 0.00095
R5930 VDD.n2744 VDD.n2731 0.00095
R5931 VDD.n2747 VDD.n2746 0.00095
R5932 VDD.n2729 VDD.n2727 0.00095
R5933 VDD.n2750 VDD.n2728 0.00095
R5934 VDD.n2798 VDD.n2797 0.00095
R5935 VDD.n2716 VDD.n2715 0.00095
R5936 VDD.n2794 VDD.n2793 0.00095
R5937 VDD.n3779 VDD.n3778 0.00095
R5938 VDD.n3775 VDD.n641 0.00095
R5939 VDD.n642 VDD.n639 0.00095
R5940 VDD.n3688 VDD.n3687 0.00095
R5941 VDD.n3684 VDD.n3055 0.00095
R5942 VDD.n3691 VDD.n3056 0.00095
R5943 VDD.n3442 VDD.n3441 0.00095
R5944 VDD.n3438 VDD.n3311 0.00095
R5945 VDD.n3445 VDD.n3312 0.00095
R5946 VDD.n3362 VDD.n3361 0.00095
R5947 VDD.n3323 VDD.n3322 0.00095
R5948 VDD.n3358 VDD.n3357 0.00095
R5949 VDD.n3539 VDD.n3538 0.00095
R5950 VDD.n3246 VDD.n3245 0.00095
R5951 VDD.n1725 VDD.n1718 0.00095
R5952 VDD.n1722 VDD.n1316 0.00095
R5953 VDD.n1728 VDD.n1314 0.00095
R5954 VDD.n1733 VDD.n1732 0.00095
R5955 VDD.n1730 VDD.n1311 0.00095
R5956 VDD.n1737 VDD.n1309 0.00095
R5957 VDD.n1745 VDD.n1738 0.00095
R5958 VDD.n1742 VDD.n1306 0.00095
R5959 VDD.n1749 VDD.n1304 0.00095
R5960 VDD.n1754 VDD.n1753 0.00095
R5961 VDD.n1751 VDD.n1301 0.00095
R5962 VDD.n1758 VDD.n1299 0.00095
R5963 VDD.n1763 VDD.n1762 0.00095
R5964 VDD.n1760 VDD.n1296 0.00095
R5965 VDD.n1767 VDD.n1294 0.00095
R5966 VDD.n1772 VDD.n1771 0.00095
R5967 VDD.n1769 VDD.n1291 0.00095
R5968 VDD.n1776 VDD.n1289 0.00095
R5969 VDD.n1781 VDD.n1780 0.00095
R5970 VDD.n1778 VDD.n1286 0.00095
R5971 VDD.n1785 VDD.n1284 0.00095
R5972 VDD.n1790 VDD.n1789 0.00095
R5973 VDD.n1787 VDD.n1281 0.00095
R5974 VDD.n1794 VDD.n1279 0.00095
R5975 VDD.n1797 VDD.n1796 0.00095
R5976 VDD.n1277 VDD.n1275 0.00095
R5977 VDD.n1800 VDD.n1276 0.00095
R5978 VDD.n1935 VDD.n1934 0.00095
R5979 VDD.n1202 VDD.n1201 0.00095
R5980 VDD.n1931 VDD.n1204 0.00095
R5981 VDD.n1923 VDD.n1205 0.00095
R5982 VDD.n1922 VDD.n1920 0.00095
R5983 VDD.n1926 VDD.n830 0.00095
R5984 VDD.n2473 VDD.n831 0.00095
R5985 VDD.n2470 VDD.n827 0.00095
R5986 VDD.n2477 VDD.n825 0.00095
R5987 VDD.n2480 VDD.n2479 0.00095
R5988 VDD.n823 VDD.n820 0.00095
R5989 VDD.n2483 VDD.n821 0.00095
R5990 VDD.n2618 VDD.n2617 0.00095
R5991 VDD.n747 VDD.n746 0.00095
R5992 VDD.n2614 VDD.n749 0.00095
R5993 VDD.n2606 VDD.n750 0.00095
R5994 VDD.n2605 VDD.n2603 0.00095
R5995 VDD.n2609 VDD.n712 0.00095
R5996 VDD.n2978 VDD.n713 0.00095
R5997 VDD.n2975 VDD.n709 0.00095
R5998 VDD.n2982 VDD.n707 0.00095
R5999 VDD.n2985 VDD.n2984 0.00095
R6000 VDD.n705 VDD.n702 0.00095
R6001 VDD.n2988 VDD.n703 0.00095
R6002 VDD.n2757 VDD.n2724 0.00095
R6003 VDD.n2754 VDD.n2721 0.00095
R6004 VDD.n2761 VDD.n2719 0.00095
R6005 VDD.n2789 VDD.n2788 0.00095
R6006 VDD.n2765 VDD.n2764 0.00095
R6007 VDD.n2785 VDD.n2784 0.00095
R6008 VDD.n3771 VDD.n3770 0.00095
R6009 VDD.n3767 VDD.n648 0.00095
R6010 VDD.n649 VDD.n646 0.00095
R6011 VDD.n3699 VDD.n3698 0.00095
R6012 VDD.n3695 VDD.n3051 0.00095
R6013 VDD.n3702 VDD.n3052 0.00095
R6014 VDD.n3453 VDD.n3452 0.00095
R6015 VDD.n3449 VDD.n3307 0.00095
R6016 VDD.n3456 VDD.n3308 0.00095
R6017 VDD.n3353 VDD.n3352 0.00095
R6018 VDD.n3329 VDD.n3328 0.00095
R6019 VDD.n3349 VDD.n3348 0.00095
R6020 VDD.n3531 VDD.n3530 0.00095
R6021 VDD.n3252 VDD.n3251 0.00095
R6022 VDD.n1714 VDD.n1713 0.00095
R6023 VDD.n1321 VDD.n1320 0.00095
R6024 VDD.n1710 VDD.n1322 0.00095
R6025 VDD.n1702 VDD.n1323 0.00095
R6026 VDD.n1701 VDD.n1327 0.00095
R6027 VDD.n1705 VDD.n1699 0.00095
R6028 VDD.n1691 VDD.n1328 0.00095
R6029 VDD.n1690 VDD.n1332 0.00095
R6030 VDD.n1694 VDD.n1688 0.00095
R6031 VDD.n1680 VDD.n1333 0.00095
R6032 VDD.n1679 VDD.n1337 0.00095
R6033 VDD.n1683 VDD.n1677 0.00095
R6034 VDD.n1669 VDD.n1338 0.00095
R6035 VDD.n1668 VDD.n1342 0.00095
R6036 VDD.n1672 VDD.n1666 0.00095
R6037 VDD.n1658 VDD.n1343 0.00095
R6038 VDD.n1657 VDD.n1347 0.00095
R6039 VDD.n1661 VDD.n1655 0.00095
R6040 VDD.n1647 VDD.n1348 0.00095
R6041 VDD.n1646 VDD.n1352 0.00095
R6042 VDD.n1650 VDD.n1644 0.00095
R6043 VDD.n1636 VDD.n1353 0.00095
R6044 VDD.n1635 VDD.n1633 0.00095
R6045 VDD.n1639 VDD.n1271 0.00095
R6046 VDD.n1807 VDD.n1272 0.00095
R6047 VDD.n1804 VDD.n1268 0.00095
R6048 VDD.n1811 VDD.n1266 0.00095
R6049 VDD.n1814 VDD.n1813 0.00095
R6050 VDD.n1264 VDD.n1259 0.00095
R6051 VDD.n1817 VDD.n1260 0.00095
R6052 VDD.n1918 VDD.n1917 0.00095
R6053 VDD.n1212 VDD.n1211 0.00095
R6054 VDD.n1914 VDD.n1214 0.00095
R6055 VDD.n1906 VDD.n1215 0.00095
R6056 VDD.n1905 VDD.n1903 0.00095
R6057 VDD.n1909 VDD.n816 0.00095
R6058 VDD.n2490 VDD.n817 0.00095
R6059 VDD.n2487 VDD.n813 0.00095
R6060 VDD.n2494 VDD.n811 0.00095
R6061 VDD.n2497 VDD.n2496 0.00095
R6062 VDD.n809 VDD.n804 0.00095
R6063 VDD.n2500 VDD.n805 0.00095
R6064 VDD.n2601 VDD.n2600 0.00095
R6065 VDD.n757 VDD.n756 0.00095
R6066 VDD.n2597 VDD.n759 0.00095
R6067 VDD.n2589 VDD.n760 0.00095
R6068 VDD.n2588 VDD.n2586 0.00095
R6069 VDD.n2592 VDD.n698 0.00095
R6070 VDD.n2995 VDD.n699 0.00095
R6071 VDD.n2992 VDD.n695 0.00095
R6072 VDD.n2999 VDD.n693 0.00095
R6073 VDD.n3002 VDD.n3001 0.00095
R6074 VDD.n691 VDD.n688 0.00095
R6075 VDD.n3005 VDD.n689 0.00095
R6076 VDD.n2780 VDD.n2779 0.00095
R6077 VDD.n2771 VDD.n2770 0.00095
R6078 VDD.n2776 VDD.n2775 0.00095
R6079 VDD.n3763 VDD.n3762 0.00095
R6080 VDD.n3759 VDD.n655 0.00095
R6081 VDD.n656 VDD.n653 0.00095
R6082 VDD.n3710 VDD.n3709 0.00095
R6083 VDD.n3706 VDD.n3047 0.00095
R6084 VDD.n3713 VDD.n3048 0.00095
R6085 VDD.n3464 VDD.n3463 0.00095
R6086 VDD.n3460 VDD.n3303 0.00095
R6087 VDD.n3467 VDD.n3304 0.00095
R6088 VDD.n3344 VDD.n3343 0.00095
R6089 VDD.n3335 VDD.n3334 0.00095
R6090 VDD.n3340 VDD.n3339 0.00095
R6091 VDD.n3523 VDD.n3522 0.00095
R6092 VDD.n3258 VDD.n3257 0.00095
R6093 VDD.n1510 VDD.n1503 0.00095
R6094 VDD.n1507 VDD.n1412 0.00095
R6095 VDD.n1513 VDD.n1410 0.00095
R6096 VDD.n1518 VDD.n1517 0.00095
R6097 VDD.n1515 VDD.n1407 0.00095
R6098 VDD.n1522 VDD.n1405 0.00095
R6099 VDD.n1527 VDD.n1526 0.00095
R6100 VDD.n1524 VDD.n1402 0.00095
R6101 VDD.n1531 VDD.n1400 0.00095
R6102 VDD.n1536 VDD.n1535 0.00095
R6103 VDD.n1533 VDD.n1397 0.00095
R6104 VDD.n1540 VDD.n1395 0.00095
R6105 VDD.n1545 VDD.n1544 0.00095
R6106 VDD.n1542 VDD.n1392 0.00095
R6107 VDD.n1549 VDD.n1390 0.00095
R6108 VDD.n1554 VDD.n1553 0.00095
R6109 VDD.n1551 VDD.n1387 0.00095
R6110 VDD.n1558 VDD.n1385 0.00095
R6111 VDD.n1561 VDD.n1560 0.00095
R6112 VDD.n1383 VDD.n1381 0.00095
R6113 VDD.n1564 VDD.n1382 0.00095
R6114 VDD.n1631 VDD.n1630 0.00095
R6115 VDD.n1360 VDD.n1359 0.00095
R6116 VDD.n1627 VDD.n1362 0.00095
R6117 VDD.n1619 VDD.n1363 0.00095
R6118 VDD.n1618 VDD.n1616 0.00095
R6119 VDD.n1622 VDD.n1255 0.00095
R6120 VDD.n1824 VDD.n1256 0.00095
R6121 VDD.n1821 VDD.n1252 0.00095
R6122 VDD.n1828 VDD.n1250 0.00095
R6123 VDD.n1831 VDD.n1830 0.00095
R6124 VDD.n1248 VDD.n1243 0.00095
R6125 VDD.n1834 VDD.n1244 0.00095
R6126 VDD.n1901 VDD.n1900 0.00095
R6127 VDD.n1222 VDD.n1221 0.00095
R6128 VDD.n1897 VDD.n1224 0.00095
R6129 VDD.n1889 VDD.n1225 0.00095
R6130 VDD.n1888 VDD.n1886 0.00095
R6131 VDD.n1892 VDD.n800 0.00095
R6132 VDD.n2507 VDD.n801 0.00095
R6133 VDD.n2504 VDD.n797 0.00095
R6134 VDD.n2511 VDD.n795 0.00095
R6135 VDD.n2514 VDD.n2513 0.00095
R6136 VDD.n793 VDD.n788 0.00095
R6137 VDD.n2517 VDD.n789 0.00095
R6138 VDD.n2584 VDD.n2583 0.00095
R6139 VDD.n767 VDD.n766 0.00095
R6140 VDD.n2580 VDD.n769 0.00095
R6141 VDD.n2572 VDD.n770 0.00095
R6142 VDD.n2571 VDD.n2569 0.00095
R6143 VDD.n2575 VDD.n684 0.00095
R6144 VDD.n3012 VDD.n685 0.00095
R6145 VDD.n3009 VDD.n681 0.00095
R6146 VDD.n3016 VDD.n679 0.00095
R6147 VDD.n3019 VDD.n3018 0.00095
R6148 VDD.n677 VDD.n674 0.00095
R6149 VDD.n3022 VDD.n675 0.00095
R6150 VDD.n3755 VDD.n3754 0.00095
R6151 VDD.n3751 VDD.n662 0.00095
R6152 VDD.n663 VDD.n660 0.00095
R6153 VDD.n3721 VDD.n3720 0.00095
R6154 VDD.n3717 VDD.n3043 0.00095
R6155 VDD.n3724 VDD.n3044 0.00095
R6156 VDD.n3474 VDD.n3300 0.00095
R6157 VDD.n3471 VDD.n3283 0.00095
R6158 VDD.n3478 VDD.n3281 0.00095
R6159 VDD.n3481 VDD.n3480 0.00095
R6160 VDD.n3279 VDD.n3276 0.00095
R6161 VDD.n3484 VDD.n3277 0.00095
R6162 VDD.n3515 VDD.n3514 0.00095
R6163 VDD.n3264 VDD.n3263 0.00095
R6164 VDD.n1499 VDD.n1498 0.00095
R6165 VDD.n1417 VDD.n1416 0.00095
R6166 VDD.n1495 VDD.n1420 0.00095
R6167 VDD.n1487 VDD.n1421 0.00095
R6168 VDD.n1486 VDD.n1424 0.00095
R6169 VDD.n1490 VDD.n1484 0.00095
R6170 VDD.n1476 VDD.n1425 0.00095
R6171 VDD.n1475 VDD.n1428 0.00095
R6172 VDD.n1479 VDD.n1473 0.00095
R6173 VDD.n1465 VDD.n1429 0.00095
R6174 VDD.n1464 VDD.n1432 0.00095
R6175 VDD.n1468 VDD.n1462 0.00095
R6176 VDD.n1454 VDD.n1433 0.00095
R6177 VDD.n1453 VDD.n1436 0.00095
R6178 VDD.n1457 VDD.n1451 0.00095
R6179 VDD.n1443 VDD.n1437 0.00095
R6180 VDD.n1442 VDD.n1440 0.00095
R6181 VDD.n1446 VDD.n1377 0.00095
R6182 VDD.n1571 VDD.n1378 0.00095
R6183 VDD.n1568 VDD.n1374 0.00095
R6184 VDD.n1575 VDD.n1372 0.00095
R6185 VDD.n1583 VDD.n1576 0.00095
R6186 VDD.n1580 VDD.n1369 0.00095
R6187 VDD.n1587 VDD.n1367 0.00095
R6188 VDD.n1614 VDD.n1613 0.00095
R6189 VDD.n1591 VDD.n1590 0.00095
R6190 VDD.n1610 VDD.n1595 0.00095
R6191 VDD.n1602 VDD.n1596 0.00095
R6192 VDD.n1601 VDD.n1599 0.00095
R6193 VDD.n1605 VDD.n1239 0.00095
R6194 VDD.n1841 VDD.n1240 0.00095
R6195 VDD.n1838 VDD.n1236 0.00095
R6196 VDD.n1845 VDD.n1234 0.00095
R6197 VDD.n1853 VDD.n1846 0.00095
R6198 VDD.n1850 VDD.n1231 0.00095
R6199 VDD.n1857 VDD.n1229 0.00095
R6200 VDD.n1884 VDD.n1883 0.00095
R6201 VDD.n1861 VDD.n1860 0.00095
R6202 VDD.n1880 VDD.n1865 0.00095
R6203 VDD.n1872 VDD.n1866 0.00095
R6204 VDD.n1871 VDD.n1869 0.00095
R6205 VDD.n1875 VDD.n784 0.00095
R6206 VDD.n2524 VDD.n785 0.00095
R6207 VDD.n2521 VDD.n781 0.00095
R6208 VDD.n2528 VDD.n779 0.00095
R6209 VDD.n2536 VDD.n2529 0.00095
R6210 VDD.n2533 VDD.n776 0.00095
R6211 VDD.n2540 VDD.n774 0.00095
R6212 VDD.n2567 VDD.n2566 0.00095
R6213 VDD.n2544 VDD.n2543 0.00095
R6214 VDD.n2563 VDD.n2548 0.00095
R6215 VDD.n2555 VDD.n2549 0.00095
R6216 VDD.n2554 VDD.n2552 0.00095
R6217 VDD.n2558 VDD.n670 0.00095
R6218 VDD.n3029 VDD.n671 0.00095
R6219 VDD.n3026 VDD.n667 0.00095
R6220 VDD.n3033 VDD.n665 0.00095
R6221 VDD.n3747 VDD.n3746 0.00095
R6222 VDD.n3743 VDD.n3739 0.00095
R6223 VDD.n3740 VDD.n3737 0.00095
R6224 VDD.n3729 VDD.n3036 0.00095
R6225 VDD.n3728 VDD.n3039 0.00095
R6226 VDD.n3732 VDD.n3040 0.00095
R6227 VDD.n3296 VDD.n3295 0.00095
R6228 VDD.n3288 VDD.n3287 0.00095
R6229 VDD.n3289 VDD.n3272 0.00095
R6230 VDD.n3491 VDD.n3273 0.00095
R6231 VDD.n3488 VDD.n3269 0.00095
R6232 VDD.n3495 VDD.n3267 0.00095
R6233 VDD.n3507 VDD.n3506 0.00095
R6234 VDD.n3499 VDD.n3498 0.00095
R6235 VDD.n2045 VDD.n2009 0.000905405
R6236 VDD.n2050 VDD.n2010 0.000905405
R6237 VDD.n2069 VDD.n2012 0.000905405
R6238 VDD.n2088 VDD.n2014 0.000905405
R6239 VDD.n2143 VDD.n2142 0.000905405
R6240 VDD.n2149 VDD.n2148 0.000905405
R6241 VDD.n2169 VDD.n2168 0.000905405
R6242 VDD.n2189 VDD.n2188 0.000905405
R6243 VDD.n4008 VDD.n131 0.0008
R6244 VDD.n3972 VDD.n131 0.0008
R6245 VDD.n1106 VDD.n853 0.0008
R6246 VDD.n853 VDD.n134 0.0008
R6247 VDD.n1087 VDD.n856 0.0008
R6248 VDD.n1088 VDD.n1087 0.0008
R6249 VDD.n4042 VDD.n112 0.0007
R6250 VDD.n4047 VDD.n4046 0.0007
R6251 VDD.n2426 VDD.n114 0.0007
R6252 VDD.n2433 VDD.n1126 0.0007
R6253 VDD.n2432 VDD.n1129 0.0007
R6254 VDD.n1953 VDD.n1949 0.0007
R6255 VDD.n1952 VDD.n1191 0.0007
R6256 VDD.n1957 VDD.n1956 0.0007
R6257 VDD.n1799 VDD.n1193 0.0007
R6258 VDD.n1798 VDD.n1278 0.0007
R6259 VDD.n1802 VDD.n1273 0.0007
R6260 VDD.n1806 VDD.n1805 0.0007
R6261 VDD.n1810 VDD.n1267 0.0007
R6262 VDD.n1809 VDD.n1270 0.0007
R6263 VDD.n1621 VDD.n1617 0.0007
R6264 VDD.n1620 VDD.n1364 0.0007
R6265 VDD.n1625 VDD.n1624 0.0007
R6266 VDD.n1615 VDD.n1366 0.0007
R6267 VDD.n1612 VDD.n1611 0.0007
R6268 VDD.n1593 VDD.n1592 0.0007
R6269 VDD.n4062 VDD.n102 0.0007
R6270 VDD.n4067 VDD.n4066 0.0007
R6271 VDD.n2408 VDD.n104 0.0007
R6272 VDD.n2415 VDD.n1136 0.0007
R6273 VDD.n2414 VDD.n1139 0.0007
R6274 VDD.n2325 VDD.n2321 0.0007
R6275 VDD.n2324 VDD.n1181 0.0007
R6276 VDD.n2329 VDD.n2328 0.0007
R6277 VDD.n1777 VDD.n1183 0.0007
R6278 VDD.n1784 VDD.n1285 0.0007
R6279 VDD.n1783 VDD.n1288 0.0007
R6280 VDD.n1649 VDD.n1645 0.0007
R6281 VDD.n1648 VDD.n1349 0.0007
R6282 VDD.n1653 VDD.n1652 0.0007
R6283 VDD.n1563 VDD.n1351 0.0007
R6284 VDD.n1562 VDD.n1384 0.0007
R6285 VDD.n1566 VDD.n1379 0.0007
R6286 VDD.n1570 VDD.n1569 0.0007
R6287 VDD.n1574 VDD.n1373 0.0007
R6288 VDD.n1573 VDD.n1376 0.0007
R6289 VDD.n4051 VDD.n107 0.0007
R6290 VDD.n4057 VDD.n4056 0.0007
R6291 VDD.n2417 VDD.n109 0.0007
R6292 VDD.n2424 VDD.n1131 0.0007
R6293 VDD.n2423 VDD.n1134 0.0007
R6294 VDD.n2314 VDD.n2310 0.0007
R6295 VDD.n2313 VDD.n1186 0.0007
R6296 VDD.n2318 VDD.n2317 0.0007
R6297 VDD.n1786 VDD.n1188 0.0007
R6298 VDD.n1793 VDD.n1280 0.0007
R6299 VDD.n1792 VDD.n1283 0.0007
R6300 VDD.n1638 VDD.n1634 0.0007
R6301 VDD.n1637 VDD.n1354 0.0007
R6302 VDD.n1642 VDD.n1641 0.0007
R6303 VDD.n1632 VDD.n1356 0.0007
R6304 VDD.n1629 VDD.n1628 0.0007
R6305 VDD.n1578 VDD.n1361 0.0007
R6306 VDD.n1582 VDD.n1581 0.0007
R6307 VDD.n1586 VDD.n1368 0.0007
R6308 VDD.n1585 VDD.n1371 0.0007
R6309 VDD.n4032 VDD.n117 0.0007
R6310 VDD.n4037 VDD.n4036 0.0007
R6311 VDD.n2435 VDD.n119 0.0007
R6312 VDD.n2442 VDD.n1121 0.0007
R6313 VDD.n2441 VDD.n1124 0.0007
R6314 VDD.n1942 VDD.n1938 0.0007
R6315 VDD.n1941 VDD.n1196 0.0007
R6316 VDD.n1946 VDD.n1945 0.0007
R6317 VDD.n1936 VDD.n1198 0.0007
R6318 VDD.n1933 VDD.n1932 0.0007
R6319 VDD.n1262 VDD.n1203 0.0007
R6320 VDD.n1816 VDD.n1263 0.0007
R6321 VDD.n1815 VDD.n1265 0.0007
R6322 VDD.n1819 VDD.n1257 0.0007
R6323 VDD.n1823 VDD.n1822 0.0007
R6324 VDD.n1827 VDD.n1251 0.0007
R6325 VDD.n1826 VDD.n1254 0.0007
R6326 VDD.n1604 VDD.n1600 0.0007
R6327 VDD.n1603 VDD.n1597 0.0007
R6328 VDD.n1608 VDD.n1607 0.0007
R6329 VDD.n4022 VDD.n122 0.0007
R6330 VDD.n4027 VDD.n4026 0.0007
R6331 VDD.n2448 VDD.n124 0.0007
R6332 VDD.n2447 VDD.n1119 0.0007
R6333 VDD.n2451 VDD.n846 0.0007
R6334 VDD.n2455 VDD.n2454 0.0007
R6335 VDD.n2459 VDD.n840 0.0007
R6336 VDD.n2458 VDD.n843 0.0007
R6337 VDD.n1925 VDD.n1921 0.0007
R6338 VDD.n1924 VDD.n1206 0.0007
R6339 VDD.n1929 VDD.n1928 0.0007
R6340 VDD.n1919 VDD.n1208 0.0007
R6341 VDD.n1916 VDD.n1915 0.0007
R6342 VDD.n1246 VDD.n1213 0.0007
R6343 VDD.n1833 VDD.n1247 0.0007
R6344 VDD.n1832 VDD.n1249 0.0007
R6345 VDD.n1836 VDD.n1241 0.0007
R6346 VDD.n1840 VDD.n1839 0.0007
R6347 VDD.n1844 VDD.n1235 0.0007
R6348 VDD.n1843 VDD.n1238 0.0007
R6349 VDD.n4012 VDD.n127 0.0007
R6350 VDD.n4017 VDD.n4016 0.0007
R6351 VDD.n1111 VDD.n129 0.0007
R6352 VDD.n1110 VDD.n850 0.0007
R6353 VDD.n1115 VDD.n1114 0.0007
R6354 VDD.n2465 VDD.n836 0.0007
R6355 VDD.n2464 VDD.n838 0.0007
R6356 VDD.n2468 VDD.n832 0.0007
R6357 VDD.n2472 VDD.n2471 0.0007
R6358 VDD.n2476 VDD.n826 0.0007
R6359 VDD.n2475 VDD.n829 0.0007
R6360 VDD.n1908 VDD.n1904 0.0007
R6361 VDD.n1907 VDD.n1216 0.0007
R6362 VDD.n1912 VDD.n1911 0.0007
R6363 VDD.n1902 VDD.n1218 0.0007
R6364 VDD.n1899 VDD.n1898 0.0007
R6365 VDD.n1848 VDD.n1223 0.0007
R6366 VDD.n1852 VDD.n1851 0.0007
R6367 VDD.n1856 VDD.n1230 0.0007
R6368 VDD.n1855 VDD.n1233 0.0007
R6369 VDD.n2812 VDD.n610 0.0007
R6370 VDD.n2811 VDD.n2807 0.0007
R6371 VDD.n2815 VDD.n2802 0.0007
R6372 VDD.n2820 VDD.n2816 0.0007
R6373 VDD.n2819 VDD.n2710 0.0007
R6374 VDD.n2824 VDD.n2823 0.0007
R6375 VDD.n2799 VDD.n2712 0.0007
R6376 VDD.n2796 VDD.n2795 0.0007
R6377 VDD.n2791 VDD.n2717 0.0007
R6378 VDD.n2790 VDD.n2718 0.0007
R6379 VDD.n2787 VDD.n2786 0.0007
R6380 VDD.n2782 VDD.n2766 0.0007
R6381 VDD.n2781 VDD.n2767 0.0007
R6382 VDD.n2778 VDD.n2777 0.0007
R6383 VDD.n2773 VDD.n2772 0.0007
R6384 VDD.n3021 VDD.n676 0.0007
R6385 VDD.n3020 VDD.n678 0.0007
R6386 VDD.n3024 VDD.n672 0.0007
R6387 VDD.n3028 VDD.n3027 0.0007
R6388 VDD.n3032 VDD.n666 0.0007
R6389 VDD.n3031 VDD.n669 0.0007
R6390 VDD.n3868 VDD.n3864 0.0007
R6391 VDD.n3867 VDD.n518 0.0007
R6392 VDD.n3872 VDD.n3871 0.0007
R6393 VDD.n2830 VDD.n520 0.0007
R6394 VDD.n2829 VDD.n2705 0.0007
R6395 VDD.n2834 VDD.n2833 0.0007
R6396 VDD.n2749 VDD.n2707 0.0007
R6397 VDD.n2748 VDD.n2730 0.0007
R6398 VDD.n2752 VDD.n2725 0.0007
R6399 VDD.n2756 VDD.n2755 0.0007
R6400 VDD.n2760 VDD.n2720 0.0007
R6401 VDD.n2759 VDD.n2723 0.0007
R6402 VDD.n3004 VDD.n690 0.0007
R6403 VDD.n3003 VDD.n692 0.0007
R6404 VDD.n3007 VDD.n686 0.0007
R6405 VDD.n3011 VDD.n3010 0.0007
R6406 VDD.n3015 VDD.n680 0.0007
R6407 VDD.n3014 VDD.n683 0.0007
R6408 VDD.n2557 VDD.n2553 0.0007
R6409 VDD.n2556 VDD.n2550 0.0007
R6410 VDD.n2561 VDD.n2560 0.0007
R6411 VDD.n3615 VDD.n3611 0.0007
R6412 VDD.n3614 VDD.n3234 0.0007
R6413 VDD.n3619 VDD.n3618 0.0007
R6414 VDD.n3548 VDD.n3236 0.0007
R6415 VDD.n3545 VDD.n3544 0.0007
R6416 VDD.n3541 VDD.n3241 0.0007
R6417 VDD.n3540 VDD.n3242 0.0007
R6418 VDD.n3537 VDD.n3536 0.0007
R6419 VDD.n3533 VDD.n3247 0.0007
R6420 VDD.n3532 VDD.n3248 0.0007
R6421 VDD.n3529 VDD.n3528 0.0007
R6422 VDD.n3525 VDD.n3253 0.0007
R6423 VDD.n3524 VDD.n3254 0.0007
R6424 VDD.n3521 VDD.n3520 0.0007
R6425 VDD.n3517 VDD.n3259 0.0007
R6426 VDD.n3516 VDD.n3260 0.0007
R6427 VDD.n3513 VDD.n3512 0.0007
R6428 VDD.n3509 VDD.n3265 0.0007
R6429 VDD.n3508 VDD.n3266 0.0007
R6430 VDD.n3505 VDD.n3504 0.0007
R6431 VDD.n3501 VDD.n3500 0.0007
R6432 VDD.n3626 VDD.n3226 0.0007
R6433 VDD.n3623 VDD.n3622 0.0007
R6434 VDD.n3367 VDD.n3231 0.0007
R6435 VDD.n3372 VDD.n3368 0.0007
R6436 VDD.n3371 VDD.n3317 0.0007
R6437 VDD.n3376 VDD.n3375 0.0007
R6438 VDD.n3363 VDD.n3319 0.0007
R6439 VDD.n3360 VDD.n3359 0.0007
R6440 VDD.n3355 VDD.n3324 0.0007
R6441 VDD.n3354 VDD.n3325 0.0007
R6442 VDD.n3351 VDD.n3350 0.0007
R6443 VDD.n3346 VDD.n3330 0.0007
R6444 VDD.n3345 VDD.n3331 0.0007
R6445 VDD.n3342 VDD.n3341 0.0007
R6446 VDD.n3337 VDD.n3336 0.0007
R6447 VDD.n3483 VDD.n3278 0.0007
R6448 VDD.n3482 VDD.n3280 0.0007
R6449 VDD.n3486 VDD.n3274 0.0007
R6450 VDD.n3490 VDD.n3489 0.0007
R6451 VDD.n3494 VDD.n3268 0.0007
R6452 VDD.n3493 VDD.n3271 0.0007
R6453 VDD.n3422 VDD.n3415 0.0007
R6454 VDD.n3421 VDD.n3417 0.0007
R6455 VDD.n3425 VDD.n3379 0.0007
R6456 VDD.n3433 VDD.n3426 0.0007
R6457 VDD.n3432 VDD.n3428 0.0007
R6458 VDD.n3436 VDD.n3313 0.0007
R6459 VDD.n3444 VDD.n3437 0.0007
R6460 VDD.n3443 VDD.n3439 0.0007
R6461 VDD.n3447 VDD.n3309 0.0007
R6462 VDD.n3455 VDD.n3448 0.0007
R6463 VDD.n3454 VDD.n3450 0.0007
R6464 VDD.n3458 VDD.n3305 0.0007
R6465 VDD.n3466 VDD.n3459 0.0007
R6466 VDD.n3465 VDD.n3461 0.0007
R6467 VDD.n3469 VDD.n3301 0.0007
R6468 VDD.n3473 VDD.n3472 0.0007
R6469 VDD.n3477 VDD.n3282 0.0007
R6470 VDD.n3476 VDD.n3299 0.0007
R6471 VDD.n3297 VDD.n3284 0.0007
R6472 VDD.n3294 VDD.n3293 0.0007
R6473 VDD.n3292 VDD.n3291 0.0007
R6474 VDD.n2936 VDD.n2929 0.0007
R6475 VDD.n2935 VDD.n2931 0.0007
R6476 VDD.n2939 VDD.n2632 0.0007
R6477 VDD.n2943 VDD.n2942 0.0007
R6478 VDD.n2947 VDD.n736 0.0007
R6479 VDD.n2946 VDD.n2630 0.0007
R6480 VDD.n2628 VDD.n738 0.0007
R6481 VDD.n2625 VDD.n2624 0.0007
R6482 VDD.n2623 VDD.n2622 0.0007
R6483 VDD.n2619 VDD.n743 0.0007
R6484 VDD.n2616 VDD.n2615 0.0007
R6485 VDD.n807 VDD.n748 0.0007
R6486 VDD.n2499 VDD.n808 0.0007
R6487 VDD.n2498 VDD.n810 0.0007
R6488 VDD.n2502 VDD.n802 0.0007
R6489 VDD.n2506 VDD.n2505 0.0007
R6490 VDD.n2510 VDD.n796 0.0007
R6491 VDD.n2509 VDD.n799 0.0007
R6492 VDD.n1874 VDD.n1870 0.0007
R6493 VDD.n1873 VDD.n1867 0.0007
R6494 VDD.n1878 VDD.n1877 0.0007
R6495 VDD.n3796 VDD.n622 0.0007
R6496 VDD.n3793 VDD.n3792 0.0007
R6497 VDD.n3789 VDD.n626 0.0007
R6498 VDD.n3788 VDD.n629 0.0007
R6499 VDD.n3785 VDD.n3784 0.0007
R6500 VDD.n3781 VDD.n633 0.0007
R6501 VDD.n3780 VDD.n636 0.0007
R6502 VDD.n3777 VDD.n3776 0.0007
R6503 VDD.n3773 VDD.n640 0.0007
R6504 VDD.n3772 VDD.n643 0.0007
R6505 VDD.n3769 VDD.n3768 0.0007
R6506 VDD.n3765 VDD.n647 0.0007
R6507 VDD.n3764 VDD.n650 0.0007
R6508 VDD.n3761 VDD.n3760 0.0007
R6509 VDD.n3757 VDD.n654 0.0007
R6510 VDD.n3756 VDD.n657 0.0007
R6511 VDD.n3753 VDD.n3752 0.0007
R6512 VDD.n3749 VDD.n661 0.0007
R6513 VDD.n3748 VDD.n664 0.0007
R6514 VDD.n3745 VDD.n3744 0.0007
R6515 VDD.n3741 VDD.n3738 0.0007
R6516 VDD.n3991 VDD.n3969 0.0007
R6517 VDD.n3990 VDD.n3971 0.0007
R6518 VDD.n3994 VDD.n141 0.0007
R6519 VDD.n3999 VDD.n3995 0.0007
R6520 VDD.n3998 VDD.n136 0.0007
R6521 VDD.n4003 VDD.n4002 0.0007
R6522 VDD.n1097 VDD.n138 0.0007
R6523 VDD.n1096 VDD.n1090 0.0007
R6524 VDD.n1101 VDD.n1100 0.0007
R6525 VDD.n2482 VDD.n822 0.0007
R6526 VDD.n2481 VDD.n824 0.0007
R6527 VDD.n2485 VDD.n818 0.0007
R6528 VDD.n2489 VDD.n2488 0.0007
R6529 VDD.n2493 VDD.n812 0.0007
R6530 VDD.n2492 VDD.n815 0.0007
R6531 VDD.n1891 VDD.n1887 0.0007
R6532 VDD.n1890 VDD.n1226 0.0007
R6533 VDD.n1895 VDD.n1894 0.0007
R6534 VDD.n1885 VDD.n1228 0.0007
R6535 VDD.n1882 VDD.n1881 0.0007
R6536 VDD.n1863 VDD.n1862 0.0007
R6537 VDD.n3879 VDD.n510 0.0007
R6538 VDD.n3876 VDD.n3875 0.0007
R6539 VDD.n2838 VDD.n515 0.0007
R6540 VDD.n2843 VDD.n2839 0.0007
R6541 VDD.n2842 VDD.n2700 0.0007
R6542 VDD.n2847 VDD.n2846 0.0007
R6543 VDD.n2736 VDD.n2702 0.0007
R6544 VDD.n2743 VDD.n2732 0.0007
R6545 VDD.n2742 VDD.n2735 0.0007
R6546 VDD.n2987 VDD.n704 0.0007
R6547 VDD.n2986 VDD.n706 0.0007
R6548 VDD.n2990 VDD.n700 0.0007
R6549 VDD.n2994 VDD.n2993 0.0007
R6550 VDD.n2998 VDD.n694 0.0007
R6551 VDD.n2997 VDD.n697 0.0007
R6552 VDD.n2574 VDD.n2570 0.0007
R6553 VDD.n2573 VDD.n771 0.0007
R6554 VDD.n2578 VDD.n2577 0.0007
R6555 VDD.n2568 VDD.n773 0.0007
R6556 VDD.n2565 VDD.n2564 0.0007
R6557 VDD.n2546 VDD.n2545 0.0007
R6558 VDD.n4071 VDD.n97 0.0007
R6559 VDD.n4077 VDD.n4076 0.0007
R6560 VDD.n2399 VDD.n99 0.0007
R6561 VDD.n2406 VDD.n1141 0.0007
R6562 VDD.n2405 VDD.n1144 0.0007
R6563 VDD.n2336 VDD.n2332 0.0007
R6564 VDD.n2335 VDD.n1176 0.0007
R6565 VDD.n2340 VDD.n2339 0.0007
R6566 VDD.n1768 VDD.n1178 0.0007
R6567 VDD.n1775 VDD.n1290 0.0007
R6568 VDD.n1774 VDD.n1293 0.0007
R6569 VDD.n1660 VDD.n1656 0.0007
R6570 VDD.n1659 VDD.n1344 0.0007
R6571 VDD.n1664 VDD.n1663 0.0007
R6572 VDD.n1550 VDD.n1346 0.0007
R6573 VDD.n1557 VDD.n1386 0.0007
R6574 VDD.n1556 VDD.n1389 0.0007
R6575 VDD.n1445 VDD.n1441 0.0007
R6576 VDD.n1444 VDD.n1438 0.0007
R6577 VDD.n1449 VDD.n1448 0.0007
R6578 VDD.n4082 VDD.n92 0.0007
R6579 VDD.n4087 VDD.n4086 0.0007
R6580 VDD.n2390 VDD.n94 0.0007
R6581 VDD.n2397 VDD.n1146 0.0007
R6582 VDD.n2396 VDD.n1149 0.0007
R6583 VDD.n2347 VDD.n2343 0.0007
R6584 VDD.n2346 VDD.n1171 0.0007
R6585 VDD.n2351 VDD.n2350 0.0007
R6586 VDD.n1759 VDD.n1173 0.0007
R6587 VDD.n1766 VDD.n1295 0.0007
R6588 VDD.n1765 VDD.n1298 0.0007
R6589 VDD.n1671 VDD.n1667 0.0007
R6590 VDD.n1670 VDD.n1339 0.0007
R6591 VDD.n1675 VDD.n1674 0.0007
R6592 VDD.n1541 VDD.n1341 0.0007
R6593 VDD.n1548 VDD.n1391 0.0007
R6594 VDD.n1547 VDD.n1394 0.0007
R6595 VDD.n1456 VDD.n1452 0.0007
R6596 VDD.n1455 VDD.n1434 0.0007
R6597 VDD.n1460 VDD.n1459 0.0007
R6598 VDD.n4124 VDD.n4122 0.0007
R6599 VDD.n4128 VDD.n74 0.0007
R6600 VDD.n4132 VDD.n4131 0.0007
R6601 VDD.n4135 VDD.n70 0.0007
R6602 VDD.n4134 VDD.n17 0.0007
R6603 VDD.n4160 VDD.n50 0.0007
R6604 VDD.n4157 VDD.n4156 0.0007
R6605 VDD.n1720 VDD.n51 0.0007
R6606 VDD.n1724 VDD.n1723 0.0007
R6607 VDD.n1727 VDD.n1315 0.0007
R6608 VDD.n1726 VDD.n1717 0.0007
R6609 VDD.n1715 VDD.n1317 0.0007
R6610 VDD.n1712 VDD.n1711 0.0007
R6611 VDD.n1505 VDD.n1318 0.0007
R6612 VDD.n1509 VDD.n1508 0.0007
R6613 VDD.n1512 VDD.n1411 0.0007
R6614 VDD.n1511 VDD.n1502 0.0007
R6615 VDD.n1500 VDD.n1413 0.0007
R6616 VDD.n1497 VDD.n1496 0.0007
R6617 VDD.n1418 VDD.n1414 0.0007
R6618 VDD.n4112 VDD.n78 0.0007
R6619 VDD.n4117 VDD.n4116 0.0007
R6620 VDD.n4141 VDD.n66 0.0007
R6621 VDD.n4140 VDD.n68 0.0007
R6622 VDD.n4144 VDD.n62 0.0007
R6623 VDD.n4149 VDD.n4145 0.0007
R6624 VDD.n4148 VDD.n57 0.0007
R6625 VDD.n4153 VDD.n4152 0.0007
R6626 VDD.n1729 VDD.n59 0.0007
R6627 VDD.n1736 VDD.n1310 0.0007
R6628 VDD.n1735 VDD.n1313 0.0007
R6629 VDD.n1704 VDD.n1700 0.0007
R6630 VDD.n1703 VDD.n1324 0.0007
R6631 VDD.n1708 VDD.n1707 0.0007
R6632 VDD.n1514 VDD.n1326 0.0007
R6633 VDD.n1521 VDD.n1406 0.0007
R6634 VDD.n1520 VDD.n1409 0.0007
R6635 VDD.n1489 VDD.n1485 0.0007
R6636 VDD.n1488 VDD.n1422 0.0007
R6637 VDD.n1493 VDD.n1492 0.0007
R6638 VDD.n4102 VDD.n82 0.0007
R6639 VDD.n4107 VDD.n4106 0.0007
R6640 VDD.n2372 VDD.n84 0.0007
R6641 VDD.n2379 VDD.n1156 0.0007
R6642 VDD.n2378 VDD.n2371 0.0007
R6643 VDD.n2369 VDD.n1158 0.0007
R6644 VDD.n2366 VDD.n2365 0.0007
R6645 VDD.n1740 VDD.n1163 0.0007
R6646 VDD.n1744 VDD.n1743 0.0007
R6647 VDD.n1748 VDD.n1305 0.0007
R6648 VDD.n1747 VDD.n1308 0.0007
R6649 VDD.n1693 VDD.n1689 0.0007
R6650 VDD.n1692 VDD.n1329 0.0007
R6651 VDD.n1697 VDD.n1696 0.0007
R6652 VDD.n1523 VDD.n1331 0.0007
R6653 VDD.n1530 VDD.n1401 0.0007
R6654 VDD.n1529 VDD.n1404 0.0007
R6655 VDD.n1478 VDD.n1474 0.0007
R6656 VDD.n1477 VDD.n1426 0.0007
R6657 VDD.n1482 VDD.n1481 0.0007
R6658 VDD.n4092 VDD.n87 0.0007
R6659 VDD.n4097 VDD.n4096 0.0007
R6660 VDD.n2381 VDD.n89 0.0007
R6661 VDD.n2388 VDD.n1151 0.0007
R6662 VDD.n2387 VDD.n1154 0.0007
R6663 VDD.n2358 VDD.n2354 0.0007
R6664 VDD.n2357 VDD.n1166 0.0007
R6665 VDD.n2362 VDD.n2361 0.0007
R6666 VDD.n1750 VDD.n1168 0.0007
R6667 VDD.n1757 VDD.n1300 0.0007
R6668 VDD.n1756 VDD.n1303 0.0007
R6669 VDD.n1682 VDD.n1678 0.0007
R6670 VDD.n1681 VDD.n1334 0.0007
R6671 VDD.n1686 VDD.n1685 0.0007
R6672 VDD.n1532 VDD.n1336 0.0007
R6673 VDD.n1539 VDD.n1396 0.0007
R6674 VDD.n1538 VDD.n1399 0.0007
R6675 VDD.n1467 VDD.n1463 0.0007
R6676 VDD.n1466 VDD.n1430 0.0007
R6677 VDD.n1471 VDD.n1470 0.0007
R6678 VDD.n2871 VDD.n2678 0.0007
R6679 VDD.n2868 VDD.n2867 0.0007
R6680 VDD.n2684 VDD.n2683 0.0007
R6681 VDD.n2953 VDD.n732 0.0007
R6682 VDD.n2952 VDD.n734 0.0007
R6683 VDD.n2956 VDD.n728 0.0007
R6684 VDD.n2960 VDD.n2959 0.0007
R6685 VDD.n2964 VDD.n722 0.0007
R6686 VDD.n2963 VDD.n725 0.0007
R6687 VDD.n2608 VDD.n2604 0.0007
R6688 VDD.n2607 VDD.n751 0.0007
R6689 VDD.n2612 VDD.n2611 0.0007
R6690 VDD.n2602 VDD.n753 0.0007
R6691 VDD.n2599 VDD.n2598 0.0007
R6692 VDD.n791 VDD.n758 0.0007
R6693 VDD.n2516 VDD.n792 0.0007
R6694 VDD.n2515 VDD.n794 0.0007
R6695 VDD.n2519 VDD.n786 0.0007
R6696 VDD.n2523 VDD.n2522 0.0007
R6697 VDD.n2527 VDD.n780 0.0007
R6698 VDD.n2526 VDD.n783 0.0007
R6699 VDD.n2860 VDD.n496 0.0007
R6700 VDD.n2859 VDD.n2688 0.0007
R6701 VDD.n2864 VDD.n2863 0.0007
R6702 VDD.n2854 VDD.n2690 0.0007
R6703 VDD.n2851 VDD.n2850 0.0007
R6704 VDD.n2696 VDD.n2695 0.0007
R6705 VDD.n2970 VDD.n718 0.0007
R6706 VDD.n2969 VDD.n720 0.0007
R6707 VDD.n2973 VDD.n714 0.0007
R6708 VDD.n2977 VDD.n2976 0.0007
R6709 VDD.n2981 VDD.n708 0.0007
R6710 VDD.n2980 VDD.n711 0.0007
R6711 VDD.n2591 VDD.n2587 0.0007
R6712 VDD.n2590 VDD.n761 0.0007
R6713 VDD.n2595 VDD.n2594 0.0007
R6714 VDD.n2585 VDD.n763 0.0007
R6715 VDD.n2582 VDD.n2581 0.0007
R6716 VDD.n2531 VDD.n768 0.0007
R6717 VDD.n2535 VDD.n2534 0.0007
R6718 VDD.n2539 VDD.n775 0.0007
R6719 VDD.n2538 VDD.n778 0.0007
R6720 VDD.n3668 VDD.n3661 0.0007
R6721 VDD.n3667 VDD.n3663 0.0007
R6722 VDD.n3671 VDD.n3061 0.0007
R6723 VDD.n3679 VDD.n3672 0.0007
R6724 VDD.n3678 VDD.n3674 0.0007
R6725 VDD.n3682 VDD.n3057 0.0007
R6726 VDD.n3690 VDD.n3683 0.0007
R6727 VDD.n3689 VDD.n3685 0.0007
R6728 VDD.n3693 VDD.n3053 0.0007
R6729 VDD.n3701 VDD.n3694 0.0007
R6730 VDD.n3700 VDD.n3696 0.0007
R6731 VDD.n3704 VDD.n3049 0.0007
R6732 VDD.n3712 VDD.n3705 0.0007
R6733 VDD.n3711 VDD.n3707 0.0007
R6734 VDD.n3715 VDD.n3045 0.0007
R6735 VDD.n3723 VDD.n3716 0.0007
R6736 VDD.n3722 VDD.n3718 0.0007
R6737 VDD.n3726 VDD.n3041 0.0007
R6738 VDD.n3731 VDD.n3727 0.0007
R6739 VDD.n3730 VDD.n3037 0.0007
R6740 VDD.n3735 VDD.n3734 0.0007
R6741 VDD.n4121 VDD.n75 0.00065
R6742 VDD.n4127 VDD.n4126 0.00065
R6743 VDD.n4118 VDD.n77 0.00065
R6744 VDD.n4110 VDD.n79 0.00065
R6745 VDD.n4115 VDD.n4114 0.00065
R6746 VDD.n4108 VDD.n81 0.00065
R6747 VDD.n4100 VDD.n83 0.00065
R6748 VDD.n4105 VDD.n4104 0.00065
R6749 VDD.n4098 VDD.n86 0.00065
R6750 VDD.n4090 VDD.n88 0.00065
R6751 VDD.n4095 VDD.n4094 0.00065
R6752 VDD.n4088 VDD.n91 0.00065
R6753 VDD.n4080 VDD.n93 0.00065
R6754 VDD.n4085 VDD.n4084 0.00065
R6755 VDD.n4078 VDD.n96 0.00065
R6756 VDD.n4072 VDD.n98 0.00065
R6757 VDD.n4075 VDD.n4074 0.00065
R6758 VDD.n4068 VDD.n101 0.00065
R6759 VDD.n4060 VDD.n103 0.00065
R6760 VDD.n4065 VDD.n4064 0.00065
R6761 VDD.n4058 VDD.n106 0.00065
R6762 VDD.n4052 VDD.n108 0.00065
R6763 VDD.n4055 VDD.n4054 0.00065
R6764 VDD.n4048 VDD.n111 0.00065
R6765 VDD.n4040 VDD.n113 0.00065
R6766 VDD.n4045 VDD.n4044 0.00065
R6767 VDD.n4038 VDD.n116 0.00065
R6768 VDD.n4030 VDD.n118 0.00065
R6769 VDD.n4035 VDD.n4034 0.00065
R6770 VDD.n4028 VDD.n121 0.00065
R6771 VDD.n4020 VDD.n123 0.00065
R6772 VDD.n4025 VDD.n4024 0.00065
R6773 VDD.n4018 VDD.n126 0.00065
R6774 VDD.n4010 VDD.n128 0.00065
R6775 VDD.n4015 VDD.n4014 0.00065
R6776 VDD.n3988 VDD.n3987 0.00065
R6777 VDD.n3970 VDD.n142 0.00065
R6778 VDD.n3993 VDD.n3992 0.00065
R6779 VDD.n2933 VDD.n2932 0.00065
R6780 VDD.n2930 VDD.n2633 0.00065
R6781 VDD.n2938 VDD.n2937 0.00065
R6782 VDD.n2870 VDD.n2679 0.00065
R6783 VDD.n2681 VDD.n2680 0.00065
R6784 VDD.n2686 VDD.n2685 0.00065
R6785 VDD.n2865 VDD.n2687 0.00065
R6786 VDD.n2857 VDD.n2689 0.00065
R6787 VDD.n2862 VDD.n2861 0.00065
R6788 VDD.n3878 VDD.n511 0.00065
R6789 VDD.n513 VDD.n512 0.00065
R6790 VDD.n2837 VDD.n516 0.00065
R6791 VDD.n3873 VDD.n517 0.00065
R6792 VDD.n3865 VDD.n519 0.00065
R6793 VDD.n3870 VDD.n3869 0.00065
R6794 VDD.n2809 VDD.n2808 0.00065
R6795 VDD.n2806 VDD.n2803 0.00065
R6796 VDD.n2814 VDD.n2813 0.00065
R6797 VDD.n3795 VDD.n623 0.00065
R6798 VDD.n627 VDD.n624 0.00065
R6799 VDD.n3790 VDD.n628 0.00065
R6800 VDD.n3665 VDD.n3664 0.00065
R6801 VDD.n3662 VDD.n3062 0.00065
R6802 VDD.n3670 VDD.n3669 0.00065
R6803 VDD.n3419 VDD.n3418 0.00065
R6804 VDD.n3416 VDD.n3380 0.00065
R6805 VDD.n3424 VDD.n3423 0.00065
R6806 VDD.n3625 VDD.n3227 0.00065
R6807 VDD.n3229 VDD.n3228 0.00065
R6808 VDD.n3366 VDD.n3232 0.00065
R6809 VDD.n3620 VDD.n3233 0.00065
R6810 VDD.n3612 VDD.n3235 0.00065
R6811 VDD.n3617 VDD.n3616 0.00065
R6812 VDD.n4130 VDD.n4129 0.00065
R6813 VDD.n71 VDD.n69 0.00065
R6814 VDD.n4138 VDD.n4137 0.00065
R6815 VDD.n67 VDD.n63 0.00065
R6816 VDD.n4143 VDD.n4142 0.00065
R6817 VDD.n2377 VDD.n2376 0.00065
R6818 VDD.n2374 VDD.n2373 0.00065
R6819 VDD.n2370 VDD.n1155 0.00065
R6820 VDD.n2386 VDD.n2385 0.00065
R6821 VDD.n2383 VDD.n2382 0.00065
R6822 VDD.n1153 VDD.n1150 0.00065
R6823 VDD.n2395 VDD.n2394 0.00065
R6824 VDD.n2392 VDD.n2391 0.00065
R6825 VDD.n1148 VDD.n1145 0.00065
R6826 VDD.n2404 VDD.n2403 0.00065
R6827 VDD.n2401 VDD.n2400 0.00065
R6828 VDD.n1143 VDD.n1140 0.00065
R6829 VDD.n2413 VDD.n2412 0.00065
R6830 VDD.n2410 VDD.n2409 0.00065
R6831 VDD.n1138 VDD.n1135 0.00065
R6832 VDD.n2422 VDD.n2421 0.00065
R6833 VDD.n2419 VDD.n2418 0.00065
R6834 VDD.n1133 VDD.n1130 0.00065
R6835 VDD.n2431 VDD.n2430 0.00065
R6836 VDD.n2428 VDD.n2427 0.00065
R6837 VDD.n1128 VDD.n1125 0.00065
R6838 VDD.n2440 VDD.n2439 0.00065
R6839 VDD.n2437 VDD.n2436 0.00065
R6840 VDD.n1123 VDD.n1120 0.00065
R6841 VDD.n2445 VDD.n2444 0.00065
R6842 VDD.n1118 VDD.n847 0.00065
R6843 VDD.n2450 VDD.n2449 0.00065
R6844 VDD.n1116 VDD.n849 0.00065
R6845 VDD.n1108 VDD.n851 0.00065
R6846 VDD.n1113 VDD.n1112 0.00065
R6847 VDD.n4004 VDD.n135 0.00065
R6848 VDD.n3996 VDD.n137 0.00065
R6849 VDD.n4001 VDD.n4000 0.00065
R6850 VDD.n2945 VDD.n2944 0.00065
R6851 VDD.n2941 VDD.n2940 0.00065
R6852 VDD.n2629 VDD.n735 0.00065
R6853 VDD.n2950 VDD.n2949 0.00065
R6854 VDD.n733 VDD.n729 0.00065
R6855 VDD.n2955 VDD.n2954 0.00065
R6856 VDD.n2853 VDD.n2691 0.00065
R6857 VDD.n2693 VDD.n2692 0.00065
R6858 VDD.n2698 VDD.n2697 0.00065
R6859 VDD.n2848 VDD.n2699 0.00065
R6860 VDD.n2840 VDD.n2701 0.00065
R6861 VDD.n2845 VDD.n2844 0.00065
R6862 VDD.n2835 VDD.n2704 0.00065
R6863 VDD.n2827 VDD.n2706 0.00065
R6864 VDD.n2832 VDD.n2831 0.00065
R6865 VDD.n2825 VDD.n2709 0.00065
R6866 VDD.n2817 VDD.n2711 0.00065
R6867 VDD.n2822 VDD.n2821 0.00065
R6868 VDD.n3787 VDD.n630 0.00065
R6869 VDD.n634 VDD.n631 0.00065
R6870 VDD.n3782 VDD.n635 0.00065
R6871 VDD.n3676 VDD.n3675 0.00065
R6872 VDD.n3673 VDD.n3058 0.00065
R6873 VDD.n3681 VDD.n3680 0.00065
R6874 VDD.n3430 VDD.n3429 0.00065
R6875 VDD.n3427 VDD.n3314 0.00065
R6876 VDD.n3435 VDD.n3434 0.00065
R6877 VDD.n3377 VDD.n3316 0.00065
R6878 VDD.n3369 VDD.n3318 0.00065
R6879 VDD.n3374 VDD.n3373 0.00065
R6880 VDD.n3547 VDD.n3237 0.00065
R6881 VDD.n3239 VDD.n3238 0.00065
R6882 VDD.n3543 VDD.n3542 0.00065
R6883 VDD.n53 VDD.n52 0.00065
R6884 VDD.n1719 VDD.n55 0.00065
R6885 VDD.n4154 VDD.n56 0.00065
R6886 VDD.n4146 VDD.n58 0.00065
R6887 VDD.n4151 VDD.n4150 0.00065
R6888 VDD.n2368 VDD.n1159 0.00065
R6889 VDD.n1161 VDD.n1160 0.00065
R6890 VDD.n1739 VDD.n1164 0.00065
R6891 VDD.n2363 VDD.n1165 0.00065
R6892 VDD.n2355 VDD.n1167 0.00065
R6893 VDD.n2360 VDD.n2359 0.00065
R6894 VDD.n2352 VDD.n1170 0.00065
R6895 VDD.n2344 VDD.n1172 0.00065
R6896 VDD.n2349 VDD.n2348 0.00065
R6897 VDD.n2341 VDD.n1175 0.00065
R6898 VDD.n2333 VDD.n1177 0.00065
R6899 VDD.n2338 VDD.n2337 0.00065
R6900 VDD.n2330 VDD.n1180 0.00065
R6901 VDD.n2322 VDD.n1182 0.00065
R6902 VDD.n2327 VDD.n2326 0.00065
R6903 VDD.n2319 VDD.n1185 0.00065
R6904 VDD.n2311 VDD.n1187 0.00065
R6905 VDD.n2316 VDD.n2315 0.00065
R6906 VDD.n1958 VDD.n1190 0.00065
R6907 VDD.n1950 VDD.n1192 0.00065
R6908 VDD.n1955 VDD.n1954 0.00065
R6909 VDD.n1947 VDD.n1195 0.00065
R6910 VDD.n1939 VDD.n1197 0.00065
R6911 VDD.n1944 VDD.n1943 0.00065
R6912 VDD.n2457 VDD.n2456 0.00065
R6913 VDD.n2453 VDD.n2452 0.00065
R6914 VDD.n842 VDD.n839 0.00065
R6915 VDD.n2462 VDD.n2461 0.00065
R6916 VDD.n837 VDD.n833 0.00065
R6917 VDD.n2467 VDD.n2466 0.00065
R6918 VDD.n1102 VDD.n1089 0.00065
R6919 VDD.n1094 VDD.n1091 0.00065
R6920 VDD.n1099 VDD.n1098 0.00065
R6921 VDD.n2627 VDD.n739 0.00065
R6922 VDD.n741 VDD.n740 0.00065
R6923 VDD.n2621 VDD.n2620 0.00065
R6924 VDD.n2962 VDD.n2961 0.00065
R6925 VDD.n2958 VDD.n2957 0.00065
R6926 VDD.n724 VDD.n721 0.00065
R6927 VDD.n2967 VDD.n2966 0.00065
R6928 VDD.n719 VDD.n715 0.00065
R6929 VDD.n2972 VDD.n2971 0.00065
R6930 VDD.n2741 VDD.n2740 0.00065
R6931 VDD.n2738 VDD.n2737 0.00065
R6932 VDD.n2734 VDD.n2731 0.00065
R6933 VDD.n2746 VDD.n2745 0.00065
R6934 VDD.n2729 VDD.n2726 0.00065
R6935 VDD.n2751 VDD.n2750 0.00065
R6936 VDD.n2798 VDD.n2713 0.00065
R6937 VDD.n2715 VDD.n2714 0.00065
R6938 VDD.n2793 VDD.n2792 0.00065
R6939 VDD.n3779 VDD.n637 0.00065
R6940 VDD.n641 VDD.n638 0.00065
R6941 VDD.n3774 VDD.n642 0.00065
R6942 VDD.n3687 VDD.n3686 0.00065
R6943 VDD.n3684 VDD.n3054 0.00065
R6944 VDD.n3692 VDD.n3691 0.00065
R6945 VDD.n3441 VDD.n3440 0.00065
R6946 VDD.n3438 VDD.n3310 0.00065
R6947 VDD.n3446 VDD.n3445 0.00065
R6948 VDD.n3362 VDD.n3320 0.00065
R6949 VDD.n3322 VDD.n3321 0.00065
R6950 VDD.n3357 VDD.n3356 0.00065
R6951 VDD.n3539 VDD.n3243 0.00065
R6952 VDD.n3245 VDD.n3244 0.00065
R6953 VDD.n3535 VDD.n3534 0.00065
R6954 VDD.n1722 VDD.n1721 0.00065
R6955 VDD.n1716 VDD.n1314 0.00065
R6956 VDD.n1734 VDD.n1733 0.00065
R6957 VDD.n1731 VDD.n1730 0.00065
R6958 VDD.n1312 VDD.n1309 0.00065
R6959 VDD.n1746 VDD.n1745 0.00065
R6960 VDD.n1742 VDD.n1741 0.00065
R6961 VDD.n1307 VDD.n1304 0.00065
R6962 VDD.n1755 VDD.n1754 0.00065
R6963 VDD.n1752 VDD.n1751 0.00065
R6964 VDD.n1302 VDD.n1299 0.00065
R6965 VDD.n1764 VDD.n1763 0.00065
R6966 VDD.n1761 VDD.n1760 0.00065
R6967 VDD.n1297 VDD.n1294 0.00065
R6968 VDD.n1773 VDD.n1772 0.00065
R6969 VDD.n1770 VDD.n1769 0.00065
R6970 VDD.n1292 VDD.n1289 0.00065
R6971 VDD.n1782 VDD.n1781 0.00065
R6972 VDD.n1779 VDD.n1778 0.00065
R6973 VDD.n1287 VDD.n1284 0.00065
R6974 VDD.n1791 VDD.n1790 0.00065
R6975 VDD.n1788 VDD.n1787 0.00065
R6976 VDD.n1282 VDD.n1279 0.00065
R6977 VDD.n1796 VDD.n1795 0.00065
R6978 VDD.n1277 VDD.n1274 0.00065
R6979 VDD.n1801 VDD.n1800 0.00065
R6980 VDD.n1935 VDD.n1199 0.00065
R6981 VDD.n1201 VDD.n1200 0.00065
R6982 VDD.n1261 VDD.n1204 0.00065
R6983 VDD.n1930 VDD.n1205 0.00065
R6984 VDD.n1922 VDD.n1207 0.00065
R6985 VDD.n1927 VDD.n1926 0.00065
R6986 VDD.n2474 VDD.n2473 0.00065
R6987 VDD.n2470 VDD.n2469 0.00065
R6988 VDD.n828 VDD.n825 0.00065
R6989 VDD.n2479 VDD.n2478 0.00065
R6990 VDD.n823 VDD.n819 0.00065
R6991 VDD.n2484 VDD.n2483 0.00065
R6992 VDD.n2618 VDD.n744 0.00065
R6993 VDD.n746 VDD.n745 0.00065
R6994 VDD.n806 VDD.n749 0.00065
R6995 VDD.n2613 VDD.n750 0.00065
R6996 VDD.n2605 VDD.n752 0.00065
R6997 VDD.n2610 VDD.n2609 0.00065
R6998 VDD.n2979 VDD.n2978 0.00065
R6999 VDD.n2975 VDD.n2974 0.00065
R7000 VDD.n710 VDD.n707 0.00065
R7001 VDD.n2984 VDD.n2983 0.00065
R7002 VDD.n705 VDD.n701 0.00065
R7003 VDD.n2989 VDD.n2988 0.00065
R7004 VDD.n2758 VDD.n2757 0.00065
R7005 VDD.n2754 VDD.n2753 0.00065
R7006 VDD.n2722 VDD.n2719 0.00065
R7007 VDD.n2789 VDD.n2762 0.00065
R7008 VDD.n2764 VDD.n2763 0.00065
R7009 VDD.n2784 VDD.n2783 0.00065
R7010 VDD.n3771 VDD.n644 0.00065
R7011 VDD.n648 VDD.n645 0.00065
R7012 VDD.n3766 VDD.n649 0.00065
R7013 VDD.n3698 VDD.n3697 0.00065
R7014 VDD.n3695 VDD.n3050 0.00065
R7015 VDD.n3703 VDD.n3702 0.00065
R7016 VDD.n3452 VDD.n3451 0.00065
R7017 VDD.n3449 VDD.n3306 0.00065
R7018 VDD.n3457 VDD.n3456 0.00065
R7019 VDD.n3353 VDD.n3326 0.00065
R7020 VDD.n3328 VDD.n3327 0.00065
R7021 VDD.n3348 VDD.n3347 0.00065
R7022 VDD.n3531 VDD.n3249 0.00065
R7023 VDD.n3251 VDD.n3250 0.00065
R7024 VDD.n3527 VDD.n3526 0.00065
R7025 VDD.n1320 VDD.n1319 0.00065
R7026 VDD.n1504 VDD.n1322 0.00065
R7027 VDD.n1709 VDD.n1323 0.00065
R7028 VDD.n1701 VDD.n1325 0.00065
R7029 VDD.n1706 VDD.n1705 0.00065
R7030 VDD.n1698 VDD.n1328 0.00065
R7031 VDD.n1690 VDD.n1330 0.00065
R7032 VDD.n1695 VDD.n1694 0.00065
R7033 VDD.n1687 VDD.n1333 0.00065
R7034 VDD.n1679 VDD.n1335 0.00065
R7035 VDD.n1684 VDD.n1683 0.00065
R7036 VDD.n1676 VDD.n1338 0.00065
R7037 VDD.n1668 VDD.n1340 0.00065
R7038 VDD.n1673 VDD.n1672 0.00065
R7039 VDD.n1665 VDD.n1343 0.00065
R7040 VDD.n1657 VDD.n1345 0.00065
R7041 VDD.n1662 VDD.n1661 0.00065
R7042 VDD.n1654 VDD.n1348 0.00065
R7043 VDD.n1646 VDD.n1350 0.00065
R7044 VDD.n1651 VDD.n1650 0.00065
R7045 VDD.n1643 VDD.n1353 0.00065
R7046 VDD.n1635 VDD.n1355 0.00065
R7047 VDD.n1640 VDD.n1639 0.00065
R7048 VDD.n1808 VDD.n1807 0.00065
R7049 VDD.n1804 VDD.n1803 0.00065
R7050 VDD.n1269 VDD.n1266 0.00065
R7051 VDD.n1813 VDD.n1812 0.00065
R7052 VDD.n1264 VDD.n1258 0.00065
R7053 VDD.n1818 VDD.n1817 0.00065
R7054 VDD.n1918 VDD.n1209 0.00065
R7055 VDD.n1211 VDD.n1210 0.00065
R7056 VDD.n1245 VDD.n1214 0.00065
R7057 VDD.n1913 VDD.n1215 0.00065
R7058 VDD.n1905 VDD.n1217 0.00065
R7059 VDD.n1910 VDD.n1909 0.00065
R7060 VDD.n2491 VDD.n2490 0.00065
R7061 VDD.n2487 VDD.n2486 0.00065
R7062 VDD.n814 VDD.n811 0.00065
R7063 VDD.n2496 VDD.n2495 0.00065
R7064 VDD.n809 VDD.n803 0.00065
R7065 VDD.n2501 VDD.n2500 0.00065
R7066 VDD.n2601 VDD.n754 0.00065
R7067 VDD.n756 VDD.n755 0.00065
R7068 VDD.n790 VDD.n759 0.00065
R7069 VDD.n2596 VDD.n760 0.00065
R7070 VDD.n2588 VDD.n762 0.00065
R7071 VDD.n2593 VDD.n2592 0.00065
R7072 VDD.n2996 VDD.n2995 0.00065
R7073 VDD.n2992 VDD.n2991 0.00065
R7074 VDD.n696 VDD.n693 0.00065
R7075 VDD.n3001 VDD.n3000 0.00065
R7076 VDD.n691 VDD.n687 0.00065
R7077 VDD.n3006 VDD.n3005 0.00065
R7078 VDD.n2780 VDD.n2768 0.00065
R7079 VDD.n2770 VDD.n2769 0.00065
R7080 VDD.n2775 VDD.n2774 0.00065
R7081 VDD.n3763 VDD.n651 0.00065
R7082 VDD.n655 VDD.n652 0.00065
R7083 VDD.n3758 VDD.n656 0.00065
R7084 VDD.n3709 VDD.n3708 0.00065
R7085 VDD.n3706 VDD.n3046 0.00065
R7086 VDD.n3714 VDD.n3713 0.00065
R7087 VDD.n3463 VDD.n3462 0.00065
R7088 VDD.n3460 VDD.n3302 0.00065
R7089 VDD.n3468 VDD.n3467 0.00065
R7090 VDD.n3344 VDD.n3332 0.00065
R7091 VDD.n3334 VDD.n3333 0.00065
R7092 VDD.n3339 VDD.n3338 0.00065
R7093 VDD.n3523 VDD.n3255 0.00065
R7094 VDD.n3257 VDD.n3256 0.00065
R7095 VDD.n3519 VDD.n3518 0.00065
R7096 VDD.n1507 VDD.n1506 0.00065
R7097 VDD.n1501 VDD.n1410 0.00065
R7098 VDD.n1519 VDD.n1518 0.00065
R7099 VDD.n1516 VDD.n1515 0.00065
R7100 VDD.n1408 VDD.n1405 0.00065
R7101 VDD.n1528 VDD.n1527 0.00065
R7102 VDD.n1525 VDD.n1524 0.00065
R7103 VDD.n1403 VDD.n1400 0.00065
R7104 VDD.n1537 VDD.n1536 0.00065
R7105 VDD.n1534 VDD.n1533 0.00065
R7106 VDD.n1398 VDD.n1395 0.00065
R7107 VDD.n1546 VDD.n1545 0.00065
R7108 VDD.n1543 VDD.n1542 0.00065
R7109 VDD.n1393 VDD.n1390 0.00065
R7110 VDD.n1555 VDD.n1554 0.00065
R7111 VDD.n1552 VDD.n1551 0.00065
R7112 VDD.n1388 VDD.n1385 0.00065
R7113 VDD.n1560 VDD.n1559 0.00065
R7114 VDD.n1383 VDD.n1380 0.00065
R7115 VDD.n1565 VDD.n1564 0.00065
R7116 VDD.n1631 VDD.n1357 0.00065
R7117 VDD.n1359 VDD.n1358 0.00065
R7118 VDD.n1577 VDD.n1362 0.00065
R7119 VDD.n1626 VDD.n1363 0.00065
R7120 VDD.n1618 VDD.n1365 0.00065
R7121 VDD.n1623 VDD.n1622 0.00065
R7122 VDD.n1825 VDD.n1824 0.00065
R7123 VDD.n1821 VDD.n1820 0.00065
R7124 VDD.n1253 VDD.n1250 0.00065
R7125 VDD.n1830 VDD.n1829 0.00065
R7126 VDD.n1248 VDD.n1242 0.00065
R7127 VDD.n1835 VDD.n1834 0.00065
R7128 VDD.n1901 VDD.n1219 0.00065
R7129 VDD.n1221 VDD.n1220 0.00065
R7130 VDD.n1847 VDD.n1224 0.00065
R7131 VDD.n1896 VDD.n1225 0.00065
R7132 VDD.n1888 VDD.n1227 0.00065
R7133 VDD.n1893 VDD.n1892 0.00065
R7134 VDD.n2508 VDD.n2507 0.00065
R7135 VDD.n2504 VDD.n2503 0.00065
R7136 VDD.n798 VDD.n795 0.00065
R7137 VDD.n2513 VDD.n2512 0.00065
R7138 VDD.n793 VDD.n787 0.00065
R7139 VDD.n2518 VDD.n2517 0.00065
R7140 VDD.n2584 VDD.n764 0.00065
R7141 VDD.n766 VDD.n765 0.00065
R7142 VDD.n2530 VDD.n769 0.00065
R7143 VDD.n2579 VDD.n770 0.00065
R7144 VDD.n2571 VDD.n772 0.00065
R7145 VDD.n2576 VDD.n2575 0.00065
R7146 VDD.n3013 VDD.n3012 0.00065
R7147 VDD.n3009 VDD.n3008 0.00065
R7148 VDD.n682 VDD.n679 0.00065
R7149 VDD.n3018 VDD.n3017 0.00065
R7150 VDD.n677 VDD.n673 0.00065
R7151 VDD.n3023 VDD.n3022 0.00065
R7152 VDD.n3755 VDD.n658 0.00065
R7153 VDD.n662 VDD.n659 0.00065
R7154 VDD.n3750 VDD.n663 0.00065
R7155 VDD.n3720 VDD.n3719 0.00065
R7156 VDD.n3717 VDD.n3042 0.00065
R7157 VDD.n3725 VDD.n3724 0.00065
R7158 VDD.n3475 VDD.n3474 0.00065
R7159 VDD.n3471 VDD.n3470 0.00065
R7160 VDD.n3298 VDD.n3281 0.00065
R7161 VDD.n3480 VDD.n3479 0.00065
R7162 VDD.n3279 VDD.n3275 0.00065
R7163 VDD.n3485 VDD.n3484 0.00065
R7164 VDD.n3515 VDD.n3261 0.00065
R7165 VDD.n3263 VDD.n3262 0.00065
R7166 VDD.n3511 VDD.n3510 0.00065
R7167 VDD.n1416 VDD.n1415 0.00065
R7168 VDD.n1420 VDD.n1419 0.00065
R7169 VDD.n1494 VDD.n1421 0.00065
R7170 VDD.n1486 VDD.n1423 0.00065
R7171 VDD.n1491 VDD.n1490 0.00065
R7172 VDD.n1483 VDD.n1425 0.00065
R7173 VDD.n1475 VDD.n1427 0.00065
R7174 VDD.n1480 VDD.n1479 0.00065
R7175 VDD.n1472 VDD.n1429 0.00065
R7176 VDD.n1464 VDD.n1431 0.00065
R7177 VDD.n1469 VDD.n1468 0.00065
R7178 VDD.n1461 VDD.n1433 0.00065
R7179 VDD.n1453 VDD.n1435 0.00065
R7180 VDD.n1458 VDD.n1457 0.00065
R7181 VDD.n1450 VDD.n1437 0.00065
R7182 VDD.n1442 VDD.n1439 0.00065
R7183 VDD.n1447 VDD.n1446 0.00065
R7184 VDD.n1572 VDD.n1571 0.00065
R7185 VDD.n1568 VDD.n1567 0.00065
R7186 VDD.n1375 VDD.n1372 0.00065
R7187 VDD.n1584 VDD.n1583 0.00065
R7188 VDD.n1580 VDD.n1579 0.00065
R7189 VDD.n1370 VDD.n1367 0.00065
R7190 VDD.n1614 VDD.n1588 0.00065
R7191 VDD.n1590 VDD.n1589 0.00065
R7192 VDD.n1595 VDD.n1594 0.00065
R7193 VDD.n1609 VDD.n1596 0.00065
R7194 VDD.n1601 VDD.n1598 0.00065
R7195 VDD.n1606 VDD.n1605 0.00065
R7196 VDD.n1842 VDD.n1841 0.00065
R7197 VDD.n1838 VDD.n1837 0.00065
R7198 VDD.n1237 VDD.n1234 0.00065
R7199 VDD.n1854 VDD.n1853 0.00065
R7200 VDD.n1850 VDD.n1849 0.00065
R7201 VDD.n1232 VDD.n1229 0.00065
R7202 VDD.n1884 VDD.n1858 0.00065
R7203 VDD.n1860 VDD.n1859 0.00065
R7204 VDD.n1865 VDD.n1864 0.00065
R7205 VDD.n1879 VDD.n1866 0.00065
R7206 VDD.n1871 VDD.n1868 0.00065
R7207 VDD.n1876 VDD.n1875 0.00065
R7208 VDD.n2525 VDD.n2524 0.00065
R7209 VDD.n2521 VDD.n2520 0.00065
R7210 VDD.n782 VDD.n779 0.00065
R7211 VDD.n2537 VDD.n2536 0.00065
R7212 VDD.n2533 VDD.n2532 0.00065
R7213 VDD.n777 VDD.n774 0.00065
R7214 VDD.n2567 VDD.n2541 0.00065
R7215 VDD.n2543 VDD.n2542 0.00065
R7216 VDD.n2548 VDD.n2547 0.00065
R7217 VDD.n2562 VDD.n2549 0.00065
R7218 VDD.n2554 VDD.n2551 0.00065
R7219 VDD.n2559 VDD.n2558 0.00065
R7220 VDD.n3030 VDD.n3029 0.00065
R7221 VDD.n3026 VDD.n3025 0.00065
R7222 VDD.n668 VDD.n665 0.00065
R7223 VDD.n3747 VDD.n3034 0.00065
R7224 VDD.n3739 VDD.n3035 0.00065
R7225 VDD.n3742 VDD.n3740 0.00065
R7226 VDD.n3736 VDD.n3036 0.00065
R7227 VDD.n3728 VDD.n3038 0.00065
R7228 VDD.n3733 VDD.n3732 0.00065
R7229 VDD.n3296 VDD.n3285 0.00065
R7230 VDD.n3287 VDD.n3286 0.00065
R7231 VDD.n3290 VDD.n3289 0.00065
R7232 VDD.n3492 VDD.n3491 0.00065
R7233 VDD.n3488 VDD.n3487 0.00065
R7234 VDD.n3270 VDD.n3267 0.00065
R7235 VDD.n3507 VDD.n3496 0.00065
R7236 VDD.n3498 VDD.n3497 0.00065
R7237 VDD.n3503 VDD.n3502 0.00065
R7238 VDD.n1968 VDD.n1967 0.0006
R7239 VDD.n2309 VDD.n1960 0.0006
R7240 VDD.n3828 VDD.n608 0.0006
R7241 VDD.n3826 VDD.n3825 0.0006
R7242 VDD.n3135 VDD.n3134 0.0006
R7243 VDD.n3848 VDD.n598 0.0006
R7244 VDD.n3850 VDD.n3849 0.0006
R7245 VDD.n3863 VDD.n523 0.0006
R7246 VDD.n3585 VDD.n3584 0.0006
R7247 VDD.n3610 VDD.n3550 0.0006
R7248 VDD.n3633 VDD.n3224 0.0006
R7249 VDD.n3631 VDD.n3630 0.0006
R7250 VDD.n3389 VDD.n3388 0.0006
R7251 VDD.n3414 VDD.n3383 0.0006
R7252 VDD.n3936 VDD.n168 0.0006
R7253 VDD.n3934 VDD.n3933 0.0006
R7254 VDD.n2637 VDD.n170 0.0006
R7255 VDD.n2928 VDD.n2636 0.0006
R7256 VDD.n3802 VDD.n620 0.0006
R7257 VDD.n3800 VDD.n3799 0.0006
R7258 VDD.n445 VDD.n444 0.0006
R7259 VDD.n3956 VDD.n159 0.0006
R7260 VDD.n3958 VDD.n3957 0.0006
R7261 VDD.n3968 VDD.n145 0.0006
R7262 VDD.n3153 VDD.n3152 0.0006
R7263 VDD.n3121 VDD.n505 0.0006
R7264 VDD.n3884 VDD.n3883 0.0006
R7265 VDD.n3880 VDD.n507 0.0006
R7266 VDD.n4165 VDD.n4164 0.0006
R7267 VDD.n4161 VDD.n19 0.0006
R7268 VDD.n2893 VDD.n2892 0.0006
R7269 VDD.n2905 VDD.n2874 0.0006
R7270 VDD.n2911 VDD.n2906 0.0006
R7271 VDD.n2873 VDD.n2872 0.0006
R7272 VDD.n3907 VDD.n3906 0.0006
R7273 VDD.n3903 VDD.n489 0.0006
R7274 VDD.n3902 VDD.n493 0.0006
R7275 VDD.n3899 VDD.n3898 0.0006
R7276 VDD.n3191 VDD.n3190 0.0006
R7277 VDD.n3660 VDD.n3065 0.0006
R7278 a_45880_2844.n0 a_45880_2844.t11 16.5211
R7279 a_45880_2844.n17 a_45880_2844.n15 16.4359
R7280 a_45880_2844.n1 a_45880_2844.n0 16.3379
R7281 a_45880_2844.n2 a_45880_2844.n1 16.3379
R7282 a_45880_2844.n3 a_45880_2844.n2 16.3379
R7283 a_45880_2844.n61 a_45880_2844.n60 12.1434
R7284 a_45880_2844.n51 a_45880_2844.n50 9.26837
R7285 a_45880_2844.n50 a_45880_2844.n40 9.22068
R7286 a_45880_2844.n57 a_45880_2844.t63 8.7356
R7287 a_45880_2844.n61 a_45880_2844.n21 8.70445
R7288 a_45880_2844.n24 a_45880_2844.n22 8.65111
R7289 a_45880_2844.n26 a_45880_2844.n24 8.5811
R7290 a_45880_2844.n59 a_45880_2844.n58 8.5811
R7291 a_45880_2844.n28 a_45880_2844.n26 8.57988
R7292 a_45880_2844.n30 a_45880_2844.n28 8.57988
R7293 a_45880_2844.n32 a_45880_2844.n30 8.57988
R7294 a_45880_2844.n34 a_45880_2844.n32 8.57988
R7295 a_45880_2844.n36 a_45880_2844.n34 8.57988
R7296 a_45880_2844.n38 a_45880_2844.n36 8.57988
R7297 a_45880_2844.n40 a_45880_2844.n38 8.57988
R7298 a_45880_2844.n52 a_45880_2844.n51 8.57988
R7299 a_45880_2844.n53 a_45880_2844.n52 8.57988
R7300 a_45880_2844.n54 a_45880_2844.n53 8.57988
R7301 a_45880_2844.n55 a_45880_2844.n54 8.57988
R7302 a_45880_2844.n56 a_45880_2844.n55 8.57988
R7303 a_45880_2844.n58 a_45880_2844.n57 8.57988
R7304 a_45880_2844.n41 a_45880_2844.t50 8.42485
R7305 a_45880_2844.n42 a_45880_2844.n41 8.27035
R7306 a_45880_2844.n43 a_45880_2844.n42 8.26914
R7307 a_45880_2844.n44 a_45880_2844.n43 8.26914
R7308 a_45880_2844.n45 a_45880_2844.n44 8.26914
R7309 a_45880_2844.n46 a_45880_2844.n45 8.26914
R7310 a_45880_2844.n47 a_45880_2844.n46 8.26914
R7311 a_45880_2844.n48 a_45880_2844.n47 8.26914
R7312 a_45880_2844.n49 a_45880_2844.n48 8.26914
R7313 a_45880_2844.n19 a_45880_2844.n17 7.84718
R7314 a_45880_2844.n50 a_45880_2844.n49 7.81455
R7315 a_45880_2844.n20 a_45880_2844.n19 7.66561
R7316 a_45880_2844.n9 a_45880_2844.t42 7.53086
R7317 a_45880_2844.n4 a_45880_2844.t15 7.53086
R7318 a_45880_2844.n64 a_45880_2844.t4 7.53086
R7319 a_45880_2844.n10 a_45880_2844.n9 7.34766
R7320 a_45880_2844.n5 a_45880_2844.n4 7.34766
R7321 a_45880_2844.n65 a_45880_2844.n63 7.34766
R7322 a_45880_2844.n65 a_45880_2844.n64 7.34766
R7323 a_45880_2844.n11 a_45880_2844.n10 7.30237
R7324 a_45880_2844.n6 a_45880_2844.n5 7.30237
R7325 a_45880_2844.n12 a_45880_2844.n11 7.25708
R7326 a_45880_2844.n7 a_45880_2844.n6 7.25708
R7327 a_45880_2844.n19 a_45880_2844.n18 7.09966
R7328 a_45880_2844.n14 a_45880_2844.n13 7.05721
R7329 a_45880_2844.n18 a_45880_2844.t6 7.03646
R7330 a_45880_2844.n63 a_45880_2844.n62 6.85858
R7331 a_45880_2844.n8 a_45880_2844.n3 6.68774
R7332 a_45880_2844.n21 a_45880_2844.t7 6.38966
R7333 a_45880_2844.n13 a_45880_2844.n12 6.11115
R7334 a_45880_2844.n8 a_45880_2844.n7 6.11115
R7335 a_45880_2844.n60 a_45880_2844.n59 4.88988
R7336 a_45880_2844.n62 a_45880_2844.n61 4.5005
R7337 a_45880_2844.n60 a_45880_2844.n56 3.6905
R7338 a_45880_2844.n13 a_45880_2844.n8 0.926553
R7339 a_45880_2844.n21 a_45880_2844.n20 0.728183
R7340 a_45880_2844.n62 a_45880_2844.n14 0.489579
R7341 a_45880_2844.n20 a_45880_2844.t8 0.186113
R7342 a_45880_2844.n18 a_45880_2844.t5 0.186113
R7343 a_45880_2844.n63 a_45880_2844.t3 0.183695
R7344 a_45880_2844.n14 a_45880_2844.t1 0.183695
R7345 a_45880_2844.n3 a_45880_2844.t10 0.183695
R7346 a_45880_2844.n2 a_45880_2844.t13 0.183695
R7347 a_45880_2844.n1 a_45880_2844.t19 0.183695
R7348 a_45880_2844.n0 a_45880_2844.t9 0.183695
R7349 a_45880_2844.n12 a_45880_2844.t44 0.183695
R7350 a_45880_2844.n11 a_45880_2844.t41 0.183695
R7351 a_45880_2844.n10 a_45880_2844.t43 0.183695
R7352 a_45880_2844.n9 a_45880_2844.t40 0.183695
R7353 a_45880_2844.n7 a_45880_2844.t16 0.183695
R7354 a_45880_2844.n6 a_45880_2844.t18 0.183695
R7355 a_45880_2844.n5 a_45880_2844.t14 0.183695
R7356 a_45880_2844.n4 a_45880_2844.t17 0.183695
R7357 a_45880_2844.n64 a_45880_2844.t2 0.183695
R7358 a_45880_2844.t0 a_45880_2844.n65 0.183695
R7359 a_45880_2844.n56 a_45880_2844.t56 0.156216
R7360 a_45880_2844.n55 a_45880_2844.t61 0.156216
R7361 a_45880_2844.n54 a_45880_2844.t62 0.156216
R7362 a_45880_2844.n53 a_45880_2844.t59 0.156216
R7363 a_45880_2844.n52 a_45880_2844.t57 0.156216
R7364 a_45880_2844.n51 a_45880_2844.t60 0.156216
R7365 a_45880_2844.n49 a_45880_2844.t47 0.156216
R7366 a_45880_2844.n48 a_45880_2844.t52 0.156216
R7367 a_45880_2844.n47 a_45880_2844.t46 0.156216
R7368 a_45880_2844.n46 a_45880_2844.t12 0.156216
R7369 a_45880_2844.n45 a_45880_2844.t48 0.156216
R7370 a_45880_2844.n44 a_45880_2844.t51 0.156216
R7371 a_45880_2844.n43 a_45880_2844.t45 0.156216
R7372 a_45880_2844.n42 a_45880_2844.t53 0.156216
R7373 a_45880_2844.n41 a_45880_2844.t49 0.156216
R7374 a_45880_2844.n59 a_45880_2844.t58 0.156216
R7375 a_45880_2844.n58 a_45880_2844.t55 0.156216
R7376 a_45880_2844.n57 a_45880_2844.t54 0.156216
R7377 a_45880_2844.n17 a_45880_2844.n16 0.102113
R7378 a_45880_2844.n24 a_45880_2844.n23 0.0717329
R7379 a_45880_2844.n26 a_45880_2844.n25 0.0717329
R7380 a_45880_2844.n28 a_45880_2844.n27 0.0717329
R7381 a_45880_2844.n30 a_45880_2844.n29 0.0717329
R7382 a_45880_2844.n32 a_45880_2844.n31 0.0717329
R7383 a_45880_2844.n34 a_45880_2844.n33 0.0717329
R7384 a_45880_2844.n36 a_45880_2844.n35 0.0717329
R7385 a_45880_2844.n38 a_45880_2844.n37 0.0717329
R7386 a_45880_2844.n40 a_45880_2844.n39 0.0717329
R7387 a_45880_2844.n16 a_45880_2844.t64 0.0551
R7388 a_45880_2844.n16 a_45880_2844.t66 0.0551
R7389 a_45880_2844.n15 a_45880_2844.t65 0.0551
R7390 a_45880_2844.n15 a_45880_2844.t67 0.0551
R7391 a_45880_2844.n39 a_45880_2844.t27 0.0527989
R7392 a_45880_2844.n39 a_45880_2844.t37 0.0527989
R7393 a_45880_2844.n37 a_45880_2844.t32 0.0527989
R7394 a_45880_2844.n37 a_45880_2844.t23 0.0527989
R7395 a_45880_2844.n35 a_45880_2844.t29 0.0527989
R7396 a_45880_2844.n35 a_45880_2844.t39 0.0527989
R7397 a_45880_2844.n33 a_45880_2844.t25 0.0527989
R7398 a_45880_2844.n33 a_45880_2844.t34 0.0527989
R7399 a_45880_2844.n31 a_45880_2844.t26 0.0527989
R7400 a_45880_2844.n31 a_45880_2844.t35 0.0527989
R7401 a_45880_2844.n29 a_45880_2844.t33 0.0527989
R7402 a_45880_2844.n29 a_45880_2844.t24 0.0527989
R7403 a_45880_2844.n27 a_45880_2844.t30 0.0527989
R7404 a_45880_2844.n27 a_45880_2844.t20 0.0527989
R7405 a_45880_2844.n25 a_45880_2844.t31 0.0527989
R7406 a_45880_2844.n25 a_45880_2844.t21 0.0527989
R7407 a_45880_2844.n23 a_45880_2844.t38 0.0527989
R7408 a_45880_2844.n23 a_45880_2844.t28 0.0527989
R7409 a_45880_2844.n22 a_45880_2844.t36 0.0527989
R7410 a_45880_2844.n22 a_45880_2844.t22 0.0527989
R7411 transmission_gate$2$1_3.out.n20 transmission_gate$2$1_3.out.n19 102.212
R7412 transmission_gate$2$1_3.out.n11 transmission_gate$2$1_3.out.t9 30.5838
R7413 transmission_gate$2$1_3.out.n9 transmission_gate$2$1_3.out.t10 30.5802
R7414 transmission_gate$2$1_3.out transmission_gate$2$1_3.out.t5 30.4906
R7415 transmission_gate$2$1_3.out transmission_gate$2$1_3.out.t13 25.0251
R7416 transmission_gate$2$1_3.out transmission_gate$2$1_3.out.t12 25.0251
R7417 transmission_gate$2$1_3.out.n2 transmission_gate$2$1_3.out.t8 25.0227
R7418 transmission_gate$2$1_3.out.n3 transmission_gate$2$1_3.out.t16 24.9469
R7419 transmission_gate$2$1_3.out.n16 transmission_gate$2$1_3.out.t7 24.9469
R7420 transmission_gate$2$1_3.out.n14 transmission_gate$2$1_3.out.t11 24.9469
R7421 transmission_gate$2$1_3.out.n10 transmission_gate$2$1_3.out.t6 24.9469
R7422 transmission_gate$2$1_3.out.n8 transmission_gate$2$1_3.out.t17 24.9469
R7423 transmission_gate$2$1_3.out.n5 transmission_gate$2$1_3.out.t14 24.9469
R7424 transmission_gate$2$1_3.out.n21 transmission_gate$2$1_3.out.t15 24.9469
R7425 transmission_gate$2$1_3.out.n0 transmission_gate$2$1_3.out.t2 17.5462
R7426 transmission_gate$2$1_3.out.n1 transmission_gate$2$1_3.out.t4 16.7838
R7427 transmission_gate$2$1_3.out.n0 transmission_gate$2$1_3.out.t1 16.7833
R7428 transmission_gate$2$1_3.out.n7 transmission_gate$2$1_3.out.n6 15.7198
R7429 transmission_gate$2$1_3.out transmission_gate$2$1_3.out.t3 12.5567
R7430 transmission_gate$2$1_3.out.n24 transmission_gate$2$1_3.out.t0 12.0263
R7431 transmission_gate$2$1_3.out.n18 transmission_gate$2$1_3.out.n17 11.2777
R7432 transmission_gate$2$1_3.out.n18 transmission_gate$2$1_3.out.n15 11.1428
R7433 transmission_gate$2$1_3.out.n4 transmission_gate$2$1_3.out 10.455
R7434 transmission_gate$2$1_3.out.n12 transmission_gate$2$1_3.out.n11 6.32655
R7435 transmission_gate$2$1_3.out.n12 transmission_gate$2$1_3.out.n9 6.20103
R7436 transmission_gate$2$1_3.out transmission_gate$2$1_3.out.n3 6.06552
R7437 transmission_gate$2$1_3.out.n23 transmission_gate$2$1_3.out 5.58854
R7438 transmission_gate$2$1_3.out.n22 transmission_gate$2$1_3.out.n21 5.3648
R7439 transmission_gate$2$1_3.out transmission_gate$2$1_3.out.n2 5.12246
R7440 transmission_gate$2$1_3.out transmission_gate$2$1_3.out.n10 4.9055
R7441 transmission_gate$2$1_3.out transmission_gate$2$1_3.out.n8 4.9055
R7442 transmission_gate$2$1_3.out.n19 transmission_gate$2$1_3.out.n18 4.50524
R7443 transmission_gate$2$1_3.out.n13 transmission_gate$2$1_3.out.n12 4.5005
R7444 transmission_gate$2$1_3.out.n23 transmission_gate$2$1_3.out.n22 4.5005
R7445 transmission_gate$2$1_3.out.n19 transmission_gate$2$1_3.out.n13 3.55905
R7446 transmission_gate$2$1_3.out.n13 transmission_gate$2$1_3.out.n7 3.28432
R7447 transmission_gate$2$1_3.out.n24 transmission_gate$2$1_3.out.n23 1.24764
R7448 transmission_gate$2$1_3.out.n7 transmission_gate$2$1_3.out 0.977474
R7449 transmission_gate$2$1_3.out transmission_gate$2$1_3.out.n1 0.947107
R7450 transmission_gate$2$1_3.out.n1 transmission_gate$2$1_3.out 0.424786
R7451 transmission_gate$2$1_3.out transmission_gate$2$1_3.out.n24 0.2411
R7452 transmission_gate$2$1_3.out transmission_gate$2$1_3.out.n0 0.140321
R7453 transmission_gate$2$1_3.out.n9 transmission_gate$2$1_3.out 0.1355
R7454 transmission_gate$2$1_3.out.n11 transmission_gate$2$1_3.out 0.131947
R7455 transmission_gate$2$1_3.out.n3 transmission_gate$2$1_3.out 0.0751053
R7456 transmission_gate$2$1_3.out.n21 transmission_gate$2$1_3.out 0.0751053
R7457 transmission_gate$2$1_3.out.n22 transmission_gate$2$1_3.out 0.0712143
R7458 transmission_gate$2$1_3.out transmission_gate$2$1_3.out.n20 0.0696071
R7459 transmission_gate$2$1_3.out.n20 transmission_gate$2$1_3.out.n4 0.0278214
R7460 transmission_gate$2$1_3.out.n2 transmission_gate$2$1_3.out 0.00878947
R7461 transmission_gate$2$1_3.out.n16 transmission_gate$2$1_3.out 0.00760526
R7462 transmission_gate$2$1_3.out.n10 transmission_gate$2$1_3.out 0.00760526
R7463 transmission_gate$2$1_3.out.n8 transmission_gate$2$1_3.out 0.00760526
R7464 transmission_gate$2$1_3.out.n15 transmission_gate$2$1_3.out 0.00642105
R7465 transmission_gate$2$1_3.out.n6 transmission_gate$2$1_3.out 0.00642105
R7466 transmission_gate$2$1_3.out.n14 transmission_gate$2$1_3.out 0.00405263
R7467 transmission_gate$2$1_3.out.n5 transmission_gate$2$1_3.out 0.00405263
R7468 transmission_gate$2$1_3.out.n4 transmission_gate$2$1_3.out 0.00371429
R7469 transmission_gate$2$1_3.out.n17 transmission_gate$2$1_3.out.n16 0.00286842
R7470 transmission_gate$2$1_3.out.n17 transmission_gate$2$1_3.out 0.00168421
R7471 transmission_gate$2$1_3.out.n15 transmission_gate$2$1_3.out.n14 0.00168421
R7472 transmission_gate$2$1_3.out.n6 transmission_gate$2$1_3.out.n5 0.00168421
R7473 transmission_gate$2$1_4.out transmission_gate$2$1_4.out.t7 30.4906
R7474 transmission_gate$2$1_4.out transmission_gate$2$1_4.out.t16 30.2901
R7475 transmission_gate$2$1_4.out transmission_gate$2$1_4.out.t13 30.2223
R7476 transmission_gate$2$1_4.out transmission_gate$2$1_4.out.t19 30.2223
R7477 transmission_gate$2$1_4.out.n17 transmission_gate$2$1_4.out.t14 29.9396
R7478 transmission_gate$2$1_4.out transmission_gate$2$1_4.out.t22 25.0251
R7479 transmission_gate$2$1_4.out transmission_gate$2$1_4.out.t18 25.0251
R7480 transmission_gate$2$1_4.out.n2 transmission_gate$2$1_4.out.t9 25.0227
R7481 transmission_gate$2$1_4.out.n3 transmission_gate$2$1_4.out.t6 24.9469
R7482 transmission_gate$2$1_4.out.n30 transmission_gate$2$1_4.out.t21 24.9469
R7483 transmission_gate$2$1_4.out.n20 transmission_gate$2$1_4.out.t11 24.9469
R7484 transmission_gate$2$1_4.out.n22 transmission_gate$2$1_4.out.t20 24.9469
R7485 transmission_gate$2$1_4.out.n25 transmission_gate$2$1_4.out.t17 24.9469
R7486 transmission_gate$2$1_4.out.n18 transmission_gate$2$1_4.out.t12 24.9469
R7487 transmission_gate$2$1_4.out.n14 transmission_gate$2$1_4.out.t23 24.9469
R7488 transmission_gate$2$1_4.out.n12 transmission_gate$2$1_4.out.t8 24.9469
R7489 transmission_gate$2$1_4.out.n9 transmission_gate$2$1_4.out.t5 24.9469
R7490 transmission_gate$2$1_4.out.n6 transmission_gate$2$1_4.out.t15 24.9469
R7491 transmission_gate$2$1_4.out.n5 transmission_gate$2$1_4.out.t10 24.9469
R7492 transmission_gate$2$1_4.out.n0 transmission_gate$2$1_4.out.t1 17.5462
R7493 transmission_gate$2$1_4.out.n1 transmission_gate$2$1_4.out.t4 16.7838
R7494 transmission_gate$2$1_4.out.n0 transmission_gate$2$1_4.out.t2 16.7833
R7495 transmission_gate$2$1_4.out.n24 transmission_gate$2$1_4.out.n21 13.5427
R7496 transmission_gate$2$1_4.out.n29 transmission_gate$2$1_4.out.n28 12.8086
R7497 transmission_gate$2$1_4.out transmission_gate$2$1_4.out.t3 12.5567
R7498 transmission_gate$2$1_4.out.n33 transmission_gate$2$1_4.out.t0 12.0263
R7499 transmission_gate$2$1_4.out.n4 transmission_gate$2$1_4.out 10.455
R7500 transmission_gate$2$1_4.out.n28 transmission_gate$2$1_4.out.n19 10.1105
R7501 transmission_gate$2$1_4.out.n27 transmission_gate$2$1_4.out.n26 9.788
R7502 transmission_gate$2$1_4.out.n24 transmission_gate$2$1_4.out.n23 9.61881
R7503 transmission_gate$2$1_4.out.n8 transmission_gate$2$1_4.out.n5 7.34425
R7504 transmission_gate$2$1_4.out transmission_gate$2$1_4.out.n3 6.06552
R7505 transmission_gate$2$1_4.out.n32 transmission_gate$2$1_4.out 5.58854
R7506 transmission_gate$2$1_4.out transmission_gate$2$1_4.out.n30 5.29088
R7507 transmission_gate$2$1_4.out transmission_gate$2$1_4.out.n2 5.12246
R7508 transmission_gate$2$1_4.out.n26 transmission_gate$2$1_4.out.n25 4.73142
R7509 transmission_gate$2$1_4.out.n23 transmission_gate$2$1_4.out.n22 4.71925
R7510 transmission_gate$2$1_4.out.n19 transmission_gate$2$1_4.out.n18 4.71011
R7511 transmission_gate$2$1_4.out.n21 transmission_gate$2$1_4.out.n20 4.6755
R7512 transmission_gate$2$1_4.out.n8 transmission_gate$2$1_4.out.n7 4.5005
R7513 transmission_gate$2$1_4.out.n11 transmission_gate$2$1_4.out.n10 4.5005
R7514 transmission_gate$2$1_4.out.n13 transmission_gate$2$1_4.out.n12 4.5005
R7515 transmission_gate$2$1_4.out.n16 transmission_gate$2$1_4.out.n15 4.5005
R7516 transmission_gate$2$1_4.out.n32 transmission_gate$2$1_4.out.n31 4.5005
R7517 transmission_gate$2$1_4.out.n27 transmission_gate$2$1_4.out.n24 3.7843
R7518 transmission_gate$2$1_4.out.n28 transmission_gate$2$1_4.out.n27 3.37994
R7519 transmission_gate$2$1_4.out.n16 transmission_gate$2$1_4.out.n13 2.8455
R7520 transmission_gate$2$1_4.out.n11 transmission_gate$2$1_4.out.n8 2.84425
R7521 transmission_gate$2$1_4.out.n13 transmission_gate$2$1_4.out.n11 2.8405
R7522 transmission_gate$2$1_4.out.n17 transmission_gate$2$1_4.out 1.96793
R7523 transmission_gate$2$1_4.out.n33 transmission_gate$2$1_4.out.n32 1.24764
R7524 transmission_gate$2$1_4.out transmission_gate$2$1_4.out.n1 0.947107
R7525 transmission_gate$2$1_4.out.n21 transmission_gate$2$1_4.out 0.643
R7526 transmission_gate$2$1_4.out.n23 transmission_gate$2$1_4.out 0.59925
R7527 transmission_gate$2$1_4.out.n19 transmission_gate$2$1_4.out 0.487211
R7528 transmission_gate$2$1_4.out.n26 transmission_gate$2$1_4.out 0.465895
R7529 transmission_gate$2$1_4.out.n1 transmission_gate$2$1_4.out 0.424786
R7530 transmission_gate$2$1_4.out transmission_gate$2$1_4.out.n17 0.351026
R7531 transmission_gate$2$1_4.out transmission_gate$2$1_4.out.n33 0.2411
R7532 transmission_gate$2$1_4.out transmission_gate$2$1_4.out.n16 0.20175
R7533 transmission_gate$2$1_4.out transmission_gate$2$1_4.out.n0 0.140321
R7534 transmission_gate$2$1_4.out.n29 transmission_gate$2$1_4.out.n4 0.114607
R7535 transmission_gate$2$1_4.out.n3 transmission_gate$2$1_4.out 0.0751053
R7536 transmission_gate$2$1_4.out.n30 transmission_gate$2$1_4.out 0.0751053
R7537 transmission_gate$2$1_4.out.n31 transmission_gate$2$1_4.out 0.0744286
R7538 transmission_gate$2$1_4.out.n31 transmission_gate$2$1_4.out.n29 0.0535357
R7539 transmission_gate$2$1_4.out.n5 transmission_gate$2$1_4.out 0.0206316
R7540 transmission_gate$2$1_4.out.n6 transmission_gate$2$1_4.out 0.0158947
R7541 transmission_gate$2$1_4.out.n10 transmission_gate$2$1_4.out 0.0147105
R7542 transmission_gate$2$1_4.out.n12 transmission_gate$2$1_4.out 0.0123421
R7543 transmission_gate$2$1_4.out.n15 transmission_gate$2$1_4.out 0.00997368
R7544 transmission_gate$2$1_4.out.n2 transmission_gate$2$1_4.out 0.00878947
R7545 transmission_gate$2$1_4.out.n20 transmission_gate$2$1_4.out 0.00760526
R7546 transmission_gate$2$1_4.out.n22 transmission_gate$2$1_4.out 0.00760526
R7547 transmission_gate$2$1_4.out.n25 transmission_gate$2$1_4.out 0.00760526
R7548 transmission_gate$2$1_4.out.n18 transmission_gate$2$1_4.out 0.00760526
R7549 transmission_gate$2$1_4.out.n14 transmission_gate$2$1_4.out 0.00760526
R7550 transmission_gate$2$1_4.out.n12 transmission_gate$2$1_4.out 0.00760526
R7551 transmission_gate$2$1_4.out.n9 transmission_gate$2$1_4.out 0.00760526
R7552 transmission_gate$2$1_4.out.n5 transmission_gate$2$1_4.out 0.00760526
R7553 transmission_gate$2$1_4.out.n7 transmission_gate$2$1_4.out 0.00642105
R7554 transmission_gate$2$1_4.out.n4 transmission_gate$2$1_4.out 0.00371429
R7555 transmission_gate$2$1_4.out.n15 transmission_gate$2$1_4.out.n14 0.00286842
R7556 transmission_gate$2$1_4.out.n10 transmission_gate$2$1_4.out.n9 0.00168421
R7557 transmission_gate$2$1_4.out.n7 transmission_gate$2$1_4.out.n6 0.00168421
R7558 INN_TELESCOPIC.n3 INN_TELESCOPIC.t4 234.008
R7559 INN_TELESCOPIC.n1 INN_TELESCOPIC.t1 12.5195
R7560 INN_TELESCOPIC.n0 INN_TELESCOPIC.t3 12.5185
R7561 INN_TELESCOPIC INN_TELESCOPIC.t0 12.2496
R7562 INN_TELESCOPIC INN_TELESCOPIC.t2 12.2496
R7563 INN_TELESCOPIC.n27 INN_TELESCOPIC.n15 8.36915
R7564 INN_TELESCOPIC.n30 INN_TELESCOPIC.n29 8.18418
R7565 INN_TELESCOPIC.n30 INN_TELESCOPIC.n3 8.0105
R7566 INN_TELESCOPIC INN_TELESCOPIC.n2 5.00142
R7567 INN_TELESCOPIC.n2 INN_TELESCOPIC.n0 4.799
R7568 INN_TELESCOPIC.n2 INN_TELESCOPIC.n1 4.7675
R7569 INN_TELESCOPIC.n18 INN_TELESCOPIC.n16 4.51471
R7570 INN_TELESCOPIC.n15 INN_TELESCOPIC.n14 4.50104
R7571 INN_TELESCOPIC.n12 INN_TELESCOPIC.n9 4.50073
R7572 INN_TELESCOPIC.n25 INN_TELESCOPIC.n17 4.50064
R7573 INN_TELESCOPIC.n29 INN_TELESCOPIC.n28 4.5005
R7574 INN_TELESCOPIC.n23 INN_TELESCOPIC.n4 4.5005
R7575 INN_TELESCOPIC.n19 INN_TELESCOPIC.n18 4.5005
R7576 INN_TELESCOPIC.n20 INN_TELESCOPIC.n5 4.5005
R7577 INN_TELESCOPIC.n22 INN_TELESCOPIC.n21 4.5005
R7578 INN_TELESCOPIC.n27 INN_TELESCOPIC.n26 4.5005
R7579 INN_TELESCOPIC.n25 INN_TELESCOPIC.n24 4.5005
R7580 INN_TELESCOPIC.n10 INN_TELESCOPIC.n8 4.5005
R7581 INN_TELESCOPIC.n7 INN_TELESCOPIC.n6 4.5005
R7582 INN_TELESCOPIC.n12 INN_TELESCOPIC.n11 4.5005
R7583 INN_TELESCOPIC.n14 INN_TELESCOPIC.n13 4.5005
R7584 INN_TELESCOPIC.n3 INN_TELESCOPIC 0.259842
R7585 INN_TELESCOPIC.n9 INN_TELESCOPIC 0.0534518
R7586 INN_TELESCOPIC.n13 INN_TELESCOPIC.n8 0.0501241
R7587 INN_TELESCOPIC.n24 INN_TELESCOPIC.n5 0.0372669
R7588 INN_TELESCOPIC INN_TELESCOPIC.n30 0.0301053
R7589 INN_TELESCOPIC.n22 INN_TELESCOPIC.n17 0.0280188
R7590 INN_TELESCOPIC.n14 INN_TELESCOPIC.n7 0.0211024
R7591 INN_TELESCOPIC.n11 INN_TELESCOPIC.n10 0.0203795
R7592 INN_TELESCOPIC.n20 INN_TELESCOPIC.n19 0.0174462
R7593 INN_TELESCOPIC.n26 INN_TELESCOPIC.n16 0.0167342
R7594 INN_TELESCOPIC.n23 INN_TELESCOPIC.n22 0.0147105
R7595 INN_TELESCOPIC.n28 INN_TELESCOPIC.n5 0.0147105
R7596 INN_TELESCOPIC.n0 INN_TELESCOPIC 0.0091747
R7597 INN_TELESCOPIC.n1 INN_TELESCOPIC 0.00809036
R7598 INN_TELESCOPIC.n18 INN_TELESCOPIC.n17 0.00117669
R7599 INN_TELESCOPIC.n24 INN_TELESCOPIC.n23 0.00117669
R7600 INN_TELESCOPIC.n28 INN_TELESCOPIC.n27 0.00117669
R7601 INN_TELESCOPIC.n29 INN_TELESCOPIC.n4 0.00106962
R7602 INN_TELESCOPIC.n21 INN_TELESCOPIC.n20 0.00106962
R7603 INN_TELESCOPIC.n26 INN_TELESCOPIC.n25 0.00106962
R7604 INN_TELESCOPIC.n10 INN_TELESCOPIC.n9 0.00104217
R7605 INN_TELESCOPIC.n11 INN_TELESCOPIC.n7 0.00104217
R7606 INN_TELESCOPIC.n15 INN_TELESCOPIC.n6 0.000725564
R7607 INN_TELESCOPIC.n8 INN_TELESCOPIC.n6 0.000725564
R7608 INN_TELESCOPIC.n13 INN_TELESCOPIC.n12 0.000725564
R7609 INN_TELESCOPIC.n19 INN_TELESCOPIC.n4 0.000642405
R7610 INN_TELESCOPIC.n21 INN_TELESCOPIC.n16 0.000642405
R7611 VSS.n2163 VSS.n1847 2.17298e+07
R7612 VSS.n1883 VSS.n252 9.607e+06
R7613 VSS.n3958 VSS.n3957 9.58815e+06
R7614 VSS.n3548 VSS.n231 9.02525e+06
R7615 VSS.n2164 VSS.n2163 8.99925e+06
R7616 VSS.n2092 VSS.n1812 8.31025e+06
R7617 VSS.n2165 VSS.n1814 8.31025e+06
R7618 VSS.n3581 VSS.n3580 7.39201e+06
R7619 VSS.n252 VSS.n209 7.3905e+06
R7620 VSS.n3582 VSS.n3581 6.552e+06
R7621 VSS.t45 VSS.n19 5.5705e+06
R7622 VSS.n2092 VSS.n1814 4.641e+06
R7623 VSS.n3933 VSS.n42 2.50523e+06
R7624 VSS.n2168 VSS.n38 1.99977e+06
R7625 VSS.n2170 VSS.n2169 1.99745e+06
R7626 VSS.n2165 VSS.n2164 1.77242e+06
R7627 VSS.n3972 VSS.n19 1.6493e+06
R7628 VSS.n3932 VSS.n43 1.28507e+06
R7629 VSS.n2172 VSS.n1811 1.22752e+06
R7630 VSS.n2169 VSS.n1811 1.10338e+06
R7631 VSS.n1813 VSS.n1812 1.10289e+06
R7632 VSS.n2171 VSS.n1812 1.07753e+06
R7633 VSS.n3582 VSS.n209 838500
R7634 VSS.n2079 VSS.n40 640799
R7635 VSS.n3547 VSS.n232 386081
R7636 VSS.n3555 VSS.n228 382652
R7637 VSS.n228 VSS.n227 376160
R7638 VSS.n3938 VSS.n3937 186383
R7639 VSS.n3944 VSS.n33 185509
R7640 VSS.n3935 VSS.n3934 183996
R7641 VSS.n42 VSS.n41 172862
R7642 VSS.n3956 VSS.n28 171068
R7643 VSS.n3022 VSS.n827 159379
R7644 VSS.n43 VSS.n42 151250
R7645 VSS.n2169 VSS.n2168 147875
R7646 VSS.n1851 VSS.n36 107873
R7647 VSS.n3973 VSS.n3972 55299
R7648 VSS.n2166 VSS.n2165 50192.4
R7649 VSS.n3976 VSS.n3975 45787.3
R7650 VSS.n3971 VSS.t524 42594.4
R7651 VSS.t465 VSS.n36 37079.6
R7652 VSS.n3970 VSS.t24 36702.4
R7653 VSS.n3930 VSS.n51 21265.4
R7654 VSS.n3946 VSS.n32 19294.8
R7655 VSS.n3971 VSS.n20 17910.2
R7656 VSS.n3542 VSS.n3541 12660.6
R7657 VSS.n1884 VSS.t97 12222.5
R7658 VSS.n3281 VSS.t461 11580
R7659 VSS.n3372 VSS.t384 11580
R7660 VSS.n793 VSS.t37 11580
R7661 VSS.t477 VSS.n688 11580
R7662 VSS.n3484 VSS.t488 11580
R7663 VSS.n2049 VSS.t526 11580
R7664 VSS.t26 VSS.n1888 11580
R7665 VSS.n1953 VSS.t140 11580
R7666 VSS.n3934 VSS.n41 11246.2
R7667 VSS.n1954 VSS.n1953 11185
R7668 VSS.n2003 VSS.n1888 11185
R7669 VSS.n2049 VSS.n2048 11185
R7670 VSS.n3484 VSS.n3483 11185
R7671 VSS.n747 VSS.n688 11185
R7672 VSS.n793 VSS.n792 11185
R7673 VSS.n3372 VSS.n3371 11185
R7674 VSS.n3282 VSS.n3281 11185
R7675 VSS.n3307 VSS.t332 11113
R7676 VSS.n3255 VSS.t216 11113
R7677 VSS.n405 VSS.t211 11113
R7678 VSS.n764 VSS.t396 11113
R7679 VSS.n723 VSS.t248 11113
R7680 VSS.n262 VSS.t298 11113
R7681 VSS.n2020 VSS.t337 11113
R7682 VSS.n1979 VSS.t455 11113
R7683 VSS.n1927 VSS.t244 11113
R7684 VSS.n1928 VSS.n1927 10611.5
R7685 VSS.n1980 VSS.n1979 10611.5
R7686 VSS.n2021 VSS.n2020 10611.5
R7687 VSS.n263 VSS.n262 10611.5
R7688 VSS.n724 VSS.n723 10611.5
R7689 VSS.n765 VSS.n764 10611.5
R7690 VSS.n406 VSS.n405 10611.5
R7691 VSS.n3256 VSS.n3255 10611.5
R7692 VSS.n3308 VSS.n3307 10611.5
R7693 VSS.t343 VSS.t195 7930.34
R7694 VSS.t199 VSS.t341 7930.34
R7695 VSS.t207 VSS.t349 7772.48
R7696 VSS.n3973 VSS.n18 7727.42
R7697 VSS.t441 VSS.t261 7719.84
R7698 VSS.t492 VSS.t398 7719.84
R7699 VSS.t220 VSS.t319 7719.84
R7700 VSS.t484 VSS.t275 7719.84
R7701 VSS.t197 VSS.t393 7719.84
R7702 VSS.t121 VSS.t159 7719.84
R7703 VSS.t205 VSS.t317 7719.84
R7704 VSS.t15 VSS.t59 7719.84
R7705 VSS.t469 VSS.t66 7719.84
R7706 VSS.t273 VSS.t231 7719.84
R7707 VSS.t285 VSS.t150 7719.84
R7708 VSS.t325 VSS.t235 7719.84
R7709 VSS.t224 VSS.t209 7719.84
R7710 VSS.t306 VSS.t292 7719.84
R7711 VSS.t226 VSS.t335 7719.84
R7712 VSS.t127 VSS.t131 7719.84
R7713 VSS.t279 VSS.t259 7719.84
R7714 VSS.t401 VSS.t450 7719.84
R7715 VSS.n2628 VSS.n2627 7425.5
R7716 VSS.n826 VSS.n825 7259.31
R7717 VSS.n3328 VSS.t72 6768.86
R7718 VSS.n3540 VSS.n3539 6554.17
R7719 VSS.n2078 VSS.n1853 5971.81
R7720 VSS.n3558 VSS.n227 5921.75
R7721 VSS.n3971 VSS.n3970 5886.59
R7722 VSS.n3518 VSS.n3517 5742.35
R7723 VSS.n2080 VSS.n2079 5686.15
R7724 VSS.t33 VSS.n369 5662.9
R7725 VSS.n827 VSS.t353 5647.83
R7726 VSS.t222 VSS.n3318 5535.43
R7727 VSS.t129 VSS.n3292 5535.43
R7728 VSS.t203 VSS.n3266 5535.43
R7729 VSS.t294 VSS.n3240 5535.43
R7730 VSS.n3385 VSS.t201 5535.43
R7731 VSS.t233 VSS.n781 5535.43
R7732 VSS.n806 VSS.t439 5535.43
R7733 VSS.t229 VSS.n756 5535.43
R7734 VSS.t283 VSS.n734 5535.43
R7735 VSS.t57 VSS.n708 5535.43
R7736 VSS.n3497 VSS.t467 5535.43
R7737 VSS.t157 VSS.n2037 5535.43
R7738 VSS.n2062 VSS.t289 5535.43
R7739 VSS.t277 VSS.n2012 5535.43
R7740 VSS.t473 VSS.n1990 5535.43
R7741 VSS.t494 VSS.n1964 5535.43
R7742 VSS.t218 VSS.n1938 5535.43
R7743 VSS.t452 VSS.n1912 5535.43
R7744 VSS.n3023 VSS.n3022 5286.9
R7745 VSS.n3555 VSS.n3554 5227.44
R7746 VSS.n3547 VSS.n3546 5227.44
R7747 VSS.n3580 VSS.n3579 5202.97
R7748 VSS.n3360 VSS.n3359 5000.83
R7749 VSS.n352 VSS.n228 4992.44
R7750 VSS.n3931 VSS.n3930 4986.21
R7751 VSS.n1857 VSS.n1856 4828.76
R7752 VSS.n3934 VSS.n40 4798.18
R7753 VSS.n352 VSS.n232 4766.23
R7754 VSS.n1884 VSS.n1883 4725.61
R7755 VSS.n1129 VSS.n28 4574.74
R7756 VSS.n3540 VSS.n40 4318.8
R7757 VSS.t437 VSS.n210 4142.26
R7758 VSS.n364 VSS.n227 4069.19
R7759 VSS.n3557 VSS.n3555 3938.88
R7760 VSS.n3957 VSS.t486 3849.6
R7761 VSS.n3937 VSS.n3936 3775.25
R7762 VSS.n3936 VSS.n3935 3775.25
R7763 VSS.n3541 VSS.n3540 3677.33
R7764 VSS.t351 VSS.n210 3635.36
R7765 VSS.n3929 VSS.t528 3607.23
R7766 VSS.n3549 VSS.n3548 3514.92
R7767 VSS.n2078 VSS.n2077 3417.14
R7768 VSS.n3936 VSS.n38 3391.45
R7769 VSS.n1883 VSS.t281 3363.4
R7770 VSS.n3937 VSS.n37 3299.29
R7771 VSS.n3935 VSS.n39 3299.29
R7772 VSS.t305 VSS.t147 3239.24
R7773 VSS.t84 VSS.t301 3239.24
R7774 VSS.t179 VSS.t409 3239.22
R7775 VSS.t522 VSS.t513 3239.22
R7776 VSS.t4 VSS.t372 3223.23
R7777 VSS.t370 VSS.t19 3223.23
R7778 VSS.n50 VSS.t53 3164.27
R7779 VSS.n1931 VSS.t254 3023.46
R7780 VSS.n1932 VSS.t23 3023.46
R7781 VSS.n1957 VSS.t83 3023.46
R7782 VSS.n1958 VSS.t62 3023.46
R7783 VSS.n1983 VSS.t324 3023.46
R7784 VSS.n1984 VSS.t63 3023.46
R7785 VSS.n2005 VSS.t302 3023.46
R7786 VSS.n2004 VSS.t395 3023.46
R7787 VSS.n2024 VSS.t267 3023.46
R7788 VSS.n2056 VSS.t392 3023.46
R7789 VSS.n2045 VSS.t419 3023.46
R7790 VSS.n2044 VSS.t403 3023.46
R7791 VSS.n266 VSS.t433 3023.46
R7792 VSS.n3491 VSS.t41 3023.46
R7793 VSS.n3480 VSS.t310 3023.46
R7794 VSS.n3479 VSS.t327 3023.46
R7795 VSS.n727 VSS.t250 3023.46
R7796 VSS.n728 VSS.t498 3023.46
R7797 VSS.n749 VSS.t368 3023.46
R7798 VSS.n748 VSS.t355 3023.46
R7799 VSS.n768 VSS.t357 3023.46
R7800 VSS.n800 VSS.t44 3023.46
R7801 VSS.n789 VSS.t0 3023.46
R7802 VSS.n788 VSS.t52 3023.46
R7803 VSS.n409 VSS.t272 3023.46
R7804 VSS.n3379 VSS.t431 3023.46
R7805 VSS.n3368 VSS.t407 3023.46
R7806 VSS.n3367 VSS.t114 3023.46
R7807 VSS.n3259 VSS.t533 3023.46
R7808 VSS.n3260 VSS.t6 3023.46
R7809 VSS.n3285 VSS.t517 3023.46
R7810 VSS.n3286 VSS.t454 3023.46
R7811 VSS.n3311 VSS.t331 3023.46
R7812 VSS.n3312 VSS.t136 3023.46
R7813 VSS.n3953 VSS.t499 3023.46
R7814 VSS.n3952 VSS.t258 3023.46
R7815 VSS.n3295 VSS.t268 3015.37
R7816 VSS.n3319 VSS.t530 3015.37
R7817 VSS.n3269 VSS.t501 3015.37
R7818 VSS.n3293 VSS.t328 3015.37
R7819 VSS.n3243 VSS.t91 3015.37
R7820 VSS.n3267 VSS.t515 3015.37
R7821 VSS.n3235 VSS.t7 3015.37
R7822 VSS.n3241 VSS.t534 3015.37
R7823 VSS.n3386 VSS.t152 3015.37
R7824 VSS.t408 VSS.n3231 3015.37
R7825 VSS.t237 VSS.n780 3015.37
R7826 VSS.n782 VSS.t271 3015.37
R7827 VSS.n807 VSS.t263 3015.37
R7828 VSS.t1 VSS.n775 3015.37
R7829 VSS.n737 VSS.t297 3015.37
R7830 VSS.n757 VSS.t358 3015.37
R7831 VSS.n711 VSS.t61 3015.37
R7832 VSS.n735 VSS.t378 3015.37
R7833 VSS.n703 VSS.t296 3015.37
R7834 VSS.n709 VSS.t251 3015.37
R7835 VSS.n3498 VSS.t5 3015.37
R7836 VSS.t309 VSS.n699 3015.37
R7837 VSS.t133 VSS.n2036 3015.37
R7838 VSS.n2038 VSS.t434 3015.37
R7839 VSS.n2063 VSS.t400 3015.37
R7840 VSS.t425 VSS.n2031 3015.37
R7841 VSS.n1993 VSS.t483 3015.37
R7842 VSS.n2013 VSS.t264 3015.37
R7843 VSS.n1967 VSS.t356 3015.37
R7844 VSS.n1991 VSS.t300 3015.37
R7845 VSS.n1941 VSS.t68 3015.37
R7846 VSS.n1965 VSS.t321 3015.37
R7847 VSS.n1915 VSS.t432 3015.37
R7848 VSS.n1939 VSS.t80 3015.37
R7849 VSS.n1907 VSS.t500 3015.37
R7850 VSS.n1913 VSS.t255 3015.37
R7851 VSS.n3541 VSS.n232 2990.86
R7852 VSS.n3929 VSS.n32 2900.27
R7853 VSS.t20 VSS.t369 2847.89
R7854 VSS.t373 VSS.t2 2847.89
R7855 VSS.t39 VSS.n32 2811.05
R7856 VSS.n2629 VSS.t9 2781.87
R7857 VSS.n2077 VSS.n2076 2769.52
R7858 VSS.n3938 VSS.n36 2741.44
R7859 VSS.t448 VSS.n1835 2688.24
R7860 VSS.n3544 VSS.n3542 2611.35
R7861 VSS.n3361 VSS.n3360 2557.41
R7862 VSS.n3842 VSS.n16 2544.56
R7863 VSS.n3957 VSS.n3956 2483.52
R7864 VSS.n2164 VSS.n1846 2372.6
R7865 VSS.n3975 VSS.n15 2344
R7866 VSS.n3841 VSS.n51 2324.65
R7867 VSS.n3976 VSS.n14 2324.65
R7868 VSS.t39 VSS.n2172 2300.56
R7869 VSS.n3022 VSS.n3021 2271.34
R7870 VSS.n2167 VSS.n1813 2218.96
R7871 VSS.n2167 VSS.n2166 2217.88
R7872 VSS.n2171 VSS.n2170 2191.62
R7873 VSS.n1928 VSS.t254 2178.28
R7874 VSS.t261 VSS.n1931 2178.28
R7875 VSS.n1932 VSS.t441 2178.28
R7876 VSS.n1947 VSS.t23 2178.28
R7877 VSS.n1954 VSS.t83 2178.28
R7878 VSS.t398 VSS.n1957 2178.28
R7879 VSS.n1958 VSS.t492 2178.28
R7880 VSS.n1973 VSS.t62 2178.28
R7881 VSS.n1980 VSS.t324 2178.28
R7882 VSS.t319 VSS.n1983 2178.28
R7883 VSS.n1984 VSS.t220 2178.28
R7884 VSS.t63 VSS.n1891 2178.28
R7885 VSS.t302 VSS.n2003 2178.28
R7886 VSS.n2005 VSS.t484 2178.28
R7887 VSS.t275 VSS.n2004 2178.28
R7888 VSS.n2069 VSS.t395 2178.28
R7889 VSS.n2021 VSS.t267 2178.28
R7890 VSS.t393 VSS.n2024 2178.28
R7891 VSS.n2056 VSS.t197 2178.28
R7892 VSS.t392 VSS.n2055 2178.28
R7893 VSS.n2048 VSS.t419 2178.28
R7894 VSS.n2045 VSS.t121 2178.28
R7895 VSS.t159 VSS.n2044 2178.28
R7896 VSS.n3504 VSS.t403 2178.28
R7897 VSS.n263 VSS.t433 2178.28
R7898 VSS.t317 VSS.n266 2178.28
R7899 VSS.n3491 VSS.t205 2178.28
R7900 VSS.t41 VSS.n3490 2178.28
R7901 VSS.n3483 VSS.t310 2178.28
R7902 VSS.n3480 VSS.t15 2178.28
R7903 VSS.t59 VSS.n3479 2178.28
R7904 VSS.n717 VSS.t327 2178.28
R7905 VSS.n724 VSS.t250 2178.28
R7906 VSS.t66 VSS.n727 2178.28
R7907 VSS.n728 VSS.t469 2178.28
R7908 VSS.t498 VSS.n691 2178.28
R7909 VSS.t368 VSS.n747 2178.28
R7910 VSS.n749 VSS.t273 2178.28
R7911 VSS.t231 VSS.n748 2178.28
R7912 VSS.n813 VSS.t355 2178.28
R7913 VSS.n765 VSS.t357 2178.28
R7914 VSS.t150 VSS.n768 2178.28
R7915 VSS.n800 VSS.t285 2178.28
R7916 VSS.t44 VSS.n799 2178.28
R7917 VSS.n792 VSS.t0 2178.28
R7918 VSS.n789 VSS.t325 2178.28
R7919 VSS.t235 VSS.n788 2178.28
R7920 VSS.n3392 VSS.t52 2178.28
R7921 VSS.n406 VSS.t272 2178.28
R7922 VSS.t209 VSS.n409 2178.28
R7923 VSS.n3379 VSS.t224 2178.28
R7924 VSS.t431 VSS.n3378 2178.28
R7925 VSS.n3371 VSS.t407 2178.28
R7926 VSS.n3368 VSS.t306 2178.28
R7927 VSS.t292 VSS.n3367 2178.28
R7928 VSS.n3249 VSS.t114 2178.28
R7929 VSS.n3256 VSS.t533 2178.28
R7930 VSS.t335 VSS.n3259 2178.28
R7931 VSS.n3260 VSS.t226 2178.28
R7932 VSS.n3275 VSS.t6 2178.28
R7933 VSS.n3282 VSS.t517 2178.28
R7934 VSS.t131 VSS.n3285 2178.28
R7935 VSS.n3286 VSS.t127 2178.28
R7936 VSS.n3301 VSS.t454 2178.28
R7937 VSS.n3308 VSS.t331 2178.28
R7938 VSS.t259 VSS.n3311 2178.28
R7939 VSS.n3312 VSS.t279 2178.28
R7940 VSS.t136 VSS.n3210 2178.28
R7941 VSS.n3955 VSS.t499 2178.28
R7942 VSS.n3953 VSS.t401 2178.28
R7943 VSS.t450 VSS.n3952 2178.28
R7944 VSS.n1921 VSS.t258 2178.28
R7945 VSS.n3295 VSS.t332 2172.46
R7946 VSS.n3318 VSS.t268 2172.46
R7947 VSS.n3319 VSS.t222 2172.46
R7948 VSS.n3321 VSS.t530 2172.46
R7949 VSS.n3269 VSS.t461 2172.46
R7950 VSS.n3292 VSS.t501 2172.46
R7951 VSS.n3293 VSS.t129 2172.46
R7952 VSS.n3299 VSS.t328 2172.46
R7953 VSS.n3243 VSS.t216 2172.46
R7954 VSS.n3266 VSS.t91 2172.46
R7955 VSS.n3267 VSS.t203 2172.46
R7956 VSS.n3273 VSS.t515 2172.46
R7957 VSS.n3235 VSS.t384 2172.46
R7958 VSS.n3240 VSS.t7 2172.46
R7959 VSS.n3241 VSS.t294 2172.46
R7960 VSS.n3247 VSS.t534 2172.46
R7961 VSS.n3386 VSS.t211 2172.46
R7962 VSS.t152 VSS.n3385 2172.46
R7963 VSS.n3231 VSS.t201 2172.46
R7964 VSS.n3232 VSS.t408 2172.46
R7965 VSS.n780 VSS.t37 2172.46
R7966 VSS.n781 VSS.t237 2172.46
R7967 VSS.n782 VSS.t233 2172.46
R7968 VSS.n3390 VSS.t271 2172.46
R7969 VSS.n807 VSS.t396 2172.46
R7970 VSS.t263 VSS.n806 2172.46
R7971 VSS.n775 VSS.t439 2172.46
R7972 VSS.n776 VSS.t1 2172.46
R7973 VSS.n737 VSS.t477 2172.46
R7974 VSS.n756 VSS.t297 2172.46
R7975 VSS.n757 VSS.t229 2172.46
R7976 VSS.n811 VSS.t358 2172.46
R7977 VSS.n711 VSS.t248 2172.46
R7978 VSS.n734 VSS.t61 2172.46
R7979 VSS.n735 VSS.t283 2172.46
R7980 VSS.n741 VSS.t378 2172.46
R7981 VSS.n703 VSS.t488 2172.46
R7982 VSS.n708 VSS.t296 2172.46
R7983 VSS.n709 VSS.t57 2172.46
R7984 VSS.n715 VSS.t251 2172.46
R7985 VSS.n3498 VSS.t298 2172.46
R7986 VSS.t5 VSS.n3497 2172.46
R7987 VSS.n699 VSS.t467 2172.46
R7988 VSS.n700 VSS.t309 2172.46
R7989 VSS.n2036 VSS.t526 2172.46
R7990 VSS.n2037 VSS.t133 2172.46
R7991 VSS.n2038 VSS.t157 2172.46
R7992 VSS.n3502 VSS.t434 2172.46
R7993 VSS.n2063 VSS.t337 2172.46
R7994 VSS.t400 VSS.n2062 2172.46
R7995 VSS.n2031 VSS.t289 2172.46
R7996 VSS.n2032 VSS.t425 2172.46
R7997 VSS.n1993 VSS.t26 2172.46
R7998 VSS.n2012 VSS.t483 2172.46
R7999 VSS.n2013 VSS.t277 2172.46
R8000 VSS.n2067 VSS.t264 2172.46
R8001 VSS.n1967 VSS.t455 2172.46
R8002 VSS.n1990 VSS.t356 2172.46
R8003 VSS.n1991 VSS.t473 2172.46
R8004 VSS.n1997 VSS.t300 2172.46
R8005 VSS.n1941 VSS.t140 2172.46
R8006 VSS.n1964 VSS.t68 2172.46
R8007 VSS.n1965 VSS.t494 2172.46
R8008 VSS.n1971 VSS.t321 2172.46
R8009 VSS.n1915 VSS.t244 2172.46
R8010 VSS.n1938 VSS.t432 2172.46
R8011 VSS.n1939 VSS.t218 2172.46
R8012 VSS.n1945 VSS.t80 2172.46
R8013 VSS.n1907 VSS.t486 2172.46
R8014 VSS.n1912 VSS.t500 2172.46
R8015 VSS.n1913 VSS.t452 2172.46
R8016 VSS.n1919 VSS.t255 2172.46
R8017 VSS.n50 VSS.n18 2075.76
R8018 VSS.t463 VSS.n827 2069.16
R8019 VSS.t413 VSS.t521 1974.97
R8020 VSS.t417 VSS.t181 1974.97
R8021 VSS.n3517 VSS.n3516 1972.58
R8022 VSS.n2172 VSS.n2171 1967.13
R8023 VSS.n2077 VSS.n1854 1956.34
R8024 VSS.t422 VSS.t316 1940.97
R8025 VSS.t412 VSS.t308 1940.97
R8026 VSS.n18 VSS.n17 1933.14
R8027 VSS.n3517 VSS.n252 1851.67
R8028 VSS.t524 VSS.n19 1748.76
R8029 VSS.n1947 VSS.n1946 1690.35
R8030 VSS.n1973 VSS.n1972 1690.35
R8031 VSS.n1998 VSS.n1891 1690.35
R8032 VSS.n2069 VSS.n2068 1690.35
R8033 VSS.n2055 VSS.n2025 1690.35
R8034 VSS.n3504 VSS.n3503 1690.35
R8035 VSS.n3490 VSS.n267 1690.35
R8036 VSS.n717 VSS.n716 1690.35
R8037 VSS.n742 VSS.n691 1690.35
R8038 VSS.n813 VSS.n812 1690.35
R8039 VSS.n799 VSS.n769 1690.35
R8040 VSS.n3392 VSS.n3391 1690.35
R8041 VSS.n3378 VSS.n410 1690.35
R8042 VSS.n3249 VSS.n3248 1690.35
R8043 VSS.n3275 VSS.n3274 1690.35
R8044 VSS.n3301 VSS.n3300 1690.35
R8045 VSS.n3322 VSS.n3210 1690.35
R8046 VSS.n3956 VSS.n3955 1690.35
R8047 VSS.n1921 VSS.n1920 1690.35
R8048 VSS.n3322 VSS.n3321 1685.83
R8049 VSS.n3300 VSS.n3299 1685.83
R8050 VSS.n3274 VSS.n3273 1685.83
R8051 VSS.n3248 VSS.n3247 1685.83
R8052 VSS.n3232 VSS.n410 1685.83
R8053 VSS.n3391 VSS.n3390 1685.83
R8054 VSS.n776 VSS.n769 1685.83
R8055 VSS.n812 VSS.n811 1685.83
R8056 VSS.n742 VSS.n741 1685.83
R8057 VSS.n716 VSS.n715 1685.83
R8058 VSS.n700 VSS.n267 1685.83
R8059 VSS.n3503 VSS.n3502 1685.83
R8060 VSS.n2032 VSS.n2025 1685.83
R8061 VSS.n2068 VSS.n2067 1685.83
R8062 VSS.n1998 VSS.n1997 1685.83
R8063 VSS.n1972 VSS.n1971 1685.83
R8064 VSS.n1946 VSS.n1945 1685.83
R8065 VSS.n1920 VSS.n1919 1685.83
R8066 VSS.n3974 VSS.n3973 1682.14
R8067 VSS.n3973 VSS.n16 1679.78
R8068 VSS.n3930 VSS.n3929 1576.57
R8069 VSS.n3581 VSS.n210 1513.92
R8070 VSS.n3518 VSS.n209 1513.92
R8071 VSS.n1127 VSS.n1123 1436.67
R8072 VSS.t11 VSS.n2142 1435.32
R8073 VSS.t475 VSS.t187 1432.34
R8074 VSS.t31 VSS.t479 1432.34
R8075 VSS.t35 VSS.t85 1432.34
R8076 VSS.t87 VSS.t185 1432.34
R8077 VSS.n3970 VSS.n21 1389.32
R8078 VSS.t409 VSS.n1851 1347.43
R8079 VSS.n2080 VSS.t179 1347.43
R8080 VSS.t513 VSS.n1853 1347.43
R8081 VSS.n1856 VSS.t522 1347.43
R8082 VSS.n2627 VSS.t147 1345.2
R8083 VSS.n1129 VSS.t305 1345.2
R8084 VSS.n1123 VSS.t24 1345.2
R8085 VSS.t301 VSS.n1127 1345.2
R8086 VSS.n2629 VSS.t84 1345.2
R8087 VSS.n369 VSS.t372 1338.55
R8088 VSS.n364 VSS.t4 1338.55
R8089 VSS.n3558 VSS.t370 1338.55
R8090 VSS.t19 VSS.n3557 1338.55
R8091 VSS.n2628 VSS.n20 1336.31
R8092 VSS.n3931 VSS.t240 1299.92
R8093 VSS.n3972 VSS.n3971 1261.53
R8094 VSS.t374 VSS.t167 1187.13
R8095 VSS.t371 VSS.t47 1183.23
R8096 VSS.t418 VSS.t379 1183.23
R8097 VSS.n3554 VSS.t369 1182.68
R8098 VSS.n3549 VSS.t20 1182.68
R8099 VSS.n3546 VSS.t373 1182.68
R8100 VSS.t2 VSS.n3544 1182.68
R8101 VSS.t377 VSS.t190 1171.56
R8102 VSS.t190 VSS.t95 1171.56
R8103 VSS.t189 VSS.t367 1171.56
R8104 VSS.t93 VSS.t189 1171.56
R8105 VSS.n3932 VSS.n3931 1166.2
R8106 VSS.t47 VSS.t96 1159.88
R8107 VSS.t94 VSS.t418 1159.88
R8108 VSS.t167 VSS.t3 1155.99
R8109 VSS.n3970 VSS.t64 1111.49
R8110 VSS.n2167 VSS.n1814 1055.6
R8111 VSS.n2168 VSS.n2167 1055.6
R8112 VSS.t134 VSS.n1882 973.054
R8113 VSS.n1878 VSS.t374 973.054
R8114 VSS.t3 VSS.n235 973.054
R8115 VSS.n3538 VSS.t187 973.054
R8116 VSS.t491 VSS.t371 973.054
R8117 VSS.t96 VSS.n3531 973.054
R8118 VSS.n241 VSS.t31 973.054
R8119 VSS.t379 VSS.t42 973.054
R8120 VSS.n307 VSS.t94 973.054
R8121 VSS.n314 VSS.t35 973.054
R8122 VSS.t185 VSS.n296 973.054
R8123 VSS.n370 VSS.t33 973.054
R8124 VSS.t531 VSS.n3322 925.89
R8125 VSS.n3300 VSS.t329 925.89
R8126 VSS.n3274 VSS.t518 925.89
R8127 VSS.n3248 VSS.t535 925.89
R8128 VSS.t510 VSS.n410 925.89
R8129 VSS.n3391 VSS.t269 925.89
R8130 VSS.t21 VSS.n769 925.89
R8131 VSS.n812 VSS.t359 925.89
R8132 VSS.t375 VSS.n742 925.89
R8133 VSS.n716 VSS.t252 925.89
R8134 VSS.t313 VSS.n267 925.89
R8135 VSS.n3503 VSS.t435 925.89
R8136 VSS.t420 VSS.n2025 925.89
R8137 VSS.n2068 VSS.t265 925.89
R8138 VSS.t303 VSS.n1998 925.89
R8139 VSS.n1972 VSS.t322 925.89
R8140 VSS.n1946 VSS.t81 925.89
R8141 VSS.n1920 VSS.t256 925.89
R8142 VSS.t85 VSS.t428 914.672
R8143 VSS.t119 VSS.t87 914.672
R8144 VSS.n3934 VSS.n3933 911.11
R8145 VSS.t161 VSS.t377 906.886
R8146 VSS.t95 VSS.t142 906.886
R8147 VSS.t367 VSS.t120 906.886
R8148 VSS.t145 VSS.t93 906.886
R8149 VSS.n3519 VSS.n3518 901.356
R8150 VSS.n1846 VSS.t413 821.538
R8151 VSS.t521 VSS.n37 821.538
R8152 VSS.n1835 VSS.t417 821.538
R8153 VSS.t181 VSS.n39 821.538
R8154 VSS.t316 VSS.n3841 806.053
R8155 VSS.n3842 VSS.t422 806.053
R8156 VSS.t308 VSS.n14 806.053
R8157 VSS.n15 VSS.t412 806.053
R8158 VSS.n3323 VSS.t531 792.414
R8159 VSS.n2142 VSS.n1804 790.463
R8160 VSS.n3306 VSS.t329 782.003
R8161 VSS.n3280 VSS.t518 782.003
R8162 VSS.n3254 VSS.t535 782.003
R8163 VSS.n3373 VSS.t510 782.003
R8164 VSS.n404 VSS.t269 782.003
R8165 VSS.n794 VSS.t21 782.003
R8166 VSS.n763 VSS.t359 782.003
R8167 VSS.n743 VSS.t375 782.003
R8168 VSS.n722 VSS.t252 782.003
R8169 VSS.n3485 VSS.t313 782.003
R8170 VSS.n261 VSS.t435 782.003
R8171 VSS.n2050 VSS.t420 782.003
R8172 VSS.n2019 VSS.t265 782.003
R8173 VSS.n1999 VSS.t303 782.003
R8174 VSS.n1978 VSS.t322 782.003
R8175 VSS.n1952 VSS.t81 782.003
R8176 VSS.n1926 VSS.t256 782.003
R8177 VSS.t490 VSS.t475 770.659
R8178 VSS.n3519 VSS.t351 710.85
R8179 VSS.t353 VSS.n826 710.85
R8180 VSS.n3579 VSS.t349 710.227
R8181 VSS.n211 VSS.t437 686.813
R8182 VSS.n3516 VSS.t281 686.813
R8183 VSS.n825 VSS.t207 686.234
R8184 VSS.t9 VSS.n2628 656.457
R8185 VSS.t145 VSS.n352 626.759
R8186 VSS.n3307 VSS.n3306 600.578
R8187 VSS.n3281 VSS.n3280 600.578
R8188 VSS.n3255 VSS.n3254 600.578
R8189 VSS.n3373 VSS.n3372 600.578
R8190 VSS.n405 VSS.n404 600.578
R8191 VSS.n794 VSS.n793 600.578
R8192 VSS.n764 VSS.n763 600.578
R8193 VSS.n743 VSS.n688 600.578
R8194 VSS.n723 VSS.n722 600.578
R8195 VSS.n3485 VSS.n3484 600.578
R8196 VSS.n262 VSS.n261 600.578
R8197 VSS.n2050 VSS.n2049 600.578
R8198 VSS.n2020 VSS.n2019 600.578
R8199 VSS.n1999 VSS.n1888 600.578
R8200 VSS.n1979 VSS.n1978 600.578
R8201 VSS.n1953 VSS.n1952 600.578
R8202 VSS.n1927 VSS.n1926 600.578
R8203 VSS.n3461 VSS.n287 591.617
R8204 VSS.n3460 VSS.n296 591.617
R8205 VSS.n3449 VSS.n328 591.617
R8206 VSS.n370 VSS.n363 591.617
R8207 VSS.t339 VSS.n3944 582.933
R8208 VSS.n241 VSS.t8 568.264
R8209 VSS.t92 VSS.n314 568.264
R8210 VSS.t72 VSS.n3327 548.124
R8211 VSS.n3361 VSS.t195 537.723
R8212 VSS.n3328 VSS.t199 537.723
R8213 VSS.n3021 VSS.t463 537.723
R8214 VSS.n3023 VSS.t343 537.723
R8215 VSS.n3359 VSS.t341 537.723
R8216 VSS.n51 VSS.n50 509.012
R8217 VSS.t347 VSS.n1884 498.671
R8218 VSS.n3947 VSS.n3946 478.603
R8219 VSS.n3943 VSS.n33 469.567
R8220 VSS.t142 VSS.n294 451.719
R8221 VSS.t192 VSS.n235 416.467
R8222 VSS.n2076 VSS.t347 410.562
R8223 VSS.n1854 VSS.t465 402.428
R8224 VSS.n2163 VSS.t164 400.447
R8225 VSS.n1878 VSS.t99 385.329
R8226 VSS.t155 VSS.n1805 381.971
R8227 VSS.n2136 VSS.t502 359.502
R8228 VSS.t426 VSS.t506 355.009
R8229 VSS.n3582 VSS.t479 288.024
R8230 VSS.n2079 VSS.n2078 285.656
R8231 VSS.t382 VSS.n2221 283.019
R8232 VSS.t386 VSS.t446 279.481
R8233 VSS.n32 VSS.n20 258.803
R8234 VSS.n1882 VSS.t99 206.287
R8235 VSS.t89 VSS.n1819 180.768
R8236 VSS.t18 VSS.n1821 180.522
R8237 VSS.t89 VSS.n1833 180.522
R8238 VSS.t192 VSS.n3538 175.15
R8239 VSS.t345 VSS.n3938 173.112
R8240 VSS.t457 VSS.n1821 172.894
R8241 VSS.n1833 VSS.t18 172.893
R8242 VSS.n3534 VSS.n3533 162.675
R8243 VSS.n3585 VSS.n3584 162.675
R8244 VSS.t119 VSS.n294 155.725
R8245 VSS.t459 VSS.n41 153.577
R8246 VSS.t77 VSS.t184 151.292
R8247 VSS.t429 VSS.t523 151.292
R8248 VSS.t416 VSS.t77 149.293
R8249 VSS.t514 VSS.t429 149.293
R8250 VSS.n3939 VSS.t345 143.78
R8251 VSS.n2149 VSS.t148 141.304
R8252 VSS.t537 VSS.n2091 135.812
R8253 VSS.n2158 VSS.t148 135.812
R8254 VSS.t459 VSS.t457 129.669
R8255 VSS.t161 VSS.n288 129.543
R8256 VSS.t190 VSS.n291 129.543
R8257 VSS.n358 VSS.t120 129.543
R8258 VSS.t189 VSS.n353 129.543
R8259 VSS.t380 VSS.n1810 124.828
R8260 VSS.n2181 VSS.t117 124.828
R8261 VSS.n2127 VSS.t504 124.828
R8262 VSS.n2137 VSS.t115 124.828
R8263 VSS.n2123 VSS.t406 124.828
R8264 VSS.n2094 VSS.t516 124.828
R8265 VSS.n2150 VSS.t410 124.828
R8266 VSS.t520 VSS.n2157 124.828
R8267 VSS.t190 VSS.n288 124.781
R8268 VSS.t142 VSS.n291 124.781
R8269 VSS.t189 VSS.n358 124.781
R8270 VSS.t145 VSS.n353 124.781
R8271 VSS.n3580 VSS.n211 121.924
R8272 VSS.t365 VSS.t183 119.105
R8273 VSS.t161 VSS.n289 118.626
R8274 VSS.t190 VSS.n292 118.626
R8275 VSS.n357 VSS.t120 118.626
R8276 VSS.t189 VSS.n351 118.626
R8277 VSS.t77 VSS.n2173 118.481
R8278 VSS.t213 VSS.n1807 118.481
R8279 VSS.t415 VSS.t365 117.531
R8280 VSS.n2186 VSS.n2185 115.341
R8281 VSS.n2173 VSS.t48 114.912
R8282 VSS.t77 VSS.n1807 114.912
R8283 VSS.t213 VSS.n1804 114.912
R8284 VSS.t190 VSS.n289 114.266
R8285 VSS.t142 VSS.n292 114.266
R8286 VSS.t189 VSS.n357 114.266
R8287 VSS.t145 VSS.n351 114.266
R8288 VSS.t17 VSS.n1831 111.243
R8289 VSS.n2228 VSS.t146 110.85
R8290 VSS.n3939 VSS.n33 109.849
R8291 VSS.t48 VSS.t39 108.489
R8292 VSS.n2175 VSS.n2174 108.35
R8293 VSS.n2133 VSS.n2132 106.853
R8294 VSS.t18 VSS.n1832 105.74
R8295 VSS.t228 VSS.n52 100.638
R8296 VSS.n2148 VSS.t148 100.281
R8297 VSS.t361 VSS.n2086 100.281
R8298 VSS.n3946 VSS.n3945 98.7443
R8299 VSS.n2102 VSS.t508 98.2709
R8300 VSS.n2109 VSS.t444 98.2709
R8301 VSS.t512 VSS.n2227 98.2709
R8302 VSS.n2234 VSS.t180 98.2709
R8303 VSS.t414 VSS.n1827 98.2709
R8304 VSS.n1838 VSS.t182 98.2709
R8305 VSS.t502 VSS.t363 97.3657
R8306 VSS.t506 VSS.t11 97.3657
R8307 VSS.n3926 VSS.t228 97.0687
R8308 VSS.n3928 VSS.t243 97.0687
R8309 VSS.t12 VSS.n2148 97.0687
R8310 VSS.t149 VSS.n2086 97.0687
R8311 VSS.t362 VSS.n1847 97.0687
R8312 VSS.n3450 VSS.t119 96.6745
R8313 VSS.t443 VSS.n54 94.9275
R8314 VSS.n2208 VSS.t106 92.2512
R8315 VSS.t471 VSS.n28 92.008
R8316 VSS.t108 VSS.n44 91.2802
R8317 VSS.n54 VSS.t55 89.2176
R8318 VSS.n55 VSS.t315 89.2176
R8319 VSS.t423 VSS.n3925 89.2176
R8320 VSS.n3548 VSS.n3547 85.1533
R8321 VSS.n2229 VSS.n43 84.5131
R8322 VSS.n2105 VSS.n2104 84.12
R8323 VSS.n3975 VSS.n3974 84.0123
R8324 VSS.n2142 VSS.n2099 83.385
R8325 VSS.n2093 VSS.n2092 81.3878
R8326 VSS.t482 VSS.t382 76.6514
R8327 VSS.t458 VSS.t386 76.6514
R8328 VSS.n2126 VSS.t364 74.3975
R8329 VSS.n2098 VSS.t191 74.3975
R8330 VSS.t13 VSS.n2089 74.3975
R8331 VSS.t361 VSS.n1848 72.8996
R8332 VSS.t242 VSS.t243 72.8016
R8333 VSS.t13 VSS.t14 72.0879
R8334 VSS.n3583 VSS.n3582 70.0604
R8335 VSS.n318 VSS.t428 68.9858
R8336 VSS.n2110 VSS.n1811 66.4313
R8337 VSS.n3461 VSS.t161 66.1682
R8338 VSS.t142 VSS.n3460 66.1682
R8339 VSS.n328 VSS.t120 66.1682
R8340 VSS.n363 VSS.t145 66.1682
R8341 VSS.n2143 VSS.t426 63.4127
R8342 VSS.n2162 VSS.n1848 62.9134
R8343 VSS.t164 VSS.n2162 61.9148
R8344 VSS.n2143 VSS.n2098 61.4155
R8345 VSS.n2092 VSS.t537 59.4182
R8346 VSS.n2222 VSS.t481 58.5697
R8347 VSS.t291 VSS.n2233 58.5697
R8348 VSS.n1822 VSS.t460 58.5697
R8349 VSS.t428 VSS.n287 58.3837
R8350 VSS.t119 VSS.n3449 58.3837
R8351 VSS.t89 VSS.n1837 56.2112
R8352 VSS.t8 VSS.n208 55.0988
R8353 VSS.n3542 VSS.n231 54.3145
R8354 VSS.n2132 VSS.t153 53.9258
R8355 VSS.n2175 VSS.t48 52.4279
R8356 VSS.n2141 VSS.t390 51.9286
R8357 VSS.n3969 VSS.t169 50.9905
R8358 VSS.t123 VSS.n3646 50.9905
R8359 VSS.n3450 VSS.n295 50.9206
R8360 VSS.n2185 VSS.t213 50.4307
R8361 VSS.n2232 VSS.t446 49.9219
R8362 VSS.n2213 VSS.t108 49.8171
R8363 VSS.n1837 VSS.n1836 49.5288
R8364 VSS.t64 VSS.n3969 49.4547
R8365 VSS.n3646 VSS.t169 49.4547
R8366 VSS.n1836 VSS.t448 48.7426
R8367 VSS.n2233 VSS.n2232 48.3496
R8368 VSS.t192 VSS.n234 47.0337
R8369 VSS.t311 VSS.t110 45.2972
R8370 VSS.t110 VSS.t411 44.6992
R8371 VSS.n2208 VSS.t137 44.6693
R8372 VSS.n2166 VSS.n38 44.521
R8373 VSS.n3977 VSS.n3976 43.2023
R8374 VSS.n2105 VSS.t238 42.4533
R8375 VSS.n63 VSS.t139 42.1559
R8376 VSS.t45 VSS.n21 41.7755
R8377 VSS.n3947 VSS.t471 41.0753
R8378 VSS.n3945 VSS.t339 41.0753
R8379 VSS.t287 VSS.n3943 41.0753
R8380 VSS.n2110 VSS.t246 40.881
R8381 VSS.t142 VSS.n295 40.8323
R8382 VSS.n2084 VSS.n2083 40.7252
R8383 VSS.n65 VSS.t139 40.661
R8384 VSS.n58 VSS.t334 39.7641
R8385 VSS.t53 VSS.n49 37.374
R8386 VSS.n58 VSS.t496 37.3723
R8387 VSS.t312 VSS.n62 37.3723
R8388 VSS.n66 VSS.t424 37.3723
R8389 VSS.n3931 VSS.n44 34.82
R8390 VSS.n3980 VSS.n3979 33.9356
R8391 VSS.n45 VSS.n13 33.0387
R8392 VSS.n3977 VSS.t177 31.9907
R8393 VSS.n2142 VSS.n2141 31.9563
R8394 VSS.t46 VSS.t45 30.4969
R8395 VSS.n3647 VSS.t125 30.2566
R8396 VSS.n3958 VSS.t162 30.2566
R8397 VSS.n315 VSS.t143 27.5992
R8398 VSS.t363 VSS.n2126 27.4625
R8399 VSS.t11 VSS.n2089 27.4625
R8400 VSS.n320 VSS.n288 26.7599
R8401 VSS.n323 VSS.n291 26.7599
R8402 VSS.n359 VSS.n358 26.7599
R8403 VSS.n354 VSS.n353 26.7599
R8404 VSS.n1877 VSS.t99 26.5116
R8405 VSS.t167 VSS.n233 26.5116
R8406 VSS.t97 VSS.n1857 25.713
R8407 VSS.t167 VSS.n1877 25.713
R8408 VSS.n2181 VSS.t213 25.4652
R8409 VSS.n49 VSS.t173 24.8165
R8410 VSS.n2103 VSS.n1811 24.3716
R8411 VSS.t97 VSS.t99 24.2757
R8412 VSS.n2137 VSS.t390 23.9673
R8413 VSS.t48 VSS.n1810 23.468
R8414 VSS.n3531 VSS.t8 23.3538
R8415 VSS.t92 VSS.n307 23.3538
R8416 VSS.n3944 VSS.t287 22.8381
R8417 VSS.t491 VSS.n239 22.5189
R8418 VSS.t47 VSS.n240 22.5189
R8419 VSS.n299 VSS.t42 22.5189
R8420 VSS.t418 VSS.n306 22.5189
R8421 VSS.t146 VSS.n43 22.4062
R8422 VSS.t143 VSS.n298 22.3592
R8423 VSS.n2127 VSS.t153 21.9701
R8424 VSS.t490 VSS.n234 21.7204
R8425 VSS.t47 VSS.n239 21.7204
R8426 VSS.t8 VSS.n240 21.7204
R8427 VSS.t418 VSS.n299 21.7204
R8428 VSS.t161 VSS.n290 21.7204
R8429 VSS.t190 VSS.n293 21.7204
R8430 VSS.n361 VSS.t120 21.7204
R8431 VSS.t189 VSS.n356 21.7204
R8432 VSS.n2222 VSS.t482 21.62
R8433 VSS.t101 VSS.n12 21.2277
R8434 VSS.n298 VSS.t428 20.9219
R8435 VSS.t190 VSS.n290 20.9219
R8436 VSS.t142 VSS.n293 20.9219
R8437 VSS.t119 VSS.n327 20.9219
R8438 VSS.t189 VSS.n361 20.9219
R8439 VSS.t145 VSS.n356 20.9219
R8440 VSS.n1822 VSS.t459 20.8338
R8441 VSS.n3950 VSS 20.7178
R8442 VSS.n3223 VSS.n3222 20.4322
R8443 VSS.n3365 VSS.n3364 20.4322
R8444 VSS.n3395 VSS.n3394 20.4322
R8445 VSS.n816 VSS.n815 20.4322
R8446 VSS.n3477 VSS.n3476 20.4322
R8447 VSS.n3507 VSS.n3506 20.4322
R8448 VSS.n2072 VSS.n2071 20.4322
R8449 VSS.n1901 VSS.n1900 20.4322
R8450 VSS.n3539 VSS.n233 19.6442
R8451 VSS.t125 VSS.t162 19.1986
R8452 VSS.t92 VSS.t112 19.0853
R8453 VSS.n2214 VSS.n2213 18.9219
R8454 VSS.t246 VSS.n2109 18.8684
R8455 VSS.n3986 VSS.n10 17.978
R8456 VSS.n2133 VSS.t514 17.9756
R8457 VSS.t28 VSS.n12 17.7896
R8458 VSS.n1908 VSS.t487 17.5155
R8459 VSS.t238 VSS.n2102 17.2961
R8460 VSS.n3983 VSS.t178 16.9722
R8461 VSS.n1124 VSS.t25 16.9698
R8462 VSS.n59 VSS.t497 16.9698
R8463 VSS.n53 VSS.t56 16.9698
R8464 VSS.n48 VSS.t54 16.9698
R8465 VSS.n1818 VSS.t449 16.9687
R8466 VSS.n2154 VSS.t165 16.9687
R8467 VSS.n2138 VSS.t116 16.9687
R8468 VSS.n2108 VSS.t445 16.9687
R8469 VSS.n2182 VSS.t118 16.9687
R8470 VSS.n2097 VSS.t427 16.9687
R8471 VSS.n1797 VSS.t447 16.9687
R8472 VSS.n3314 VSS.t280 16.945
R8473 VSS.n3212 VSS.t260 16.945
R8474 VSS.n3288 VSS.t128 16.945
R8475 VSS.n3215 VSS.t132 16.945
R8476 VSS.n3262 VSS.t227 16.945
R8477 VSS.n3226 VSS.t336 16.945
R8478 VSS.n413 VSS.t293 16.945
R8479 VSS.n412 VSS.t307 16.945
R8480 VSS.n3381 VSS.t225 16.945
R8481 VSS.n400 VSS.t210 16.945
R8482 VSS.n771 VSS.t236 16.945
R8483 VSS.n787 VSS.t326 16.945
R8484 VSS.n802 VSS.t286 16.945
R8485 VSS.n759 VSS.t151 16.945
R8486 VSS.n752 VSS.t232 16.945
R8487 VSS.n751 VSS.t274 16.945
R8488 VSS.n730 VSS.t470 16.945
R8489 VSS.n693 VSS.t67 16.945
R8490 VSS.n270 VSS.t60 16.945
R8491 VSS.n269 VSS.t16 16.945
R8492 VSS.n3493 VSS.t206 16.945
R8493 VSS.n257 VSS.t318 16.945
R8494 VSS.n2027 VSS.t160 16.945
R8495 VSS.n2043 VSS.t122 16.945
R8496 VSS.n2058 VSS.t198 16.945
R8497 VSS.n2015 VSS.t394 16.945
R8498 VSS.n2008 VSS.t276 16.945
R8499 VSS.n2007 VSS.t485 16.945
R8500 VSS.n1986 VSS.t221 16.945
R8501 VSS.n1893 VSS.t320 16.945
R8502 VSS.n1960 VSS.t493 16.945
R8503 VSS.n1897 VSS.t399 16.945
R8504 VSS.n1934 VSS.t442 16.945
R8505 VSS.n1904 VSS.t262 16.945
R8506 VSS.n30 VSS.t451 16.945
R8507 VSS.n29 VSS.t402 16.945
R8508 VSS.n3211 VSS.t223 16.945
R8509 VSS.n3297 VSS.t333 16.945
R8510 VSS.n3214 VSS.t130 16.945
R8511 VSS.n3271 VSS.t462 16.945
R8512 VSS.n3225 VSS.t204 16.945
R8513 VSS.n3245 VSS.t217 16.945
R8514 VSS.n3228 VSS.t295 16.945
R8515 VSS.n3234 VSS.t385 16.945
R8516 VSS.n3229 VSS.t202 16.945
R8517 VSS.n3388 VSS.t212 16.945
R8518 VSS.n784 VSS.t234 16.945
R8519 VSS.n778 VSS.t38 16.945
R8520 VSS.n773 VSS.t440 16.945
R8521 VSS.n809 VSS.t397 16.945
R8522 VSS.n687 VSS.t230 16.945
R8523 VSS.n739 VSS.t478 16.945
R8524 VSS.n692 VSS.t284 16.945
R8525 VSS.n713 VSS.t249 16.945
R8526 VSS.n696 VSS.t58 16.945
R8527 VSS.n702 VSS.t489 16.945
R8528 VSS.n697 VSS.t468 16.945
R8529 VSS.n3500 VSS.t299 16.945
R8530 VSS.n2040 VSS.t158 16.945
R8531 VSS.n2034 VSS.t527 16.945
R8532 VSS.n2029 VSS.t290 16.945
R8533 VSS.n2065 VSS.t338 16.945
R8534 VSS.n1887 VSS.t278 16.945
R8535 VSS.n1995 VSS.t27 16.945
R8536 VSS.n1892 VSS.t474 16.945
R8537 VSS.n1969 VSS.t456 16.945
R8538 VSS.n1896 VSS.t495 16.945
R8539 VSS.n1943 VSS.t141 16.945
R8540 VSS.n1903 VSS.t219 16.945
R8541 VSS.n1917 VSS.t245 16.945
R8542 VSS.n1906 VSS.t453 16.945
R8543 VSS.n69 VSS.t525 16.8396
R8544 VSS.n3922 VSS.t529 16.8384
R8545 VSS.n297 VSS.t88 16.8029
R8546 VSS.n311 VSS.t86 16.8029
R8547 VSS.n312 VSS.t36 16.8029
R8548 VSS.n3586 VSS.t480 16.8029
R8549 VSS.n3535 VSS.t476 16.8029
R8550 VSS.n3536 VSS.t188 16.8029
R8551 VSS.n1858 VSS.t135 16.8029
R8552 VSS.n1122 VSS.t10 16.8017
R8553 VSS.n350 VSS.t34 16.8017
R8554 VSS.n2174 VSS.t416 16.4777
R8555 VSS.n3647 VSS.t123 16.434
R8556 VSS.n1861 VSS.n1858 16.1779
R8557 VSS.n3933 VSS.n3932 16.1162
R8558 VSS.n2207 VSS.n2199 15.9348
R8559 VSS.n3455 VSS.n3454 15.7911
R8560 VSS.n3321 VSS 15.7634
R8561 VSS.n3955 VSS 15.7634
R8562 VSS.n1868 VSS.n1867 15.7485
R8563 VSS.n1875 VSS.n1859 15.7485
R8564 VSS.n3980 VSS.t28 15.6974
R8565 VSS.n45 VSS.t173 15.0994
R8566 VSS.n1922 VSS.n1921 15.045
R8567 VSS.n3952 VSS.n3951 15.045
R8568 VSS.n3954 VSS.n3953 15.045
R8569 VSS.n1948 VSS.n1947 15.045
R8570 VSS.n1933 VSS.n1932 15.045
R8571 VSS.n1931 VSS.n1930 15.045
R8572 VSS.n1929 VSS.n1928 15.045
R8573 VSS.n1974 VSS.n1973 15.045
R8574 VSS.n1959 VSS.n1958 15.045
R8575 VSS.n1957 VSS.n1956 15.045
R8576 VSS.n1955 VSS.n1954 15.045
R8577 VSS.n1894 VSS.n1891 15.045
R8578 VSS.n1985 VSS.n1984 15.045
R8579 VSS.n1983 VSS.n1982 15.045
R8580 VSS.n1981 VSS.n1980 15.045
R8581 VSS.n2070 VSS.n2069 15.045
R8582 VSS.n2004 VSS.n1885 15.045
R8583 VSS.n2006 VSS.n2005 15.045
R8584 VSS.n2003 VSS.n2002 15.045
R8585 VSS.n2055 VSS.n2054 15.045
R8586 VSS.n2057 VSS.n2056 15.045
R8587 VSS.n2024 VSS.n2023 15.045
R8588 VSS.n2022 VSS.n2021 15.045
R8589 VSS.n3505 VSS.n3504 15.045
R8590 VSS.n2044 VSS.n255 15.045
R8591 VSS.n2046 VSS.n2045 15.045
R8592 VSS.n2048 VSS.n2047 15.045
R8593 VSS.n3490 VSS.n3489 15.045
R8594 VSS.n3492 VSS.n3491 15.045
R8595 VSS.n266 VSS.n265 15.045
R8596 VSS.n264 VSS.n263 15.045
R8597 VSS.n718 VSS.n717 15.045
R8598 VSS.n3479 VSS.n3478 15.045
R8599 VSS.n3481 VSS.n3480 15.045
R8600 VSS.n3483 VSS.n3482 15.045
R8601 VSS.n694 VSS.n691 15.045
R8602 VSS.n729 VSS.n728 15.045
R8603 VSS.n727 VSS.n726 15.045
R8604 VSS.n725 VSS.n724 15.045
R8605 VSS.n814 VSS.n813 15.045
R8606 VSS.n748 VSS.n685 15.045
R8607 VSS.n750 VSS.n749 15.045
R8608 VSS.n747 VSS.n746 15.045
R8609 VSS.n799 VSS.n798 15.045
R8610 VSS.n801 VSS.n800 15.045
R8611 VSS.n768 VSS.n767 15.045
R8612 VSS.n766 VSS.n765 15.045
R8613 VSS.n3393 VSS.n3392 15.045
R8614 VSS.n788 VSS.n398 15.045
R8615 VSS.n790 VSS.n789 15.045
R8616 VSS.n792 VSS.n791 15.045
R8617 VSS.n3378 VSS.n3377 15.045
R8618 VSS.n3380 VSS.n3379 15.045
R8619 VSS.n409 VSS.n408 15.045
R8620 VSS.n407 VSS.n406 15.045
R8621 VSS.n3250 VSS.n3249 15.045
R8622 VSS.n3367 VSS.n3366 15.045
R8623 VSS.n3369 VSS.n3368 15.045
R8624 VSS.n3371 VSS.n3370 15.045
R8625 VSS.n3276 VSS.n3275 15.045
R8626 VSS.n3261 VSS.n3260 15.045
R8627 VSS.n3259 VSS.n3258 15.045
R8628 VSS.n3257 VSS.n3256 15.045
R8629 VSS.n3302 VSS.n3301 15.045
R8630 VSS.n3287 VSS.n3286 15.045
R8631 VSS.n3285 VSS.n3284 15.045
R8632 VSS.n3283 VSS.n3282 15.045
R8633 VSS.n3320 VSS.n3319 15.045
R8634 VSS.n3318 VSS.n3317 15.045
R8635 VSS.n3299 VSS.n3298 15.045
R8636 VSS.n3294 VSS.n3293 15.045
R8637 VSS.n3292 VSS.n3291 15.045
R8638 VSS.n3270 VSS.n3269 15.045
R8639 VSS.n3273 VSS.n3272 15.045
R8640 VSS.n3268 VSS.n3267 15.045
R8641 VSS.n3266 VSS.n3265 15.045
R8642 VSS.n3244 VSS.n3243 15.045
R8643 VSS.n3247 VSS.n3246 15.045
R8644 VSS.n3242 VSS.n3241 15.045
R8645 VSS.n3240 VSS.n3239 15.045
R8646 VSS.n3236 VSS.n3235 15.045
R8647 VSS.n3233 VSS.n3232 15.045
R8648 VSS.n3231 VSS.n3230 15.045
R8649 VSS.n3385 VSS.n3384 15.045
R8650 VSS.n3387 VSS.n3386 15.045
R8651 VSS.n3390 VSS.n3389 15.045
R8652 VSS.n783 VSS.n782 15.045
R8653 VSS.n781 VSS.n772 15.045
R8654 VSS.n780 VSS.n779 15.045
R8655 VSS.n777 VSS.n776 15.045
R8656 VSS.n775 VSS.n774 15.045
R8657 VSS.n806 VSS.n805 15.045
R8658 VSS.n808 VSS.n807 15.045
R8659 VSS.n811 VSS.n810 15.045
R8660 VSS.n758 VSS.n757 15.045
R8661 VSS.n756 VSS.n755 15.045
R8662 VSS.n738 VSS.n737 15.045
R8663 VSS.n741 VSS.n740 15.045
R8664 VSS.n736 VSS.n735 15.045
R8665 VSS.n734 VSS.n733 15.045
R8666 VSS.n712 VSS.n711 15.045
R8667 VSS.n715 VSS.n714 15.045
R8668 VSS.n710 VSS.n709 15.045
R8669 VSS.n708 VSS.n707 15.045
R8670 VSS.n704 VSS.n703 15.045
R8671 VSS.n701 VSS.n700 15.045
R8672 VSS.n699 VSS.n698 15.045
R8673 VSS.n3497 VSS.n3496 15.045
R8674 VSS.n3499 VSS.n3498 15.045
R8675 VSS.n3502 VSS.n3501 15.045
R8676 VSS.n2039 VSS.n2038 15.045
R8677 VSS.n2037 VSS.n2028 15.045
R8678 VSS.n2036 VSS.n2035 15.045
R8679 VSS.n2033 VSS.n2032 15.045
R8680 VSS.n2031 VSS.n2030 15.045
R8681 VSS.n2062 VSS.n2061 15.045
R8682 VSS.n2064 VSS.n2063 15.045
R8683 VSS.n2067 VSS.n2066 15.045
R8684 VSS.n2014 VSS.n2013 15.045
R8685 VSS.n2012 VSS.n2011 15.045
R8686 VSS.n1994 VSS.n1993 15.045
R8687 VSS.n1997 VSS.n1996 15.045
R8688 VSS.n1992 VSS.n1991 15.045
R8689 VSS.n1990 VSS.n1989 15.045
R8690 VSS.n1968 VSS.n1967 15.045
R8691 VSS.n1971 VSS.n1970 15.045
R8692 VSS.n1966 VSS.n1965 15.045
R8693 VSS.n1964 VSS.n1963 15.045
R8694 VSS.n1942 VSS.n1941 15.045
R8695 VSS.n1945 VSS.n1944 15.045
R8696 VSS.n1940 VSS.n1939 15.045
R8697 VSS.n1938 VSS.n1937 15.045
R8698 VSS.n1916 VSS.n1915 15.045
R8699 VSS.n1919 VSS.n1918 15.045
R8700 VSS.n1914 VSS.n1913 15.045
R8701 VSS.n1912 VSS.n1911 15.045
R8702 VSS.n1908 VSS.n1907 15.045
R8703 VSS.n3296 VSS.n3295 15.045
R8704 VSS.n3210 VSS.n3208 15.045
R8705 VSS.n3313 VSS.n3312 15.045
R8706 VSS.n3311 VSS.n3310 15.045
R8707 VSS.n3309 VSS.n3308 15.045
R8708 VSS.n2083 VSS.n1849 14.9956
R8709 VSS.n371 VSS.n370 14.9029
R8710 VSS.n3449 VSS.n3448 14.9029
R8711 VSS.n3457 VSS.n296 14.9029
R8712 VSS.n287 VSS.n285 14.9029
R8713 VSS.n1882 VSS.n1881 14.9029
R8714 VSS.n1124 VSS.n1123 14.9017
R8715 VSS.n54 VSS.n53 14.9017
R8716 VSS.n59 VSS.n58 14.9017
R8717 VSS.n49 VSS.n48 14.9017
R8718 VSS.n314 VSS.n313 14.9017
R8719 VSS.n242 VSS.n241 14.9017
R8720 VSS.n3538 VSS.n3537 14.9017
R8721 VSS.n2109 VSS.n2108 14.9005
R8722 VSS.n2233 VSS.n1797 14.9005
R8723 VSS.n1837 VSS.n1818 14.9005
R8724 VSS.n2182 VSS.n2181 14.9005
R8725 VSS.n2138 VSS.n2137 14.9005
R8726 VSS.n2098 VSS.n2097 14.9005
R8727 VSS.n2154 VSS.n1848 14.9005
R8728 VSS.t516 VSS.n2091 14.4805
R8729 VSS.n2104 VSS.t415 14.1514
R8730 VSS.n2158 VSS.t520 13.9811
R8731 VSS.n17 VSS.t101 13.6038
R8732 VSS.n3583 VSS.n208 13.256
R8733 VSS.t528 VSS.n3928 12.8478
R8734 VSS.n1824 VSS.t387 12.3846
R8735 VSS.n2087 VSS.t507 12.3846
R8736 VSS.n2129 VSS.t505 12.3846
R8737 VSS.n2100 VSS.t509 12.3846
R8738 VSS.n1808 VSS.t381 12.3846
R8739 VSS.n2121 VSS.t503 12.3846
R8740 VSS.n2224 VSS.t383 12.3846
R8741 VSS.n3356 VSS.t342 12.3525
R8742 VSS.n3025 VSS.t344 12.3525
R8743 VSS.n3396 VSS.t354 12.3525
R8744 VSS.n3576 VSS.t350 12.3525
R8745 VSS.n250 VSS.t352 12.3525
R8746 VSS.n253 VSS.t348 12.3525
R8747 VSS.n34 VSS.t346 12.3525
R8748 VSS.n1898 VSS.t340 12.3525
R8749 VSS.n2218 VSS.n2214 12.3235
R8750 VSS.n1924 VSS.t257 12.3047
R8751 VSS.n1950 VSS.t82 12.3047
R8752 VSS.n1976 VSS.t323 12.3047
R8753 VSS.n1890 VSS.t304 12.3047
R8754 VSS.n2017 VSS.t266 12.3047
R8755 VSS.n2052 VSS.t421 12.3047
R8756 VSS.n259 VSS.t436 12.3047
R8757 VSS.n3487 VSS.t314 12.3047
R8758 VSS.n720 VSS.t253 12.3047
R8759 VSS.n690 VSS.t376 12.3047
R8760 VSS.n761 VSS.t360 12.3047
R8761 VSS.n796 VSS.t22 12.3047
R8762 VSS.n402 VSS.t270 12.3047
R8763 VSS.n3375 VSS.t511 12.3047
R8764 VSS.n3252 VSS.t536 12.3047
R8765 VSS.n3278 VSS.t519 12.3047
R8766 VSS.n3304 VSS.t330 12.3047
R8767 VSS.n3209 VSS.t532 12.3047
R8768 VSS.n3942 VSS.t288 12.3005
R8769 VSS.n3948 VSS.t472 12.3005
R8770 VSS.n2073 VSS.t466 12.3005
R8771 VSS.n3325 VSS.t73 12.3005
R8772 VSS.n3329 VSS.t200 12.3005
R8773 VSS.n3362 VSS.t196 12.3005
R8774 VSS.n3020 VSS.t464 12.3005
R8775 VSS.n824 VSS.t208 12.3005
R8776 VSS.n3515 VSS.t282 12.3005
R8777 VSS.n334 VSS.t438 12.3005
R8778 VSS.n3455 VSS.t186 12.3005
R8779 VSS.n302 VSS.t32 12.3005
R8780 VSS VSS.t405 12.2496
R8781 VSS VSS.t404 12.2496
R8782 VSS VSS.t70 12.2496
R8783 VSS VSS.t74 12.2496
R8784 VSS VSS.t71 12.2496
R8785 VSS VSS.t75 12.2496
R8786 VSS VSS.t76 12.2496
R8787 VSS VSS.t69 12.2496
R8788 VSS.n2153 VSS.n1795 12.1754
R8789 VSS.n2180 VSS.n2179 12.0514
R8790 VSS.t115 VSS.n2136 11.9839
R8791 VSS.n3533 VSS.t491 11.8946
R8792 VSS.n3584 VSS.t42 11.8946
R8793 VSS.n303 VSS.n302 11.6207
R8794 VSS.n2229 VSS.t180 11.3999
R8795 VSS.n2170 VSS.n1813 11.1497
R8796 VSS.n327 VSS.n295 11.0202
R8797 VSS.n1832 VSS.t182 11.0068
R8798 VSS.n355 VSS.n354 10.9989
R8799 VSS.n360 VSS.n359 10.9989
R8800 VSS.n3452 VSS.n3451 10.9989
R8801 VSS.n324 VSS.n323 10.9989
R8802 VSS.n321 VSS.n320 10.9989
R8803 VSS.n3451 VSS.n294 10.9976
R8804 VSS.t161 VSS.t428 10.878
R8805 VSS.t119 VSS.t120 10.878
R8806 VSS.n1842 VSS.n1841 10.8088
R8807 VSS.t55 VSS.n16 10.7065
R8808 VSS.n3326 VSS.n3324 10.6394
R8809 VSS.t117 VSS.n1805 10.486
R8810 VSS.n3943 VSS 10.4644
R8811 VSS VSS.n3947 10.4644
R8812 VSS VSS.n1854 10.4644
R8813 VSS VSS.n3328 10.4644
R8814 VSS VSS.n3361 10.4644
R8815 VSS.n3021 VSS 10.4644
R8816 VSS.n825 VSS 10.4644
R8817 VSS.n3516 VSS 10.4644
R8818 VSS VSS.n211 10.4644
R8819 VSS.n1926 VSS.n1925 10.4122
R8820 VSS.n1952 VSS.n1951 10.4122
R8821 VSS.n1978 VSS.n1977 10.4122
R8822 VSS.n2000 VSS.n1999 10.4122
R8823 VSS.n2019 VSS.n2018 10.4122
R8824 VSS.n2051 VSS.n2050 10.4122
R8825 VSS.n261 VSS.n260 10.4122
R8826 VSS.n3486 VSS.n3485 10.4122
R8827 VSS.n722 VSS.n721 10.4122
R8828 VSS.n744 VSS.n743 10.4122
R8829 VSS.n763 VSS.n762 10.4122
R8830 VSS.n795 VSS.n794 10.4122
R8831 VSS.n404 VSS.n403 10.4122
R8832 VSS.n3374 VSS.n3373 10.4122
R8833 VSS.n3254 VSS.n3253 10.4122
R8834 VSS.n3280 VSS.n3279 10.4122
R8835 VSS.n3306 VSS.n3305 10.4122
R8836 VSS.n826 VSS 10.4041
R8837 VSS.n3546 VSS.n3545 10.4029
R8838 VSS.n3554 VSS.n3553 10.4029
R8839 VSS.n1835 VSS.n1834 10.4017
R8840 VSS.n1839 VSS.n1838 10.4017
R8841 VSS.n2157 VSS.n2156 10.4017
R8842 VSS.n2141 VSS.n2140 10.4017
R8843 VSS.n2111 VSS.n2110 10.4017
R8844 VSS.n2185 VSS.n2184 10.4017
R8845 VSS.n2095 VSS.n2094 10.4017
R8846 VSS.n2235 VSS.n2234 10.4017
R8847 VSS.n1846 VSS.n1845 10.4017
R8848 VSS.n1853 VSS.n1852 10.4017
R8849 VSS.n1851 VSS.n1850 10.4017
R8850 VSS.n1127 VSS.n1126 10.4017
R8851 VSS.n62 VSS.n61 10.4017
R8852 VSS.n56 VSS.n55 10.4017
R8853 VSS.n3984 VSS.n12 10.4017
R8854 VSS.n46 VSS.n45 10.4017
R8855 VSS.n3359 VSS 10.4017
R8856 VSS VSS.n3023 10.4017
R8857 VSS.n3579 VSS 10.4017
R8858 VSS VSS.n3519 10.4017
R8859 VSS.n2076 VSS 10.4017
R8860 VSS.t42 VSS.n207 10.4017
R8861 VSS.t491 VSS.n3532 10.4017
R8862 VSS.n1879 VSS.n1878 10.4017
R8863 VSS VSS.n3939 10.4017
R8864 VSS.n3945 VSS 10.4017
R8865 VSS.n2627 VSS.n2626 10.4005
R8866 VSS.n1130 VSS.n1129 10.4005
R8867 VSS.n3981 VSS.n3980 10.4005
R8868 VSS.n3841 VSS.n3840 10.4005
R8869 VSS.n3843 VSS.n3842 10.4005
R8870 VSS.n3837 VSS.n14 10.4005
R8871 VSS.n3838 VSS.n15 10.4005
R8872 VSS.n67 VSS.n66 10.4005
R8873 VSS.n2630 VSS.n2629 10.4005
R8874 VSS.n369 VSS.n368 10.4005
R8875 VSS.n365 VSS.n364 10.4005
R8876 VSS.n3559 VSS.n3558 10.4005
R8877 VSS.n3557 VSS.n3556 10.4005
R8878 VSS.n3550 VSS.n3549 10.4005
R8879 VSS.n3544 VSS.n3543 10.4005
R8880 VSS.n236 VSS.n235 10.4005
R8881 VSS.n3531 VSS.n3530 10.4005
R8882 VSS.n308 VSS.n307 10.4005
R8883 VSS.n3462 VSS.n3461 10.4005
R8884 VSS.n3460 VSS.n3459 10.4005
R8885 VSS.n3446 VSS.n328 10.4005
R8886 VSS.n363 VSS.n362 10.4005
R8887 VSS.n2081 VSS.n2080 10.4005
R8888 VSS.n1856 VSS.n1855 10.4005
R8889 VSS.n1815 VSS.n37 10.4005
R8890 VSS.n1816 VSS.n39 10.4005
R8891 VSS.n2102 VSS.n2101 10.4005
R8892 VSS.n2106 VSS.n2105 10.4005
R8893 VSS.n2223 VSS.n2222 10.4005
R8894 VSS.n2227 VSS.n2226 10.4005
R8895 VSS.n1823 VSS.n1822 10.4005
R8896 VSS.n1827 VSS.n1826 10.4005
R8897 VSS.n1810 VSS.n1809 10.4005
R8898 VSS.n2176 VSS.n2175 10.4005
R8899 VSS.n2128 VSS.n2127 10.4005
R8900 VSS.n2132 VSS.n2131 10.4005
R8901 VSS.n2126 VSS.n2125 10.4005
R8902 VSS.n2124 VSS.n2123 10.4005
R8903 VSS.n2089 VSS.n2088 10.4005
R8904 VSS.n2151 VSS.n2150 10.4005
R8905 VSS.n3925 VSS.n3924 10.4005
R8906 VSS.n2083 VSS.n2082 10.2617
R8907 VSS.n3316 VSS.n3315 9.86777
R8908 VSS.n3290 VSS.n3289 9.86777
R8909 VSS.n3264 VSS.n3263 9.86777
R8910 VSS.n3238 VSS.n3237 9.86777
R8911 VSS.n3383 VSS.n3382 9.86777
R8912 VSS.n786 VSS.n785 9.86777
R8913 VSS.n804 VSS.n803 9.86777
R8914 VSS.n754 VSS.n753 9.86777
R8915 VSS.n732 VSS.n731 9.86777
R8916 VSS.n706 VSS.n705 9.86777
R8917 VSS.n3495 VSS.n3494 9.86777
R8918 VSS.n2042 VSS.n2041 9.86777
R8919 VSS.n2060 VSS.n2059 9.86777
R8920 VSS.n2010 VSS.n2009 9.86777
R8921 VSS.n1988 VSS.n1987 9.86777
R8922 VSS.n1962 VSS.n1961 9.86777
R8923 VSS.n1936 VSS.n1935 9.86777
R8924 VSS.n1910 VSS.n1909 9.86777
R8925 VSS.n319 VSS.n318 9.85138
R8926 VSS.n3931 VSS.t106 9.84983
R8927 VSS.n3926 VSS.t423 9.63595
R8928 VSS.n2186 VSS.t184 9.48736
R8929 VSS.t523 VSS.n2099 9.48736
R8930 VSS.t406 VSS.n2093 9.48736
R8931 VSS.t410 VSS.n2149 9.48736
R8932 VSS.n2221 VSS.t444 9.43446
R8933 VSS.n317 VSS.t144 9.38971
R8934 VSS.n3675 VSS.n3662 9.28824
R8935 VSS.n3667 VSS.n3661 9.28824
R8936 VSS.n3689 VSS.n3649 9.28824
R8937 VSS.n3654 VSS.n3645 9.28824
R8938 VSS.n3331 VSS.n3330 9.06441
R8939 VSS.n3567 VSS.n221 9.03546
R8940 VSS.n2997 VSS.n2996 9.03509
R8941 VSS.n3407 VSS.n3403 9.03509
R8942 VSS.n662 VSS.n415 9.03471
R8943 VSS.n3018 VSS.n3017 9.03471
R8944 VSS.n3575 VSS.n3574 9.03471
R8945 VSS.n3221 VSS.n3220 9.03471
R8946 VSS.n2205 VSS.n2204 9.03471
R8947 VSS.n2268 VSS.n2267 9.03471
R8948 VSS.n2636 VSS.n1121 9.03471
R8949 VSS.n3445 VSS.n3444 9.03471
R8950 VSS.n310 VSS.n279 9.03471
R8951 VSS.n3528 VSS.n3527 9.03471
R8952 VSS.n275 VSS.n271 9.03471
R8953 VSS.n822 VSS.n821 9.03471
R8954 VSS.n340 VSS.n336 9.03471
R8955 VSS.n3513 VSS.n3512 9.03471
R8956 VSS.n3031 VSS.n3027 9.03471
R8957 VSS.n115 VSS.n11 9.03471
R8958 VSS.n73 VSS.n70 9.03471
R8959 VSS.n660 VSS.n659 9.00164
R8960 VSS.n3010 VSS.n3006 9.00164
R8961 VSS.n2999 VSS.n828 9.00164
R8962 VSS.n338 VSS.n337 9.00164
R8963 VSS.n217 VSS.n213 9.00164
R8964 VSS.n817 VSS.n397 9.00164
R8965 VSS.n3355 VSS.n3354 9.00164
R8966 VSS.n3216 VSS.n3207 9.00164
R8967 VSS.n2200 VSS.n1317 9.00164
R8968 VSS.n2260 VSS.n1318 9.00164
R8969 VSS.n3673 VSS.n3662 9.00164
R8970 VSS.n3665 VSS.n3661 9.00164
R8971 VSS.n3687 VSS.n3649 9.00164
R8972 VSS.n3652 VSS.n3645 9.00164
R8973 VSS.n348 VSS.n329 9.00164
R8974 VSS.n3465 VSS.n3464 9.00164
R8975 VSS.n3475 VSS.n3474 9.00164
R8976 VSS.n3508 VSS.n249 9.00164
R8977 VSS.n244 VSS.n243 9.00164
R8978 VSS.n225 VSS.n222 9.00164
R8979 VSS.n3405 VSS.n3404 9.00164
R8980 VSS.n3029 VSS.n3028 9.00164
R8981 VSS.n3849 VSS.n3848 9.00164
R8982 VSS.n3920 VSS.n3919 9.00164
R8983 VSS.n343 VSS.n212 9.0005
R8984 VSS.n3399 VSS.n3398 9.0005
R8985 VSS.n421 VSS.n417 9.0005
R8986 VSS.n2270 VSS.n2269 9.0005
R8987 VSS.n2178 VSS.n1321 9.0005
R8988 VSS.n2241 VSS.n2240 9.0005
R8989 VSS.n2624 VSS.n2623 9.0005
R8990 VSS.n3679 VSS.n3678 9.0005
R8991 VSS.n3682 VSS.n3681 9.0005
R8992 VSS.n3693 VSS.n3692 9.0005
R8993 VSS.n3696 VSS.n3695 9.0005
R8994 VSS.n3410 VSS.n229 9.0005
R8995 VSS.n3562 VSS.n3561 9.0005
R8996 VSS.n3588 VSS.n3587 9.0005
R8997 VSS.n286 VSS.n281 9.0005
R8998 VSS.n373 VSS.n372 9.0005
R8999 VSS.n684 VSS.n218 9.0005
R9000 VSS.n3005 VSS.n3004 9.0005
R9001 VSS.n3522 VSS.n3521 9.0005
R9002 VSS.n277 VSS.n272 9.0005
R9003 VSS.n3009 VSS.n683 9.0005
R9004 VSS.n666 VSS.n416 9.0005
R9005 VSS.n3034 VSS.n414 9.0005
R9006 VSS.n3847 VSS.n117 9.0005
R9007 VSS.t43 VSS.n3583 8.29471
R9008 VSS.n300 VSS.n234 8.29212
R9009 VSS.n316 VSS.t113 8.26317
R9010 VSS.n2231 VSS.n1798 8.21881
R9011 VSS.n2120 VSS.n2119 7.94259
R9012 VSS.n306 VSS 7.79335
R9013 VSS.n2238 VSS.n1796 7.66708
R9014 VSS.n2146 VSS.n2145 7.63552
R9015 VSS.n1833 VSS.n1820 7.57772
R9016 VSS.n304 VSS.n208 7.50798
R9017 VSS.n305 VSS.n299 7.50679
R9018 VSS.n301 VSS.n240 7.50679
R9019 VSS.n300 VSS.n239 7.50679
R9020 VSS.t315 VSS.n52 7.49474
R9021 VSS.n322 VSS.n319 7.47173
R9022 VSS.t183 VSS.n2103 7.46905
R9023 VSS.n2228 VSS.t512 7.46905
R9024 VSS.n1831 VSS.t414 7.46905
R9025 VSS.n2220 VSS.n2219 7.40324
R9026 VSS.n3978 VSS.n3977 7.30271
R9027 VSS.n1865 VSS.n1864 7.27866
R9028 VSS.n2159 VSS.n2086 7.26523
R9029 VSS.n2218 VSS.n2217 7.23472
R9030 VSS.n2161 VSS.n2084 7.09749
R9031 VSS.n355 VSS 7.04445
R9032 VSS.n3921 VSS.n3920 7.03234
R9033 VSS.n1844 VSS.n1843 6.9806
R9034 VSS.n3845 VSS.n3844 6.863
R9035 VSS.n1864 VSS.t389 6.85217
R9036 VSS.n3978 VSS.n13 6.84971
R9037 VSS.n1128 VSS.n27 6.80183
R9038 VSS.n3967 VSS.n23 6.80183
R9039 VSS.n2135 VSS.n2090 6.77655
R9040 VSS.n360 VSS.n326 6.77597
R9041 VSS.n322 VSS.n321 6.77597
R9042 VSS.n3453 VSS.n3452 6.77496
R9043 VSS.n325 VSS.n324 6.77445
R9044 VSS.n1803 VSS.n1802 6.60011
R9045 VSS.n3922 VSS.n3921 6.51143
R9046 VSS.n2161 VSS.n2160 6.47463
R9047 VSS.n1828 VSS.n1819 6.47463
R9048 VSS.n2114 VSS.n2113 6.42901
R9049 VSS.n2160 VSS.n2085 6.42241
R9050 VSS.n1830 VSS.n1828 6.42241
R9051 VSS.n64 VSS.n21 6.41876
R9052 VSS.n3928 VSS.n3927 6.41788
R9053 VSS.n316 VSS.n315 6.37582
R9054 VSS.n2147 VSS.n2146 6.359
R9055 VSS.n2238 VSS.n2237 6.31471
R9056 VSS.n2214 VSS.n2207 6.2705
R9057 VSS.n3451 VSS.n3450 6.17942
R9058 VSS.n3967 VSS.n3966 6.16664
R9059 VSS.n3964 VSS.n24 6.16664
R9060 VSS.n27 VSS.n26 6.16623
R9061 VSS.n64 VSS.n63 6.11876
R9062 VSS.n3927 VSS.n52 6.11788
R9063 VSS.n2134 VSS.n2133 6.11052
R9064 VSS.n2104 VSS.n1799 6.11052
R9065 VSS.n3539 VSS.t192 6.0693
R9066 VSS.n1843 VSS.n1842 6.05795
R9067 VSS.n2148 VSS.n2147 6.05604
R9068 VSS.n1829 VSS.n1798 5.99687
R9069 VSS.n1843 VSS.n1817 5.92473
R9070 VSS.n0 VSS.t103 5.87481
R9071 VSS.n2 VSS.t29 5.87481
R9072 VSS.n5 VSS.t111 5.87481
R9073 VSS.n3979 VSS.n3978 5.87021
R9074 VSS.n2135 VSS.n2134 5.86995
R9075 VSS.n2220 VSS.n1799 5.86995
R9076 VSS.n2144 VSS.n2143 5.83534
R9077 VSS.n2230 VSS.n2228 5.83061
R9078 VSS.n2144 VSS.n2093 5.83061
R9079 VSS.n3543 VSS.n230 5.80787
R9080 VSS.n1852 VSS.n1849 5.8055
R9081 VSS.n3839 VSS.n3837 5.8055
R9082 VSS.n3844 VSS.n3840 5.8055
R9083 VSS.n1834 VSS.n1817 5.80432
R9084 VSS.n1845 VSS.n1844 5.80432
R9085 VSS.n2082 VSS.n2081 5.80076
R9086 VSS.n3845 VSS.n3839 5.74274
R9087 VSS.n2215 VSS.t241 5.73862
R9088 VSS.n1800 VSS.t156 5.73862
R9089 VSS.n1829 VSS.n1821 5.7357
R9090 VSS.n2160 VSS.n2159 5.72291
R9091 VSS.n1828 VSS.n1820 5.72291
R9092 VSS.n10 VSS.n9 5.63024
R9093 VSS.n3985 VSS.n3984 5.54142
R9094 VSS.n1872 VSS.n1866 5.52586
R9095 VSS.n26 VSS 5.4995
R9096 VSS.n2194 VSS.n2192 5.49145
R9097 VSS.n4 VSS.n1 5.4875
R9098 VSS.n2197 VSS.n2196 5.48357
R9099 VSS.n8 VSS.n7 5.48
R9100 VSS.n3966 VSS.n3965 5.477
R9101 VSS.n3962 VSS.n22 5.477
R9102 VSS.n3695 VSS.n3694 5.43631
R9103 VSS.n3961 VSS.t124 5.42757
R9104 VSS.n2134 VSS.n2099 5.4067
R9105 VSS.n2103 VSS.n1799 5.4067
R9106 VSS.n3921 VSS.n69 5.40465
R9107 VSS.n2188 VSS.n1806 5.4005
R9108 VSS.n2189 VSS.n2188 5.39095
R9109 VSS.n3680 VSS.n3679 5.37645
R9110 VSS VSS.n3960 5.3735
R9111 VSS.n2209 VSS.t138 5.35415
R9112 VSS.n2193 VSS.t51 5.3165
R9113 VSS.n65 VSS.n64 5.28926
R9114 VSS.n3927 VSS.n3926 5.28838
R9115 VSS.n2217 VSS.n2216 5.27734
R9116 VSS.n1802 VSS.n1801 5.27734
R9117 VSS.n1866 VSS.n1865 5.27162
R9118 VSS.n2210 VSS.t107 5.1777
R9119 VSS.n2230 VSS.n2229 5.17692
R9120 VSS.n2212 VSS.t109 5.16823
R9121 VSS.n2209 VSS.n2208 5.16611
R9122 VSS.n2231 VSS.n2230 5.15892
R9123 VSS.n2211 VSS.n44 5.15664
R9124 VSS.n3681 VSS.n3680 5.08994
R9125 VSS.n3694 VSS.n3693 5.08994
R9126 VSS.n1871 VSS 5.04776
R9127 VSS.t504 VSS.t155 4.99359
R9128 VSS.n2173 VSS.n1806 4.98773
R9129 VSS.n2215 VSS.t239 4.95231
R9130 VSS.n1800 VSS.t154 4.95231
R9131 VSS.n2216 VSS.t366 4.95112
R9132 VSS.n1801 VSS.t430 4.95112
R9133 VSS.n318 VSS.n317 4.88675
R9134 VSS.n2194 VSS.n2193 4.86642
R9135 VSS VSS.n1871 4.80264
R9136 VSS.n3949 VSS.n31 4.76528
R9137 VSS.n3941 VSS.n3940 4.76528
R9138 VSS.n2075 VSS.n2074 4.76528
R9139 VSS.n1825 VSS.n1824 4.76458
R9140 VSS.n2152 VSS.n2087 4.76458
R9141 VSS.n2130 VSS.n2129 4.76458
R9142 VSS.n2107 VSS.n2100 4.76458
R9143 VSS.n2177 VSS.n1808 4.76458
R9144 VSS.n2122 VSS.n2121 4.76458
R9145 VSS.n2225 VSS.n2224 4.76458
R9146 VSS.n2196 VSS.n2195 4.72845
R9147 VSS.n3324 VSS.n3323 4.69818
R9148 VSS.n3327 VSS.n3326 4.67576
R9149 VSS.n2624 VSS.n1130 4.62484
R9150 VSS.n1873 VSS.n1860 4.58513
R9151 VSS VSS.n3358 4.55379
R9152 VSS.n3024 VSS 4.55379
R9153 VSS VSS.n3578 4.55379
R9154 VSS.n3520 VSS 4.55379
R9155 VSS VSS.n2075 4.55379
R9156 VSS.n3940 VSS 4.55379
R9157 VSS VSS.n31 4.55379
R9158 VSS.n2082 VSS.n1850 4.50524
R9159 VSS.n2634 VSS.n2633 4.50392
R9160 VSS.n3326 VSS.n3325 4.50287
R9161 VSS.n362 VSS.n349 4.50287
R9162 VSS.n3459 VSS.n3458 4.50287
R9163 VSS.n309 VSS.n308 4.50287
R9164 VSS.n3530 VSS.n3529 4.50287
R9165 VSS.n237 VSS.n236 4.50287
R9166 VSS.n665 VSS.n657 4.50199
R9167 VSS.n3015 VSS.n3014 4.50199
R9168 VSS.n3003 VSS.n2995 4.50199
R9169 VSS.n342 VSS.n331 4.50199
R9170 VSS.n216 VSS.n215 4.50199
R9171 VSS.n396 VSS.n394 4.50199
R9172 VSS.n420 VSS.n418 4.50199
R9173 VSS.n3351 VSS.n422 4.50199
R9174 VSS.n3206 VSS.n3204 4.50199
R9175 VSS.n2117 VSS.n2116 4.50199
R9176 VSS.n1793 VSS.n1791 4.50199
R9177 VSS.n1316 VSS.n1314 4.50199
R9178 VSS.n2265 VSS.n2264 4.50199
R9179 VSS.n2621 VSS.n2618 4.50199
R9180 VSS.n2622 VSS.n2617 4.50199
R9181 VSS.n3677 VSS.n3670 4.50199
R9182 VSS.n3660 VSS.n3658 4.50199
R9183 VSS.n3691 VSS.n3657 4.50199
R9184 VSS.n3644 VSS.n3642 4.50199
R9185 VSS.n2639 VSS.n1119 4.50199
R9186 VSS.n347 VSS.n346 4.50199
R9187 VSS.n3471 VSS.n278 4.50199
R9188 VSS.n3468 VSS.n3467 4.50199
R9189 VSS.n248 VSS.n246 4.50199
R9190 VSS.n204 VSS.n202 4.50199
R9191 VSS.n3565 VSS.n219 4.50199
R9192 VSS.n3409 VSS.n392 4.50199
R9193 VSS.n3033 VSS.n680 4.50199
R9194 VSS.n3852 VSS.n3851 4.50199
R9195 VSS.n3916 VSS.n75 4.50199
R9196 VSS.n1817 VSS.n1816 4.50168
R9197 VSS.n1844 VSS.n1815 4.50168
R9198 VSS.n302 VSS.n205 4.50168
R9199 VSS.n3551 VSS.n3550 4.50168
R9200 VSS.n3556 VSS.n226 4.50168
R9201 VSS.n366 VSS.n365 4.50168
R9202 VSS.n3339 VSS.n431 4.50095
R9203 VSS.n3198 VSS.n3197 4.50095
R9204 VSS.n3190 VSS.n3189 4.50095
R9205 VSS.n3182 VSS.n3181 4.50095
R9206 VSS.n3174 VSS.n3173 4.50095
R9207 VSS.n3166 VSS.n3165 4.50095
R9208 VSS.n3158 VSS.n3157 4.50095
R9209 VSS.n3713 VSS.n166 4.5007
R9210 VSS.n3605 VSS.n191 4.5007
R9211 VSS.n3625 VSS.n181 4.5007
R9212 VSS.n3615 VSS.n186 4.5007
R9213 VSS.n3635 VSS.n176 4.5007
R9214 VSS.n1008 VSS.n1003 4.5007
R9215 VSS.n3723 VSS.n161 4.5007
R9216 VSS.n3733 VSS.n156 4.5007
R9217 VSS.n3868 VSS.n3867 4.5007
R9218 VSS.n3878 VSS.n3873 4.5007
R9219 VSS.n3749 VSS.n3748 4.5007
R9220 VSS.n3760 VSS.n3755 4.5007
R9221 VSS.n3869 VSS.n3868 4.50065
R9222 VSS.n3860 VSS.n111 4.50065
R9223 VSS.n3832 VSS.n119 4.50065
R9224 VSS.n3823 VSS.n124 4.50065
R9225 VSS.n1621 VSS.n1620 4.50065
R9226 VSS.n1609 VSS.n1421 4.50065
R9227 VSS.n1453 VSS.n1452 4.50065
R9228 VSS.n7 VSS.n6 4.5005
R9229 VSS.n4 VSS.n3 4.5005
R9230 VSS.n665 VSS.n664 4.5005
R9231 VSS.n664 VSS.n662 4.5005
R9232 VSS.n663 VSS.n658 4.5005
R9233 VSS.n661 VSS.n657 4.5005
R9234 VSS.n668 VSS.n667 4.5005
R9235 VSS.n3016 VSS.n3015 4.5005
R9236 VSS.n3017 VSS.n3016 4.5005
R9237 VSS.n3011 VSS.n3008 4.5005
R9238 VSS.n3014 VSS.n3007 4.5005
R9239 VSS.n3013 VSS.n3012 4.5005
R9240 VSS.n3003 VSS.n3002 4.5005
R9241 VSS.n3002 VSS.n2997 4.5005
R9242 VSS.n3001 VSS.n3000 4.5005
R9243 VSS.n2998 VSS.n2995 4.5005
R9244 VSS.n2994 VSS.n829 4.5005
R9245 VSS.n422 VSS.n420 4.5005
R9246 VSS.n3353 VSS.n3352 4.5005
R9247 VSS.n3351 VSS.n418 4.5005
R9248 VSS.n3350 VSS.n419 4.5005
R9249 VSS.n3219 VSS.n3206 4.5005
R9250 VSS.n3220 VSS.n3219 4.5005
R9251 VSS.n3218 VSS.n3205 4.5005
R9252 VSS.n3217 VSS.n3204 4.5005
R9253 VSS.n3333 VSS.n3332 4.5005
R9254 VSS.n2188 VSS.n2187 4.5005
R9255 VSS.n1826 VSS.n1825 4.5005
R9256 VSS.n1840 VSS.n1839 4.5005
R9257 VSS.n2152 VSS.n2151 4.5005
R9258 VSS.n2156 VSS.n2155 4.5005
R9259 VSS.n2116 VSS.n1793 4.5005
R9260 VSS.n2115 VSS.n1792 4.5005
R9261 VSS.n2117 VSS.n1791 4.5005
R9262 VSS.n2243 VSS.n2242 4.5005
R9263 VSS.n2131 VSS.n2130 4.5005
R9264 VSS.n2140 VSS.n2139 4.5005
R9265 VSS.n2107 VSS.n2106 4.5005
R9266 VSS.n2112 VSS.n2111 4.5005
R9267 VSS.n2119 VSS.n2118 4.5005
R9268 VSS.n2203 VSS.n1316 4.5005
R9269 VSS.n2204 VSS.n2203 4.5005
R9270 VSS.n2202 VSS.n1315 4.5005
R9271 VSS.n2201 VSS.n1314 4.5005
R9272 VSS.n2272 VSS.n2271 4.5005
R9273 VSS.n2266 VSS.n2265 4.5005
R9274 VSS.n2267 VSS.n2266 4.5005
R9275 VSS.n2261 VSS.n1320 4.5005
R9276 VSS.n2264 VSS.n1319 4.5005
R9277 VSS.n2263 VSS.n2262 4.5005
R9278 VSS.n2177 VSS.n2176 4.5005
R9279 VSS.n2184 VSS.n2183 4.5005
R9280 VSS.n2124 VSS.n2122 4.5005
R9281 VSS.n2096 VSS.n2095 4.5005
R9282 VSS.n2226 VSS.n2225 4.5005
R9283 VSS.n2236 VSS.n2235 4.5005
R9284 VSS.n2239 VSS.n2238 4.5005
R9285 VSS.n2114 VSS.n1794 4.5005
R9286 VSS.n1855 VSS.n1849 4.5005
R9287 VSS.n2622 VSS.n2621 4.5005
R9288 VSS.n2620 VSS.n2619 4.5005
R9289 VSS.n2618 VSS.n2617 4.5005
R9290 VSS.n2616 VSS.n1131 4.5005
R9291 VSS.n3655 VSS.n3644 4.5005
R9292 VSS.n3655 VSS.n3654 4.5005
R9293 VSS.n3651 VSS.n3643 4.5005
R9294 VSS.n3653 VSS.n3642 4.5005
R9295 VSS.n3698 VSS.n3697 4.5005
R9296 VSS.n3691 VSS.n3690 4.5005
R9297 VSS.n3690 VSS.n3689 4.5005
R9298 VSS.n3686 VSS.n3685 4.5005
R9299 VSS.n3688 VSS.n3657 4.5005
R9300 VSS.n3656 VSS.n3650 4.5005
R9301 VSS.n3668 VSS.n3660 4.5005
R9302 VSS.n3668 VSS.n3667 4.5005
R9303 VSS.n3664 VSS.n3659 4.5005
R9304 VSS.n3666 VSS.n3658 4.5005
R9305 VSS.n3684 VSS.n3683 4.5005
R9306 VSS.n3677 VSS.n3676 4.5005
R9307 VSS.n3676 VSS.n3675 4.5005
R9308 VSS.n3672 VSS.n3671 4.5005
R9309 VSS.n3674 VSS.n3670 4.5005
R9310 VSS.n3669 VSS.n3663 4.5005
R9311 VSS.n2639 VSS.n2638 4.5005
R9312 VSS.n2638 VSS.n2636 4.5005
R9313 VSS.n2637 VSS.n1120 4.5005
R9314 VSS.n2635 VSS.n1119 4.5005
R9315 VSS.n2641 VSS.n2640 4.5005
R9316 VSS.n3963 VSS.n3962 4.5005
R9317 VSS.n3965 VSS.n3964 4.5005
R9318 VSS.n2633 VSS.n2632 4.5005
R9319 VSS.n1126 VSS.n1125 4.5005
R9320 VSS.n2631 VSS.n2630 4.5005
R9321 VSS.n2626 VSS.n2625 4.5005
R9322 VSS.n57 VSS.n56 4.5005
R9323 VSS.n3924 VSS.n3923 4.5005
R9324 VSS.n61 VSS.n60 4.5005
R9325 VSS.n68 VSS.n67 4.5005
R9326 VSS.n47 VSS.n46 4.5005
R9327 VSS.n3982 VSS.n3981 4.5005
R9328 VSS.n3984 VSS.n3983 4.5005
R9329 VSS.n3839 VSS.n3838 4.5005
R9330 VSS.n3844 VSS.n3843 4.5005
R9331 VSS.n1925 VSS.n1905 4.5005
R9332 VSS.n1924 VSS.n1923 4.5005
R9333 VSS.n1951 VSS.n1902 4.5005
R9334 VSS.n1950 VSS.n1949 4.5005
R9335 VSS.n1977 VSS.n1895 4.5005
R9336 VSS.n1976 VSS.n1975 4.5005
R9337 VSS.n2001 VSS.n2000 4.5005
R9338 VSS.n1890 VSS.n1889 4.5005
R9339 VSS.n2018 VSS.n2016 4.5005
R9340 VSS.n2017 VSS.n1886 4.5005
R9341 VSS.n2051 VSS.n2026 4.5005
R9342 VSS.n2053 VSS.n2052 4.5005
R9343 VSS.n260 VSS.n258 4.5005
R9344 VSS.n259 VSS.n256 4.5005
R9345 VSS.n3486 VSS.n268 4.5005
R9346 VSS.n3488 VSS.n3487 4.5005
R9347 VSS.n721 VSS.n695 4.5005
R9348 VSS.n720 VSS.n719 4.5005
R9349 VSS.n745 VSS.n744 4.5005
R9350 VSS.n690 VSS.n689 4.5005
R9351 VSS.n762 VSS.n760 4.5005
R9352 VSS.n761 VSS.n686 4.5005
R9353 VSS.n795 VSS.n770 4.5005
R9354 VSS.n797 VSS.n796 4.5005
R9355 VSS.n403 VSS.n401 4.5005
R9356 VSS.n402 VSS.n399 4.5005
R9357 VSS.n3374 VSS.n411 4.5005
R9358 VSS.n3376 VSS.n3375 4.5005
R9359 VSS.n3253 VSS.n3227 4.5005
R9360 VSS.n3252 VSS.n3251 4.5005
R9361 VSS.n3279 VSS.n3224 4.5005
R9362 VSS.n3278 VSS.n3277 4.5005
R9363 VSS.n3305 VSS.n3213 4.5005
R9364 VSS.n3304 VSS.n3303 4.5005
R9365 VSS.n3324 VSS.n3209 4.5005
R9366 VSS.n1873 VSS.n1872 4.5005
R9367 VSS.n278 VSS.n276 4.5005
R9368 VSS.n276 VSS.n275 4.5005
R9369 VSS.n3473 VSS.n3472 4.5005
R9370 VSS.n3471 VSS.n273 4.5005
R9371 VSS.n3470 VSS.n274 4.5005
R9372 VSS.n3469 VSS.n3468 4.5005
R9373 VSS.n3469 VSS.n279 4.5005
R9374 VSS.n284 VSS.n280 4.5005
R9375 VSS.n3467 VSS.n3466 4.5005
R9376 VSS.n283 VSS.n282 4.5005
R9377 VSS.n3511 VSS.n248 4.5005
R9378 VSS.n3512 VSS.n3511 4.5005
R9379 VSS.n3510 VSS.n247 4.5005
R9380 VSS.n3509 VSS.n246 4.5005
R9381 VSS.n3524 VSS.n3523 4.5005
R9382 VSS.n3526 VSS.n204 4.5005
R9383 VSS.n3527 VSS.n3526 4.5005
R9384 VSS.n3525 VSS.n203 4.5005
R9385 VSS.n245 VSS.n202 4.5005
R9386 VSS.n3590 VSS.n3589 4.5005
R9387 VSS.n3553 VSS.n3552 4.5005
R9388 VSS.n3545 VSS.n230 4.5005
R9389 VSS.n3560 VSS.n3559 4.5005
R9390 VSS.n368 VSS.n367 4.5005
R9391 VSS.n1880 VSS.n1879 4.5005
R9392 VSS.n3532 VSS.n238 4.5005
R9393 VSS.n207 VSS.n206 4.5005
R9394 VSS.n3463 VSS.n3462 4.5005
R9395 VSS.n3447 VSS.n3446 4.5005
R9396 VSS.n3456 VSS.n3455 4.5005
R9397 VSS.n2145 VSS.n2144 4.5005
R9398 VSS.n2199 VSS.n2198 4.5005
R9399 VSS.n2191 VSS.n2190 4.5005
R9400 VSS.n2207 VSS.n2206 4.5005
R9401 VSS.n1899 VSS.n1898 4.5005
R9402 VSS.n35 VSS.n34 4.5005
R9403 VSS.n254 VSS.n253 4.5005
R9404 VSS.n251 VSS.n250 4.5005
R9405 VSS.n3577 VSS.n3576 4.5005
R9406 VSS.n3397 VSS.n3396 4.5005
R9407 VSS.n3026 VSS.n3025 4.5005
R9408 VSS.n3357 VSS.n3356 4.5005
R9409 VSS.n3949 VSS.n3948 4.5005
R9410 VSS.n3942 VSS.n3941 4.5005
R9411 VSS.n2074 VSS.n2073 4.5005
R9412 VSS.n3515 VSS.n3514 4.5005
R9413 VSS.n335 VSS.n334 4.5005
R9414 VSS.n824 VSS.n823 4.5005
R9415 VSS.n3020 VSS.n3019 4.5005
R9416 VSS.n3363 VSS.n3362 4.5005
R9417 VSS.n3330 VSS.n3329 4.5005
R9418 VSS.n3033 VSS.n3032 4.5005
R9419 VSS.n3032 VSS.n3031 4.5005
R9420 VSS.n682 VSS.n681 4.5005
R9421 VSS.n3030 VSS.n680 4.5005
R9422 VSS.n3036 VSS.n3035 4.5005
R9423 VSS.n3723 VSS.n3722 4.5005
R9424 VSS.n3724 VSS.n3723 4.5005
R9425 VSS.n1008 VSS.n1007 4.5005
R9426 VSS.n1009 VSS.n1008 4.5005
R9427 VSS.n3041 VSS.n3040 4.5005
R9428 VSS.n3042 VSS.n3041 4.5005
R9429 VSS.n673 VSS.n670 4.5005
R9430 VSS.n674 VSS.n673 4.5005
R9431 VSS.n426 VSS.n423 4.5005
R9432 VSS.n429 VSS.n423 4.5005
R9433 VSS.n3338 VSS.n3335 4.5005
R9434 VSS.n3339 VSS.n3338 4.5005
R9435 VSS.n833 VSS.n830 4.5005
R9436 VSS.n3050 VSS.n540 4.5005
R9437 VSS.n3051 VSS.n3050 4.5005
R9438 VSS.n2993 VSS.n2992 4.5005
R9439 VSS.n2772 VSS.n2768 4.5005
R9440 VSS.n3591 VSS.n196 4.5005
R9441 VSS.n3703 VSS.n3700 4.5005
R9442 VSS.n3704 VSS.n3703 4.5005
R9443 VSS.n3699 VSS.n171 4.5005
R9444 VSS.n3713 VSS.n3710 4.5005
R9445 VSS.n3714 VSS.n3713 4.5005
R9446 VSS.n3635 VSS.n3632 4.5005
R9447 VSS.n3636 VSS.n3635 4.5005
R9448 VSS.n3625 VSS.n3622 4.5005
R9449 VSS.n3626 VSS.n3625 4.5005
R9450 VSS.n3615 VSS.n3612 4.5005
R9451 VSS.n3616 VSS.n3615 4.5005
R9452 VSS.n3605 VSS.n3602 4.5005
R9453 VSS.n3606 VSS.n3605 4.5005
R9454 VSS.n3595 VSS.n3592 4.5005
R9455 VSS.n3596 VSS.n3595 4.5005
R9456 VSS.n2775 VSS.n2769 4.5005
R9457 VSS.n2776 VSS.n2775 4.5005
R9458 VSS.n2986 VSS.n539 4.5005
R9459 VSS.n2985 VSS.n830 4.5005
R9460 VSS.n3037 VSS.n541 4.5005
R9461 VSS.n669 VSS.n545 4.5005
R9462 VSS.n3349 VSS.n3348 4.5005
R9463 VSS.n3334 VSS.n430 4.5005
R9464 VSS.n165 VSS.n162 4.5005
R9465 VSS.n3719 VSS.n162 4.5005
R9466 VSS.n1004 VSS.n1000 4.5005
R9467 VSS.n1004 VSS.n1001 4.5005
R9468 VSS.n544 VSS.n542 4.5005
R9469 VSS.n679 VSS.n542 4.5005
R9470 VSS.n655 VSS.n546 4.5005
R9471 VSS.n656 VSS.n546 4.5005
R9472 VSS.n3345 VSS.n427 4.5005
R9473 VSS.n3345 VSS.n3344 4.5005
R9474 VSS.n3203 VSS.n431 4.5005
R9475 VSS.n2989 VSS.n834 4.5005
R9476 VSS.n3048 VSS.n3047 4.5005
R9477 VSS.n3048 VSS.n538 4.5005
R9478 VSS.n2991 VSS.n2990 4.5005
R9479 VSS.n2774 VSS.n2773 4.5005
R9480 VSS.n3594 VSS.n3593 4.5005
R9481 VSS.n3604 VSS.n3603 4.5005
R9482 VSS.n3614 VSS.n3613 4.5005
R9483 VSS.n3624 VSS.n3623 4.5005
R9484 VSS.n1006 VSS.n1005 4.5005
R9485 VSS.n175 VSS.n172 4.5005
R9486 VSS.n3641 VSS.n172 4.5005
R9487 VSS.n3702 VSS.n3701 4.5005
R9488 VSS.n3721 VSS.n3720 4.5005
R9489 VSS.n3712 VSS.n3711 4.5005
R9490 VSS.n170 VSS.n167 4.5005
R9491 VSS.n3709 VSS.n167 4.5005
R9492 VSS.n3634 VSS.n3633 4.5005
R9493 VSS.n180 VSS.n177 4.5005
R9494 VSS.n3631 VSS.n177 4.5005
R9495 VSS.n185 VSS.n182 4.5005
R9496 VSS.n3621 VSS.n182 4.5005
R9497 VSS.n190 VSS.n187 4.5005
R9498 VSS.n3611 VSS.n187 4.5005
R9499 VSS.n195 VSS.n192 4.5005
R9500 VSS.n3601 VSS.n192 4.5005
R9501 VSS.n200 VSS.n197 4.5005
R9502 VSS.n201 VSS.n197 4.5005
R9503 VSS.n2770 VSS.n2766 4.5005
R9504 VSS.n2770 VSS.n2767 4.5005
R9505 VSS.n3049 VSS.n537 4.5005
R9506 VSS.n2989 VSS.n2988 4.5005
R9507 VSS.n3039 VSS.n3038 4.5005
R9508 VSS.n672 VSS.n671 4.5005
R9509 VSS.n3347 VSS.n3346 4.5005
R9510 VSS.n3337 VSS.n3336 4.5005
R9511 VSS.n3726 VSS.n163 4.5005
R9512 VSS.n3726 VSS.n3725 4.5005
R9513 VSS.n1011 VSS.n999 4.5005
R9514 VSS.n1011 VSS.n1010 4.5005
R9515 VSS.n3044 VSS.n543 4.5005
R9516 VSS.n3044 VSS.n3043 4.5005
R9517 VSS.n676 VSS.n547 4.5005
R9518 VSS.n676 VSS.n675 4.5005
R9519 VSS.n638 VSS.n425 4.5005
R9520 VSS.n638 VSS.n637 4.5005
R9521 VSS.n3341 VSS.n432 4.5005
R9522 VSS.n3341 VSS.n3340 4.5005
R9523 VSS.n2983 VSS.n832 4.5005
R9524 VSS.n3053 VSS.n536 4.5005
R9525 VSS.n3053 VSS.n3052 4.5005
R9526 VSS.n835 VSS.n831 4.5005
R9527 VSS.n2771 VSS.n2764 4.5005
R9528 VSS.n3600 VSS.n3599 4.5005
R9529 VSS.n3610 VSS.n3609 4.5005
R9530 VSS.n3620 VSS.n3619 4.5005
R9531 VSS.n3630 VSS.n3629 4.5005
R9532 VSS.n1002 VSS.n998 4.5005
R9533 VSS.n3706 VSS.n173 4.5005
R9534 VSS.n3706 VSS.n3705 4.5005
R9535 VSS.n3708 VSS.n3707 4.5005
R9536 VSS.n3728 VSS.n3727 4.5005
R9537 VSS.n3718 VSS.n3717 4.5005
R9538 VSS.n3716 VSS.n168 4.5005
R9539 VSS.n3716 VSS.n3715 4.5005
R9540 VSS.n3640 VSS.n3639 4.5005
R9541 VSS.n3638 VSS.n178 4.5005
R9542 VSS.n3638 VSS.n3637 4.5005
R9543 VSS.n3628 VSS.n183 4.5005
R9544 VSS.n3628 VSS.n3627 4.5005
R9545 VSS.n3618 VSS.n188 4.5005
R9546 VSS.n3618 VSS.n3617 4.5005
R9547 VSS.n3608 VSS.n193 4.5005
R9548 VSS.n3608 VSS.n3607 4.5005
R9549 VSS.n3598 VSS.n198 4.5005
R9550 VSS.n3598 VSS.n3597 4.5005
R9551 VSS.n2778 VSS.n2765 4.5005
R9552 VSS.n2778 VSS.n2777 4.5005
R9553 VSS.n2987 VSS.n535 4.5005
R9554 VSS.n2984 VSS.n2983 4.5005
R9555 VSS.n3046 VSS.n3045 4.5005
R9556 VSS.n678 VSS.n677 4.5005
R9557 VSS.n428 VSS.n424 4.5005
R9558 VSS.n3343 VSS.n3342 4.5005
R9559 VSS.n3733 VSS.n3730 4.5005
R9560 VSS.n3734 VSS.n3733 4.5005
R9561 VSS.n3732 VSS.n3731 4.5005
R9562 VSS.n160 VSS.n157 4.5005
R9563 VSS.n3729 VSS.n157 4.5005
R9564 VSS.n3738 VSS.n3737 4.5005
R9565 VSS.n3736 VSS.n158 4.5005
R9566 VSS.n3736 VSS.n3735 4.5005
R9567 VSS.n2686 VSS.n159 4.5005
R9568 VSS.n2683 VSS.n2682 4.5005
R9569 VSS.n2682 VSS.n1093 4.5005
R9570 VSS.n2692 VSS.n2691 4.5005
R9571 VSS.n2691 VSS.n1088 4.5005
R9572 VSS.n1016 VSS.n1013 4.5005
R9573 VSS.n1017 VSS.n1016 4.5005
R9574 VSS.n3068 VSS.n528 4.5005
R9575 VSS.n3069 VSS.n3068 4.5005
R9576 VSS.n551 VSS.n548 4.5005
R9577 VSS.n554 VSS.n548 4.5005
R9578 VSS.n643 VSS.n640 4.5005
R9579 VSS.n644 VSS.n643 4.5005
R9580 VSS.n436 VSS.n433 4.5005
R9581 VSS.n3197 VSS.n433 4.5005
R9582 VSS.n839 VSS.n836 4.5005
R9583 VSS.n3054 VSS.n530 4.5005
R9584 VSS.n3054 VSS.n533 4.5005
R9585 VSS.n2982 VSS.n2981 4.5005
R9586 VSS.n2783 VSS.n2782 4.5005
R9587 VSS.n2758 VSS.n199 4.5005
R9588 VSS.n2749 VSS.n194 4.5005
R9589 VSS.n2740 VSS.n189 4.5005
R9590 VSS.n2731 VSS.n184 4.5005
R9591 VSS.n1012 VSS.n949 4.5005
R9592 VSS.n2710 VSS.n2709 4.5005
R9593 VSS.n2709 VSS.n1078 4.5005
R9594 VSS.n2713 VSS.n174 4.5005
R9595 VSS.n2695 VSS.n164 4.5005
R9596 VSS.n2704 VSS.n169 4.5005
R9597 VSS.n2701 VSS.n2700 4.5005
R9598 VSS.n2700 VSS.n1083 4.5005
R9599 VSS.n2722 VSS.n179 4.5005
R9600 VSS.n2719 VSS.n2718 4.5005
R9601 VSS.n2718 VSS.n1073 4.5005
R9602 VSS.n2728 VSS.n2727 4.5005
R9603 VSS.n2727 VSS.n1068 4.5005
R9604 VSS.n2737 VSS.n2736 4.5005
R9605 VSS.n2736 VSS.n1063 4.5005
R9606 VSS.n2746 VSS.n2745 4.5005
R9607 VSS.n2745 VSS.n1058 4.5005
R9608 VSS.n2755 VSS.n2754 4.5005
R9609 VSS.n2754 VSS.n1053 4.5005
R9610 VSS.n2781 VSS.n2780 4.5005
R9611 VSS.n2781 VSS.n1048 4.5005
R9612 VSS.n3056 VSS.n3055 4.5005
R9613 VSS.n2976 VSS.n836 4.5005
R9614 VSS.n3065 VSS.n527 4.5005
R9615 VSS.n654 VSS.n653 4.5005
R9616 VSS.n639 VSS.n555 4.5005
R9617 VSS.n3202 VSS.n3201 4.5005
R9618 VSS.n2685 VSS.n1094 4.5005
R9619 VSS.n2689 VSS.n1095 4.5005
R9620 VSS.n2690 VSS.n2689 4.5005
R9621 VSS.n2698 VSS.n1090 4.5005
R9622 VSS.n2699 VSS.n2698 4.5005
R9623 VSS.n996 VSS.n950 4.5005
R9624 VSS.n997 VSS.n950 4.5005
R9625 VSS.n529 VSS.n525 4.5005
R9626 VSS.n529 VSS.n526 4.5005
R9627 VSS.n650 VSS.n552 4.5005
R9628 VSS.n650 VSS.n649 4.5005
R9629 VSS.n635 VSS.n556 4.5005
R9630 VSS.n636 VSS.n556 4.5005
R9631 VSS.n3198 VSS.n437 4.5005
R9632 VSS.n2978 VSS.n840 4.5005
R9633 VSS.n3063 VSS.n3062 4.5005
R9634 VSS.n3062 VSS.n3061 4.5005
R9635 VSS.n2980 VSS.n2979 4.5005
R9636 VSS.n2763 VSS.n1049 4.5005
R9637 VSS.n2757 VSS.n1054 4.5005
R9638 VSS.n2748 VSS.n1059 4.5005
R9639 VSS.n2739 VSS.n1064 4.5005
R9640 VSS.n2730 VSS.n1069 4.5005
R9641 VSS.n1015 VSS.n1014 4.5005
R9642 VSS.n2716 VSS.n1080 4.5005
R9643 VSS.n2717 VSS.n2716 4.5005
R9644 VSS.n2712 VSS.n1079 4.5005
R9645 VSS.n2694 VSS.n1089 4.5005
R9646 VSS.n2703 VSS.n1084 4.5005
R9647 VSS.n2707 VSS.n1085 4.5005
R9648 VSS.n2708 VSS.n2707 4.5005
R9649 VSS.n2721 VSS.n1074 4.5005
R9650 VSS.n2725 VSS.n1075 4.5005
R9651 VSS.n2726 VSS.n2725 4.5005
R9652 VSS.n2734 VSS.n1070 4.5005
R9653 VSS.n2735 VSS.n2734 4.5005
R9654 VSS.n2743 VSS.n1065 4.5005
R9655 VSS.n2744 VSS.n2743 4.5005
R9656 VSS.n2752 VSS.n1060 4.5005
R9657 VSS.n2753 VSS.n2752 4.5005
R9658 VSS.n2761 VSS.n1055 4.5005
R9659 VSS.n2762 VSS.n2761 4.5005
R9660 VSS.n2786 VSS.n1050 4.5005
R9661 VSS.n2787 VSS.n2786 4.5005
R9662 VSS.n3057 VSS.n531 4.5005
R9663 VSS.n2978 VSS.n2977 4.5005
R9664 VSS.n3067 VSS.n3066 4.5005
R9665 VSS.n652 VSS.n651 4.5005
R9666 VSS.n642 VSS.n641 4.5005
R9667 VSS.n3200 VSS.n3199 4.5005
R9668 VSS.n2688 VSS.n2687 4.5005
R9669 VSS.n2684 VSS.n2681 4.5005
R9670 VSS.n2681 VSS.n2680 4.5005
R9671 VSS.n2693 VSS.n1092 4.5005
R9672 VSS.n1092 VSS.n1091 4.5005
R9673 VSS.n1019 VSS.n951 4.5005
R9674 VSS.n1019 VSS.n1018 4.5005
R9675 VSS.n3071 VSS.n524 4.5005
R9676 VSS.n3071 VSS.n3070 4.5005
R9677 VSS.n576 VSS.n550 4.5005
R9678 VSS.n576 VSS.n575 4.5005
R9679 VSS.n646 VSS.n557 4.5005
R9680 VSS.n646 VSS.n645 4.5005
R9681 VSS.n3195 VSS.n435 4.5005
R9682 VSS.n3196 VSS.n3195 4.5005
R9683 VSS.n2974 VSS.n838 4.5005
R9684 VSS.n3060 VSS.n3059 4.5005
R9685 VSS.n3059 VSS.n3058 4.5005
R9686 VSS.n841 VSS.n837 4.5005
R9687 VSS.n2785 VSS.n2784 4.5005
R9688 VSS.n2760 VSS.n2759 4.5005
R9689 VSS.n2751 VSS.n2750 4.5005
R9690 VSS.n2742 VSS.n2741 4.5005
R9691 VSS.n2733 VSS.n2732 4.5005
R9692 VSS.n1021 VSS.n1020 4.5005
R9693 VSS.n2711 VSS.n1082 4.5005
R9694 VSS.n1082 VSS.n1081 4.5005
R9695 VSS.n2715 VSS.n2714 4.5005
R9696 VSS.n2697 VSS.n2696 4.5005
R9697 VSS.n2706 VSS.n2705 4.5005
R9698 VSS.n2702 VSS.n1087 4.5005
R9699 VSS.n1087 VSS.n1086 4.5005
R9700 VSS.n2724 VSS.n2723 4.5005
R9701 VSS.n2720 VSS.n1077 4.5005
R9702 VSS.n1077 VSS.n1076 4.5005
R9703 VSS.n2729 VSS.n1072 4.5005
R9704 VSS.n1072 VSS.n1071 4.5005
R9705 VSS.n2738 VSS.n1067 4.5005
R9706 VSS.n1067 VSS.n1066 4.5005
R9707 VSS.n2747 VSS.n1062 4.5005
R9708 VSS.n1062 VSS.n1061 4.5005
R9709 VSS.n2756 VSS.n1057 4.5005
R9710 VSS.n1057 VSS.n1056 4.5005
R9711 VSS.n2779 VSS.n1052 4.5005
R9712 VSS.n1052 VSS.n1051 4.5005
R9713 VSS.n534 VSS.n532 4.5005
R9714 VSS.n2975 VSS.n2974 4.5005
R9715 VSS.n3064 VSS.n523 4.5005
R9716 VSS.n553 VSS.n549 4.5005
R9717 VSS.n648 VSS.n647 4.5005
R9718 VSS.n438 VSS.n434 4.5005
R9719 VSS.n3861 VSS.n3860 4.5005
R9720 VSS.n113 VSS.n110 4.5005
R9721 VSS.n114 VSS.n110 4.5005
R9722 VSS.n3859 VSS.n3858 4.5005
R9723 VSS.n3857 VSS.n3856 4.5005
R9724 VSS.n3857 VSS.n101 4.5005
R9725 VSS.n3854 VSS.n112 4.5005
R9726 VSS.n3855 VSS.n3854 4.5005
R9727 VSS.n3867 VSS.n3866 4.5005
R9728 VSS.n3867 VSS.n107 4.5005
R9729 VSS.n3864 VSS.n108 4.5005
R9730 VSS.n3870 VSS.n109 4.5005
R9731 VSS.n3871 VSS.n3870 4.5005
R9732 VSS.n3865 VSS.n3863 4.5005
R9733 VSS.n3863 VSS.n3862 4.5005
R9734 VSS.n3853 VSS.n3852 4.5005
R9735 VSS.n3853 VSS.n115 4.5005
R9736 VSS.n3836 VSS.n116 4.5005
R9737 VSS.n3851 VSS.n3850 4.5005
R9738 VSS.n3835 VSS.n3834 4.5005
R9739 VSS.n3846 VSS.n3845 4.5005
R9740 VSS.n75 VSS.n74 4.5005
R9741 VSS.n74 VSS.n73 4.5005
R9742 VSS.n3918 VSS.n3917 4.5005
R9743 VSS.n3916 VSS.n71 4.5005
R9744 VSS.n3915 VSS.n72 4.5005
R9745 VSS.n3886 VSS.n3885 4.5005
R9746 VSS.n3884 VSS.n3883 4.5005
R9747 VSS.n3884 VSS.n96 4.5005
R9748 VSS.n102 VSS.n97 4.5005
R9749 VSS.n3889 VSS.n98 4.5005
R9750 VSS.n3890 VSS.n3889 4.5005
R9751 VSS.n3888 VSS.n3887 4.5005
R9752 VSS.n3882 VSS.n100 4.5005
R9753 VSS.n100 VSS.n99 4.5005
R9754 VSS.n3878 VSS.n3874 4.5005
R9755 VSS.n3879 VSS.n3878 4.5005
R9756 VSS.n3877 VSS.n3876 4.5005
R9757 VSS.n3875 VSS.n105 4.5005
R9758 VSS.n3875 VSS.n106 4.5005
R9759 VSS.n3872 VSS.n103 4.5005
R9760 VSS.n3881 VSS.n104 4.5005
R9761 VSS.n3881 VSS.n3880 4.5005
R9762 VSS.n3914 VSS.n3913 4.5005
R9763 VSS.n3833 VSS.n3832 4.5005
R9764 VSS.n121 VSS.n118 4.5005
R9765 VSS.n3827 VSS.n118 4.5005
R9766 VSS.n2679 VSS.n2678 4.5005
R9767 VSS.n1099 VSS.n1096 4.5005
R9768 VSS.n1102 VSS.n1096 4.5005
R9769 VSS.n2668 VSS.n2665 4.5005
R9770 VSS.n2669 VSS.n2668 4.5005
R9771 VSS.n969 VSS.n952 4.5005
R9772 VSS.n989 VSS.n952 4.5005
R9773 VSS.n3076 VSS.n3073 4.5005
R9774 VSS.n3077 VSS.n3076 4.5005
R9775 VSS.n584 VSS.n578 4.5005
R9776 VSS.n585 VSS.n584 4.5005
R9777 VSS.n561 VSS.n558 4.5005
R9778 VSS.n628 VSS.n558 4.5005
R9779 VSS.n442 VSS.n439 4.5005
R9780 VSS.n3189 VSS.n439 4.5005
R9781 VSS.n845 VSS.n842 4.5005
R9782 VSS.n3085 VSS.n517 4.5005
R9783 VSS.n3086 VSS.n3085 4.5005
R9784 VSS.n2973 VSS.n2972 4.5005
R9785 VSS.n2556 VSS.n1159 4.5005
R9786 VSS.n2567 VSS.n1154 4.5005
R9787 VSS.n2578 VSS.n1149 4.5005
R9788 VSS.n2589 VSS.n1144 4.5005
R9789 VSS.n2600 VSS.n1139 4.5005
R9790 VSS.n995 VSS.n994 4.5005
R9791 VSS.n2646 VSS.n2643 4.5005
R9792 VSS.n2647 VSS.n2646 4.5005
R9793 VSS.n2642 VSS.n1113 4.5005
R9794 VSS.n79 VSS.n76 4.5005
R9795 VSS.n82 VSS.n76 4.5005
R9796 VSS.n2664 VSS.n1103 4.5005
R9797 VSS.n2653 VSS.n1108 4.5005
R9798 VSS.n2657 VSS.n2654 4.5005
R9799 VSS.n2658 VSS.n2657 4.5005
R9800 VSS.n2615 VSS.n2614 4.5005
R9801 VSS.n1135 VSS.n1132 4.5005
R9802 VSS.n1138 VSS.n1132 4.5005
R9803 VSS.n2604 VSS.n2601 4.5005
R9804 VSS.n2605 VSS.n2604 4.5005
R9805 VSS.n2593 VSS.n2590 4.5005
R9806 VSS.n2594 VSS.n2593 4.5005
R9807 VSS.n2582 VSS.n2579 4.5005
R9808 VSS.n2583 VSS.n2582 4.5005
R9809 VSS.n2571 VSS.n2568 4.5005
R9810 VSS.n2572 VSS.n2571 4.5005
R9811 VSS.n2560 VSS.n2557 4.5005
R9812 VSS.n2561 VSS.n2560 4.5005
R9813 VSS.n2966 VSS.n516 4.5005
R9814 VSS.n2965 VSS.n842 4.5005
R9815 VSS.n3072 VSS.n518 4.5005
R9816 VSS.n581 VSS.n577 4.5005
R9817 VSS.n634 VSS.n633 4.5005
R9818 VSS.n3194 VSS.n3193 4.5005
R9819 VSS.n3912 VSS.n3911 4.5005
R9820 VSS.n3831 VSS.n3830 4.5005
R9821 VSS.n3829 VSS.n122 4.5005
R9822 VSS.n3829 VSS.n3828 4.5005
R9823 VSS.n2677 VSS.n2676 4.5005
R9824 VSS.n2675 VSS.n1100 4.5005
R9825 VSS.n2675 VSS.n2674 4.5005
R9826 VSS.n1107 VSS.n1104 4.5005
R9827 VSS.n2663 VSS.n1104 4.5005
R9828 VSS.n991 VSS.n970 4.5005
R9829 VSS.n991 VSS.n990 4.5005
R9830 VSS.n521 VSS.n519 4.5005
R9831 VSS.n522 VSS.n519 4.5005
R9832 VSS.n579 VSS.n573 4.5005
R9833 VSS.n579 VSS.n574 4.5005
R9834 VSS.n630 VSS.n562 4.5005
R9835 VSS.n630 VSS.n629 4.5005
R9836 VSS.n3190 VSS.n443 4.5005
R9837 VSS.n2969 VSS.n846 4.5005
R9838 VSS.n3083 VSS.n3082 4.5005
R9839 VSS.n3083 VSS.n515 4.5005
R9840 VSS.n2971 VSS.n2970 4.5005
R9841 VSS.n2559 VSS.n2558 4.5005
R9842 VSS.n2570 VSS.n2569 4.5005
R9843 VSS.n2581 VSS.n2580 4.5005
R9844 VSS.n2592 VSS.n2591 4.5005
R9845 VSS.n2603 VSS.n2602 4.5005
R9846 VSS.n993 VSS.n992 4.5005
R9847 VSS.n1117 VSS.n1114 4.5005
R9848 VSS.n1118 VSS.n1114 4.5005
R9849 VSS.n2645 VSS.n2644 4.5005
R9850 VSS.n3910 VSS.n80 4.5005
R9851 VSS.n3910 VSS.n3909 4.5005
R9852 VSS.n2667 VSS.n2666 4.5005
R9853 VSS.n2656 VSS.n2655 4.5005
R9854 VSS.n1112 VSS.n1109 4.5005
R9855 VSS.n2652 VSS.n1109 4.5005
R9856 VSS.n2613 VSS.n2612 4.5005
R9857 VSS.n2611 VSS.n1136 4.5005
R9858 VSS.n2611 VSS.n2610 4.5005
R9859 VSS.n1143 VSS.n1140 4.5005
R9860 VSS.n2599 VSS.n1140 4.5005
R9861 VSS.n1148 VSS.n1145 4.5005
R9862 VSS.n2588 VSS.n1145 4.5005
R9863 VSS.n1153 VSS.n1150 4.5005
R9864 VSS.n2577 VSS.n1150 4.5005
R9865 VSS.n1158 VSS.n1155 4.5005
R9866 VSS.n2566 VSS.n1155 4.5005
R9867 VSS.n2555 VSS.n1160 4.5005
R9868 VSS.n1160 VSS.n935 4.5005
R9869 VSS.n3084 VSS.n514 4.5005
R9870 VSS.n2969 VSS.n2968 4.5005
R9871 VSS.n3075 VSS.n3074 4.5005
R9872 VSS.n583 VSS.n582 4.5005
R9873 VSS.n632 VSS.n631 4.5005
R9874 VSS.n3192 VSS.n3191 4.5005
R9875 VSS.n81 VSS.n77 4.5005
R9876 VSS.n3825 VSS.n120 4.5005
R9877 VSS.n3826 VSS.n3825 4.5005
R9878 VSS.n1101 VSS.n1097 4.5005
R9879 VSS.n2337 VSS.n1098 4.5005
R9880 VSS.n2337 VSS.n2336 4.5005
R9881 VSS.n2671 VSS.n1105 4.5005
R9882 VSS.n2671 VSS.n2670 4.5005
R9883 VSS.n987 VSS.n968 4.5005
R9884 VSS.n988 VSS.n987 4.5005
R9885 VSS.n3079 VSS.n520 4.5005
R9886 VSS.n3079 VSS.n3078 4.5005
R9887 VSS.n587 VSS.n572 4.5005
R9888 VSS.n587 VSS.n586 4.5005
R9889 VSS.n626 VSS.n560 4.5005
R9890 VSS.n627 VSS.n626 4.5005
R9891 VSS.n3187 VSS.n441 4.5005
R9892 VSS.n3188 VSS.n3187 4.5005
R9893 VSS.n2963 VSS.n844 4.5005
R9894 VSS.n3088 VSS.n513 4.5005
R9895 VSS.n3088 VSS.n3087 4.5005
R9896 VSS.n847 VSS.n843 4.5005
R9897 VSS.n2565 VSS.n2564 4.5005
R9898 VSS.n2576 VSS.n2575 4.5005
R9899 VSS.n2587 VSS.n2586 4.5005
R9900 VSS.n2598 VSS.n2597 4.5005
R9901 VSS.n2609 VSS.n2608 4.5005
R9902 VSS.n971 VSS.n967 4.5005
R9903 VSS.n2649 VSS.n1115 4.5005
R9904 VSS.n2649 VSS.n2648 4.5005
R9905 VSS.n2651 VSS.n2650 4.5005
R9906 VSS.n3808 VSS.n78 4.5005
R9907 VSS.n3808 VSS.n3807 4.5005
R9908 VSS.n2673 VSS.n2672 4.5005
R9909 VSS.n2662 VSS.n2661 4.5005
R9910 VSS.n2660 VSS.n1110 4.5005
R9911 VSS.n2660 VSS.n2659 4.5005
R9912 VSS.n1137 VSS.n1133 4.5005
R9913 VSS.n2376 VSS.n1134 4.5005
R9914 VSS.n2376 VSS.n2375 4.5005
R9915 VSS.n2607 VSS.n1141 4.5005
R9916 VSS.n2607 VSS.n2606 4.5005
R9917 VSS.n2596 VSS.n1146 4.5005
R9918 VSS.n2596 VSS.n2595 4.5005
R9919 VSS.n2585 VSS.n1151 4.5005
R9920 VSS.n2585 VSS.n2584 4.5005
R9921 VSS.n2574 VSS.n1156 4.5005
R9922 VSS.n2574 VSS.n2573 4.5005
R9923 VSS.n2563 VSS.n1161 4.5005
R9924 VSS.n2563 VSS.n2562 4.5005
R9925 VSS.n2967 VSS.n512 4.5005
R9926 VSS.n2964 VSS.n2963 4.5005
R9927 VSS.n3081 VSS.n3080 4.5005
R9928 VSS.n580 VSS.n571 4.5005
R9929 VSS.n563 VSS.n559 4.5005
R9930 VSS.n444 VSS.n440 4.5005
R9931 VSS.n3899 VSS.n83 4.5005
R9932 VSS.n3903 VSS.n3900 4.5005
R9933 VSS.n3904 VSS.n3903 4.5005
R9934 VSS.n3902 VSS.n3901 4.5005
R9935 VSS.n87 VSS.n84 4.5005
R9936 VSS.n88 VSS.n84 4.5005
R9937 VSS.n3908 VSS.n3907 4.5005
R9938 VSS.n3906 VSS.n85 4.5005
R9939 VSS.n3906 VSS.n3905 4.5005
R9940 VSS.n3892 VSS.n93 4.5005
R9941 VSS.n3895 VSS.n94 4.5005
R9942 VSS.n3896 VSS.n3895 4.5005
R9943 VSS.n3894 VSS.n3893 4.5005
R9944 VSS.n95 VSS.n91 4.5005
R9945 VSS.n95 VSS.n92 4.5005
R9946 VSS.n3891 VSS.n89 4.5005
R9947 VSS.n3898 VSS.n90 4.5005
R9948 VSS.n3898 VSS.n3897 4.5005
R9949 VSS.n3748 VSS.n3747 4.5005
R9950 VSS.n3748 VSS.n3740 4.5005
R9951 VSS.n3745 VSS.n3741 4.5005
R9952 VSS.n3752 VSS.n3742 4.5005
R9953 VSS.n3753 VSS.n3752 4.5005
R9954 VSS.n3751 VSS.n3750 4.5005
R9955 VSS.n3746 VSS.n3744 4.5005
R9956 VSS.n3744 VSS.n3743 4.5005
R9957 VSS.n134 VSS.n86 4.5005
R9958 VSS.n3809 VSS.n129 4.5005
R9959 VSS.n3824 VSS.n3823 4.5005
R9960 VSS.n126 VSS.n123 4.5005
R9961 VSS.n128 VSS.n123 4.5005
R9962 VSS.n2342 VSS.n2341 4.5005
R9963 VSS.n2340 VSS.n2339 4.5005
R9964 VSS.n2340 VSS.n1278 4.5005
R9965 VSS.n2348 VSS.n2347 4.5005
R9966 VSS.n2347 VSS.n1273 4.5005
R9967 VSS.n975 VSS.n972 4.5005
R9968 VSS.n980 VSS.n972 4.5005
R9969 VSS.n3103 VSS.n504 4.5005
R9970 VSS.n3104 VSS.n3103 4.5005
R9971 VSS.n590 VSS.n589 4.5005
R9972 VSS.n590 VSS.n565 4.5005
R9973 VSS.n599 VSS.n564 4.5005
R9974 VSS.n619 VSS.n564 4.5005
R9975 VSS.n448 VSS.n445 4.5005
R9976 VSS.n3181 VSS.n445 4.5005
R9977 VSS.n851 VSS.n848 4.5005
R9978 VSS.n3089 VSS.n506 4.5005
R9979 VSS.n3089 VSS.n509 4.5005
R9980 VSS.n2962 VSS.n2961 4.5005
R9981 VSS.n2554 VSS.n2553 4.5005
R9982 VSS.n2414 VSS.n1157 4.5005
R9983 VSS.n2408 VSS.n1152 4.5005
R9984 VSS.n2399 VSS.n1147 4.5005
R9985 VSS.n2390 VSS.n1142 4.5005
R9986 VSS.n986 VSS.n985 4.5005
R9987 VSS.n2366 VSS.n2365 4.5005
R9988 VSS.n2365 VSS.n1263 4.5005
R9989 VSS.n2369 VSS.n1116 4.5005
R9990 VSS.n3813 VSS.n3810 4.5005
R9991 VSS.n3814 VSS.n3813 4.5005
R9992 VSS.n3800 VSS.n3797 4.5005
R9993 VSS.n3801 VSS.n3800 4.5005
R9994 VSS.n2351 VSS.n1106 4.5005
R9995 VSS.n2360 VSS.n1111 4.5005
R9996 VSS.n2357 VSS.n2356 4.5005
R9997 VSS.n2356 VSS.n1268 4.5005
R9998 VSS.n2381 VSS.n2380 4.5005
R9999 VSS.n2379 VSS.n2378 4.5005
R10000 VSS.n2379 VSS.n1258 4.5005
R10001 VSS.n2387 VSS.n2386 4.5005
R10002 VSS.n2386 VSS.n1253 4.5005
R10003 VSS.n2396 VSS.n2395 4.5005
R10004 VSS.n2395 VSS.n1248 4.5005
R10005 VSS.n2405 VSS.n2404 4.5005
R10006 VSS.n2404 VSS.n1243 4.5005
R10007 VSS.n2417 VSS.n1241 4.5005
R10008 VSS.n2418 VSS.n2417 4.5005
R10009 VSS.n1165 VSS.n1162 4.5005
R10010 VSS.n1168 VSS.n1162 4.5005
R10011 VSS.n3091 VSS.n3090 4.5005
R10012 VSS.n2956 VSS.n848 4.5005
R10013 VSS.n3100 VSS.n503 4.5005
R10014 VSS.n592 VSS.n591 4.5005
R10015 VSS.n625 VSS.n624 4.5005
R10016 VSS.n3186 VSS.n3185 4.5005
R10017 VSS.n3799 VSS.n3798 4.5005
R10018 VSS.n3812 VSS.n3811 4.5005
R10019 VSS.n3822 VSS.n3821 4.5005
R10020 VSS.n3820 VSS.n127 4.5005
R10021 VSS.n3820 VSS.n3819 4.5005
R10022 VSS.n2335 VSS.n1279 4.5005
R10023 VSS.n2345 VSS.n1280 4.5005
R10024 VSS.n2346 VSS.n2345 4.5005
R10025 VSS.n2354 VSS.n1275 4.5005
R10026 VSS.n2355 VSS.n2354 4.5005
R10027 VSS.n982 VSS.n976 4.5005
R10028 VSS.n982 VSS.n981 4.5005
R10029 VSS.n505 VSS.n501 4.5005
R10030 VSS.n505 VSS.n502 4.5005
R10031 VSS.n595 VSS.n567 4.5005
R10032 VSS.n596 VSS.n595 4.5005
R10033 VSS.n621 VSS.n600 4.5005
R10034 VSS.n621 VSS.n620 4.5005
R10035 VSS.n3182 VSS.n449 4.5005
R10036 VSS.n2958 VSS.n852 4.5005
R10037 VSS.n3098 VSS.n3097 4.5005
R10038 VSS.n3097 VSS.n3096 4.5005
R10039 VSS.n2960 VSS.n2959 4.5005
R10040 VSS.n2552 VSS.n2551 4.5005
R10041 VSS.n2416 VSS.n2415 4.5005
R10042 VSS.n2407 VSS.n1244 4.5005
R10043 VSS.n2398 VSS.n1249 4.5005
R10044 VSS.n2389 VSS.n1254 4.5005
R10045 VSS.n984 VSS.n983 4.5005
R10046 VSS.n2372 VSS.n1265 4.5005
R10047 VSS.n2373 VSS.n2372 4.5005
R10048 VSS.n2368 VSS.n1264 4.5005
R10049 VSS.n133 VSS.n130 4.5005
R10050 VSS.n3806 VSS.n130 4.5005
R10051 VSS.n138 VSS.n135 4.5005
R10052 VSS.n3796 VSS.n135 4.5005
R10053 VSS.n2350 VSS.n1274 4.5005
R10054 VSS.n2359 VSS.n1269 4.5005
R10055 VSS.n2363 VSS.n1270 4.5005
R10056 VSS.n2364 VSS.n2363 4.5005
R10057 VSS.n2374 VSS.n1259 4.5005
R10058 VSS.n2384 VSS.n1260 4.5005
R10059 VSS.n2385 VSS.n2384 4.5005
R10060 VSS.n2393 VSS.n1255 4.5005
R10061 VSS.n2394 VSS.n2393 4.5005
R10062 VSS.n2402 VSS.n1250 4.5005
R10063 VSS.n2403 VSS.n2402 4.5005
R10064 VSS.n2411 VSS.n1245 4.5005
R10065 VSS.n2412 VSS.n2411 4.5005
R10066 VSS.n1242 VSS.n1239 4.5005
R10067 VSS.n1242 VSS.n1240 4.5005
R10068 VSS.n2550 VSS.n1166 4.5005
R10069 VSS.n2550 VSS.n2549 4.5005
R10070 VSS.n3092 VSS.n507 4.5005
R10071 VSS.n2958 VSS.n2957 4.5005
R10072 VSS.n3102 VSS.n3101 4.5005
R10073 VSS.n570 VSS.n566 4.5005
R10074 VSS.n623 VSS.n622 4.5005
R10075 VSS.n3184 VSS.n3183 4.5005
R10076 VSS.n3805 VSS.n3804 4.5005
R10077 VSS.n3818 VSS.n3817 4.5005
R10078 VSS.n1615 VSS.n125 4.5005
R10079 VSS.n1615 VSS.n1614 4.5005
R10080 VSS.n2344 VSS.n2343 4.5005
R10081 VSS.n2338 VSS.n2334 4.5005
R10082 VSS.n2334 VSS.n2333 4.5005
R10083 VSS.n2349 VSS.n1277 4.5005
R10084 VSS.n1277 VSS.n1276 4.5005
R10085 VSS.n978 VSS.n974 4.5005
R10086 VSS.n979 VSS.n978 4.5005
R10087 VSS.n3106 VSS.n500 4.5005
R10088 VSS.n3106 VSS.n3105 4.5005
R10089 VSS.n588 VSS.n569 4.5005
R10090 VSS.n569 VSS.n568 4.5005
R10091 VSS.n617 VSS.n598 4.5005
R10092 VSS.n618 VSS.n617 4.5005
R10093 VSS.n3179 VSS.n447 4.5005
R10094 VSS.n3180 VSS.n3179 4.5005
R10095 VSS.n2954 VSS.n850 4.5005
R10096 VSS.n3095 VSS.n3094 4.5005
R10097 VSS.n3094 VSS.n3093 4.5005
R10098 VSS.n853 VSS.n849 4.5005
R10099 VSS.n1167 VSS.n1163 4.5005
R10100 VSS.n2413 VSS.n1237 4.5005
R10101 VSS.n2410 VSS.n2409 4.5005
R10102 VSS.n2401 VSS.n2400 4.5005
R10103 VSS.n2392 VSS.n2391 4.5005
R10104 VSS.n977 VSS.n973 4.5005
R10105 VSS.n2367 VSS.n1267 4.5005
R10106 VSS.n1267 VSS.n1266 4.5005
R10107 VSS.n2371 VSS.n2370 4.5005
R10108 VSS.n3816 VSS.n131 4.5005
R10109 VSS.n3816 VSS.n3815 4.5005
R10110 VSS.n3803 VSS.n136 4.5005
R10111 VSS.n3803 VSS.n3802 4.5005
R10112 VSS.n2353 VSS.n2352 4.5005
R10113 VSS.n2362 VSS.n2361 4.5005
R10114 VSS.n2358 VSS.n1272 4.5005
R10115 VSS.n1272 VSS.n1271 4.5005
R10116 VSS.n2383 VSS.n2382 4.5005
R10117 VSS.n2377 VSS.n1262 4.5005
R10118 VSS.n1262 VSS.n1261 4.5005
R10119 VSS.n2388 VSS.n1257 4.5005
R10120 VSS.n1257 VSS.n1256 4.5005
R10121 VSS.n2397 VSS.n1252 4.5005
R10122 VSS.n1252 VSS.n1251 4.5005
R10123 VSS.n2406 VSS.n1247 4.5005
R10124 VSS.n1247 VSS.n1246 4.5005
R10125 VSS.n2420 VSS.n1238 4.5005
R10126 VSS.n2420 VSS.n2419 4.5005
R10127 VSS.n1226 VSS.n1164 4.5005
R10128 VSS.n1226 VSS.n1225 4.5005
R10129 VSS.n511 VSS.n508 4.5005
R10130 VSS.n2955 VSS.n2954 4.5005
R10131 VSS.n3099 VSS.n499 4.5005
R10132 VSS.n594 VSS.n593 4.5005
R10133 VSS.n601 VSS.n597 4.5005
R10134 VSS.n450 VSS.n446 4.5005
R10135 VSS.n3786 VSS.n139 4.5005
R10136 VSS.n3790 VSS.n3787 4.5005
R10137 VSS.n3791 VSS.n3790 4.5005
R10138 VSS.n3789 VSS.n3788 4.5005
R10139 VSS.n143 VSS.n140 4.5005
R10140 VSS.n144 VSS.n140 4.5005
R10141 VSS.n3795 VSS.n3794 4.5005
R10142 VSS.n3793 VSS.n141 4.5005
R10143 VSS.n3793 VSS.n3792 4.5005
R10144 VSS.n3779 VSS.n3775 4.5005
R10145 VSS.n3782 VSS.n3776 4.5005
R10146 VSS.n3783 VSS.n3782 4.5005
R10147 VSS.n3781 VSS.n3780 4.5005
R10148 VSS.n3777 VSS.n147 4.5005
R10149 VSS.n3777 VSS.n148 4.5005
R10150 VSS.n3778 VSS.n145 4.5005
R10151 VSS.n3785 VSS.n146 4.5005
R10152 VSS.n3785 VSS.n3784 4.5005
R10153 VSS.n3768 VSS.n3764 4.5005
R10154 VSS.n3771 VSS.n3765 4.5005
R10155 VSS.n3772 VSS.n3771 4.5005
R10156 VSS.n3770 VSS.n3769 4.5005
R10157 VSS.n3766 VSS.n151 4.5005
R10158 VSS.n3766 VSS.n152 4.5005
R10159 VSS.n3767 VSS.n149 4.5005
R10160 VSS.n3774 VSS.n150 4.5005
R10161 VSS.n3774 VSS.n3773 4.5005
R10162 VSS.n3760 VSS.n3756 4.5005
R10163 VSS.n3761 VSS.n3760 4.5005
R10164 VSS.n3759 VSS.n3758 4.5005
R10165 VSS.n3757 VSS.n155 4.5005
R10166 VSS.n3757 VSS.n3739 4.5005
R10167 VSS.n3754 VSS.n153 4.5005
R10168 VSS.n3763 VSS.n154 4.5005
R10169 VSS.n3763 VSS.n3762 4.5005
R10170 VSS.n1643 VSS.n142 4.5005
R10171 VSS.n1637 VSS.n137 4.5005
R10172 VSS.n1628 VSS.n132 4.5005
R10173 VSS.n1620 VSS.n1619 4.5005
R10174 VSS.n1618 VSS.n1617 4.5005
R10175 VSS.n1618 VSS.n1417 4.5005
R10176 VSS.n2332 VSS.n2331 4.5005
R10177 VSS.n1284 VSS.n1281 4.5005
R10178 VSS.n1287 VSS.n1281 4.5005
R10179 VSS.n2321 VSS.n2318 4.5005
R10180 VSS.n2322 VSS.n2321 4.5005
R10181 VSS.n2843 VSS.n900 4.5005
R10182 VSS.n2844 VSS.n2843 4.5005
R10183 VSS.n3109 VSS.n3108 4.5005
R10184 VSS.n3109 VSS.n492 4.5005
R10185 VSS.n3120 VSS.n490 4.5005
R10186 VSS.n3121 VSS.n3120 4.5005
R10187 VSS.n605 VSS.n602 4.5005
R10188 VSS.n610 VSS.n602 4.5005
R10189 VSS.n454 VSS.n451 4.5005
R10190 VSS.n3173 VSS.n451 4.5005
R10191 VSS.n857 VSS.n854 4.5005
R10192 VSS.n2942 VSS.n2940 4.5005
R10193 VSS.n2943 VSS.n2942 4.5005
R10194 VSS.n2953 VSS.n2952 4.5005
R10195 VSS.n2431 VSS.n1227 4.5005
R10196 VSS.n2425 VSS.n2424 4.5005
R10197 VSS.n2244 VSS.n1329 4.5005
R10198 VSS.n2259 VSS.n2258 4.5005
R10199 VSS.n2273 VSS.n1308 4.5005
R10200 VSS.n2840 VSS.n899 4.5005
R10201 VSS.n2299 VSS.n2296 4.5005
R10202 VSS.n2300 VSS.n2299 4.5005
R10203 VSS.n2295 VSS.n1298 4.5005
R10204 VSS.n1625 VSS.n1624 4.5005
R10205 VSS.n1624 VSS.n1412 4.5005
R10206 VSS.n1634 VSS.n1633 4.5005
R10207 VSS.n1633 VSS.n1407 4.5005
R10208 VSS.n1646 VSS.n1405 4.5005
R10209 VSS.n1647 VSS.n1646 4.5005
R10210 VSS.n2317 VSS.n1288 4.5005
R10211 VSS.n2306 VSS.n1293 4.5005
R10212 VSS.n2310 VSS.n2307 4.5005
R10213 VSS.n2311 VSS.n2310 4.5005
R10214 VSS.n2284 VSS.n1303 4.5005
R10215 VSS.n2288 VSS.n2285 4.5005
R10216 VSS.n2289 VSS.n2288 4.5005
R10217 VSS.n2277 VSS.n2274 4.5005
R10218 VSS.n2278 VSS.n2277 4.5005
R10219 VSS.n1325 VSS.n1322 4.5005
R10220 VSS.n1328 VSS.n1322 4.5005
R10221 VSS.n2248 VSS.n2245 4.5005
R10222 VSS.n2249 VSS.n2248 4.5005
R10223 VSS.n2423 VSS.n2422 4.5005
R10224 VSS.n2423 VSS.n1230 4.5005
R10225 VSS.n2434 VSS.n1228 4.5005
R10226 VSS.n2435 VSS.n2434 4.5005
R10227 VSS.n861 VSS.n510 4.5005
R10228 VSS.n860 VSS.n854 4.5005
R10229 VSS.n3111 VSS.n3110 4.5005
R10230 VSS.n3117 VSS.n489 4.5005
R10231 VSS.n616 VSS.n615 4.5005
R10232 VSS.n3178 VSS.n3177 4.5005
R10233 VSS.n1645 VSS.n1644 4.5005
R10234 VSS.n1636 VSS.n1408 4.5005
R10235 VSS.n1627 VSS.n1413 4.5005
R10236 VSS.n1613 VSS.n1418 4.5005
R10237 VSS.n1622 VSS.n1419 4.5005
R10238 VSS.n1623 VSS.n1622 4.5005
R10239 VSS.n2330 VSS.n2329 4.5005
R10240 VSS.n2328 VSS.n1285 4.5005
R10241 VSS.n2328 VSS.n2327 4.5005
R10242 VSS.n1292 VSS.n1289 4.5005
R10243 VSS.n2316 VSS.n1289 4.5005
R10244 VSS.n901 VSS.n897 4.5005
R10245 VSS.n901 VSS.n898 4.5005
R10246 VSS.n3114 VSS.n494 4.5005
R10247 VSS.n3115 VSS.n3114 4.5005
R10248 VSS.n491 VSS.n487 4.5005
R10249 VSS.n491 VSS.n488 4.5005
R10250 VSS.n612 VSS.n606 4.5005
R10251 VSS.n612 VSS.n611 4.5005
R10252 VSS.n3174 VSS.n455 4.5005
R10253 VSS.n2949 VSS.n858 4.5005
R10254 VSS.n862 VSS.n497 4.5005
R10255 VSS.n2939 VSS.n862 4.5005
R10256 VSS.n2951 VSS.n2950 4.5005
R10257 VSS.n2433 VSS.n2432 4.5005
R10258 VSS.n1236 VSS.n1231 4.5005
R10259 VSS.n2247 VSS.n2246 4.5005
R10260 VSS.n2257 VSS.n2256 4.5005
R10261 VSS.n2276 VSS.n2275 4.5005
R10262 VSS.n2842 VSS.n2841 4.5005
R10263 VSS.n1302 VSS.n1299 4.5005
R10264 VSS.n2294 VSS.n1299 4.5005
R10265 VSS.n2298 VSS.n2297 4.5005
R10266 VSS.n1631 VSS.n1414 4.5005
R10267 VSS.n1632 VSS.n1631 4.5005
R10268 VSS.n1640 VSS.n1409 4.5005
R10269 VSS.n1641 VSS.n1640 4.5005
R10270 VSS.n1406 VSS.n1403 4.5005
R10271 VSS.n1406 VSS.n1404 4.5005
R10272 VSS.n2320 VSS.n2319 4.5005
R10273 VSS.n2309 VSS.n2308 4.5005
R10274 VSS.n1297 VSS.n1294 4.5005
R10275 VSS.n2305 VSS.n1294 4.5005
R10276 VSS.n2287 VSS.n2286 4.5005
R10277 VSS.n1307 VSS.n1304 4.5005
R10278 VSS.n2283 VSS.n1304 4.5005
R10279 VSS.n1312 VSS.n1309 4.5005
R10280 VSS.n1313 VSS.n1309 4.5005
R10281 VSS.n2255 VSS.n1326 4.5005
R10282 VSS.n2255 VSS.n2254 4.5005
R10283 VSS.n1790 VSS.n1330 4.5005
R10284 VSS.n1330 VSS.n1235 4.5005
R10285 VSS.n2428 VSS.n1232 4.5005
R10286 VSS.n2429 VSS.n2428 4.5005
R10287 VSS.n1229 VSS.n1223 4.5005
R10288 VSS.n1229 VSS.n1224 4.5005
R10289 VSS.n2941 VSS.n2938 4.5005
R10290 VSS.n2949 VSS.n2948 4.5005
R10291 VSS.n498 VSS.n493 4.5005
R10292 VSS.n3119 VSS.n3118 4.5005
R10293 VSS.n614 VSS.n613 4.5005
R10294 VSS.n3176 VSS.n3175 4.5005
R10295 VSS.n1642 VSS.n1401 4.5005
R10296 VSS.n1639 VSS.n1638 4.5005
R10297 VSS.n1630 VSS.n1629 4.5005
R10298 VSS.n1616 VSS.n1612 4.5005
R10299 VSS.n1612 VSS.n1611 4.5005
R10300 VSS.n1286 VSS.n1282 4.5005
R10301 VSS.n1661 VSS.n1283 4.5005
R10302 VSS.n1661 VSS.n1660 4.5005
R10303 VSS.n2324 VSS.n1290 4.5005
R10304 VSS.n2324 VSS.n2323 4.5005
R10305 VSS.n2846 VSS.n896 4.5005
R10306 VSS.n2846 VSS.n2845 4.5005
R10307 VSS.n3107 VSS.n496 4.5005
R10308 VSS.n496 VSS.n495 4.5005
R10309 VSS.n3123 VSS.n486 4.5005
R10310 VSS.n3123 VSS.n3122 4.5005
R10311 VSS.n608 VSS.n604 4.5005
R10312 VSS.n609 VSS.n608 4.5005
R10313 VSS.n3171 VSS.n453 4.5005
R10314 VSS.n3172 VSS.n3171 4.5005
R10315 VSS.n884 VSS.n856 4.5005
R10316 VSS.n2945 VSS.n863 4.5005
R10317 VSS.n2945 VSS.n2944 4.5005
R10318 VSS.n859 VSS.n855 4.5005
R10319 VSS.n2430 VSS.n1221 4.5005
R10320 VSS.n2427 VSS.n2426 4.5005
R10321 VSS.n2253 VSS.n2252 4.5005
R10322 VSS.n1327 VSS.n1323 4.5005
R10323 VSS.n2282 VSS.n2281 4.5005
R10324 VSS.n2839 VSS.n895 4.5005
R10325 VSS.n2302 VSS.n1300 4.5005
R10326 VSS.n2302 VSS.n2301 4.5005
R10327 VSS.n2304 VSS.n2303 4.5005
R10328 VSS.n1626 VSS.n1416 4.5005
R10329 VSS.n1416 VSS.n1415 4.5005
R10330 VSS.n1635 VSS.n1411 4.5005
R10331 VSS.n1411 VSS.n1410 4.5005
R10332 VSS.n1649 VSS.n1402 4.5005
R10333 VSS.n1649 VSS.n1648 4.5005
R10334 VSS.n2326 VSS.n2325 4.5005
R10335 VSS.n2315 VSS.n2314 4.5005
R10336 VSS.n2313 VSS.n1295 4.5005
R10337 VSS.n2313 VSS.n2312 4.5005
R10338 VSS.n2293 VSS.n2292 4.5005
R10339 VSS.n2291 VSS.n1305 4.5005
R10340 VSS.n2291 VSS.n2290 4.5005
R10341 VSS.n2280 VSS.n1310 4.5005
R10342 VSS.n2280 VSS.n2279 4.5005
R10343 VSS.n1360 VSS.n1324 4.5005
R10344 VSS.n1360 VSS.n1359 4.5005
R10345 VSS.n2251 VSS.n1331 4.5005
R10346 VSS.n2251 VSS.n2250 4.5005
R10347 VSS.n2421 VSS.n1234 4.5005
R10348 VSS.n1234 VSS.n1233 4.5005
R10349 VSS.n2437 VSS.n1222 4.5005
R10350 VSS.n2437 VSS.n2436 4.5005
R10351 VSS.n2947 VSS.n2946 4.5005
R10352 VSS.n884 VSS.n883 4.5005
R10353 VSS.n3113 VSS.n3112 4.5005
R10354 VSS.n3116 VSS.n485 4.5005
R10355 VSS.n607 VSS.n603 4.5005
R10356 VSS.n456 VSS.n452 4.5005
R10357 VSS.n2537 VSS.n2536 4.5005
R10358 VSS.n1175 VSS.n1172 4.5005
R10359 VSS.n1178 VSS.n1172 4.5005
R10360 VSS.n2535 VSS.n2534 4.5005
R10361 VSS.n2533 VSS.n1176 4.5005
R10362 VSS.n2533 VSS.n2532 4.5005
R10363 VSS.n1177 VSS.n1173 4.5005
R10364 VSS.n1210 VSS.n1174 4.5005
R10365 VSS.n1210 VSS.n1209 4.5005
R10366 VSS.n2539 VSS.n1169 4.5005
R10367 VSS.n2543 VSS.n2540 4.5005
R10368 VSS.n2544 VSS.n2543 4.5005
R10369 VSS.n2542 VSS.n2541 4.5005
R10370 VSS.n2538 VSS.n1170 4.5005
R10371 VSS.n1170 VSS.n921 4.5005
R10372 VSS.n2548 VSS.n2547 4.5005
R10373 VSS.n2546 VSS.n1171 4.5005
R10374 VSS.n2546 VSS.n2545 4.5005
R10375 VSS.n2800 VSS.n2799 4.5005
R10376 VSS.n2798 VSS.n2797 4.5005
R10377 VSS.n2798 VSS.n930 4.5005
R10378 VSS.n936 VSS.n931 4.5005
R10379 VSS.n2803 VSS.n932 4.5005
R10380 VSS.n2804 VSS.n2803 4.5005
R10381 VSS.n2802 VSS.n2801 4.5005
R10382 VSS.n2796 VSS.n934 4.5005
R10383 VSS.n934 VSS.n933 4.5005
R10384 VSS.n2789 VSS.n1045 4.5005
R10385 VSS.n2792 VSS.n1046 4.5005
R10386 VSS.n2793 VSS.n2792 4.5005
R10387 VSS.n2791 VSS.n2790 4.5005
R10388 VSS.n1047 VSS.n939 4.5005
R10389 VSS.n1047 VSS.n1042 4.5005
R10390 VSS.n2788 VSS.n937 4.5005
R10391 VSS.n2795 VSS.n938 4.5005
R10392 VSS.n2795 VSS.n2794 4.5005
R10393 VSS.n3438 VSS.n3437 4.5005
R10394 VSS.n377 VSS.n374 4.5005
R10395 VSS.n380 VSS.n374 4.5005
R10396 VSS.n3436 VSS.n3435 4.5005
R10397 VSS.n3434 VSS.n378 4.5005
R10398 VSS.n3434 VSS.n3433 4.5005
R10399 VSS.n379 VSS.n375 4.5005
R10400 VSS.n1044 VSS.n376 4.5005
R10401 VSS.n1044 VSS.n1043 4.5005
R10402 VSS.n3443 VSS.n346 4.5005
R10403 VSS.n3444 VSS.n3443 4.5005
R10404 VSS.n3442 VSS.n3441 4.5005
R10405 VSS.n347 VSS.n330 4.5005
R10406 VSS.n3440 VSS.n3439 4.5005
R10407 VSS.n342 VSS.n341 4.5005
R10408 VSS.n341 VSS.n340 4.5005
R10409 VSS.n333 VSS.n332 4.5005
R10410 VSS.n339 VSS.n331 4.5005
R10411 VSS.n345 VSS.n344 4.5005
R10412 VSS.n2448 VSS.n1211 4.5005
R10413 VSS.n1654 VSS.n1653 4.5005
R10414 VSS.n1584 VSS.n1431 4.5005
R10415 VSS.n1595 VSS.n1426 4.5005
R10416 VSS.n1610 VSS.n1609 4.5005
R10417 VSS.n1423 VSS.n1420 4.5005
R10418 VSS.n1425 VSS.n1420 4.5005
R10419 VSS.n1666 VSS.n1665 4.5005
R10420 VSS.n1664 VSS.n1663 4.5005
R10421 VSS.n1664 VSS.n1389 4.5005
R10422 VSS.n1672 VSS.n1671 4.5005
R10423 VSS.n1671 VSS.n1384 4.5005
R10424 VSS.n2849 VSS.n2848 4.5005
R10425 VSS.n2849 VSS.n888 4.5005
R10426 VSS.n2904 VSS.n2898 4.5005
R10427 VSS.n2905 VSS.n2904 4.5005
R10428 VSS.n3126 VSS.n3125 4.5005
R10429 VSS.n3126 VSS.n478 4.5005
R10430 VSS.n3137 VSS.n476 4.5005
R10431 VSS.n3138 VSS.n3137 4.5005
R10432 VSS.n460 VSS.n457 4.5005
R10433 VSS.n3165 VSS.n457 4.5005
R10434 VSS.n2860 VSS.n886 4.5005
R10435 VSS.n870 VSS.n864 4.5005
R10436 VSS.n869 VSS.n864 4.5005
R10437 VSS.n2857 VSS.n885 4.5005
R10438 VSS.n2442 VSS.n2441 4.5005
R10439 VSS.n1774 VSS.n1339 4.5005
R10440 VSS.n1789 VSS.n1788 4.5005
R10441 VSS.n1717 VSS.n1361 4.5005
R10442 VSS.n1711 VSS.n1311 4.5005
R10443 VSS.n2851 VSS.n2850 4.5005
R10444 VSS.n1690 VSS.n1689 4.5005
R10445 VSS.n1689 VSS.n1374 4.5005
R10446 VSS.n1693 VSS.n1301 4.5005
R10447 VSS.n1599 VSS.n1596 4.5005
R10448 VSS.n1600 VSS.n1599 4.5005
R10449 VSS.n1588 VSS.n1585 4.5005
R10450 VSS.n1589 VSS.n1588 4.5005
R10451 VSS.n1652 VSS.n1651 4.5005
R10452 VSS.n1652 VSS.n1394 4.5005
R10453 VSS.n1675 VSS.n1291 4.5005
R10454 VSS.n1684 VSS.n1296 4.5005
R10455 VSS.n1681 VSS.n1680 4.5005
R10456 VSS.n1680 VSS.n1379 4.5005
R10457 VSS.n1702 VSS.n1306 4.5005
R10458 VSS.n1699 VSS.n1698 4.5005
R10459 VSS.n1698 VSS.n1369 4.5005
R10460 VSS.n1708 VSS.n1707 4.5005
R10461 VSS.n1707 VSS.n1364 4.5005
R10462 VSS.n1720 VSS.n1362 4.5005
R10463 VSS.n1721 VSS.n1720 4.5005
R10464 VSS.n1335 VSS.n1332 4.5005
R10465 VSS.n1338 VSS.n1332 4.5005
R10466 VSS.n1778 VSS.n1775 4.5005
R10467 VSS.n1779 VSS.n1778 4.5005
R10468 VSS.n2440 VSS.n2439 4.5005
R10469 VSS.n2440 VSS.n1214 4.5005
R10470 VSS.n2451 VSS.n1212 4.5005
R10471 VSS.n2452 VSS.n2451 4.5005
R10472 VSS.n2937 VSS.n2936 4.5005
R10473 VSS.n2861 VSS.n2860 4.5005
R10474 VSS.n2901 VSS.n2897 4.5005
R10475 VSS.n3128 VSS.n3127 4.5005
R10476 VSS.n3134 VSS.n475 4.5005
R10477 VSS.n3170 VSS.n3169 4.5005
R10478 VSS.n2450 VSS.n2449 4.5005
R10479 VSS.n1400 VSS.n1395 4.5005
R10480 VSS.n1587 VSS.n1586 4.5005
R10481 VSS.n1598 VSS.n1597 4.5005
R10482 VSS.n1608 VSS.n1607 4.5005
R10483 VSS.n1606 VSS.n1424 4.5005
R10484 VSS.n1606 VSS.n1605 4.5005
R10485 VSS.n1659 VSS.n1390 4.5005
R10486 VSS.n1669 VSS.n1391 4.5005
R10487 VSS.n1670 VSS.n1669 4.5005
R10488 VSS.n1678 VSS.n1386 4.5005
R10489 VSS.n1679 VSS.n1678 4.5005
R10490 VSS.n2854 VSS.n890 4.5005
R10491 VSS.n2855 VSS.n2854 4.5005
R10492 VSS.n2899 VSS.n2896 4.5005
R10493 VSS.n2899 VSS.n483 4.5005
R10494 VSS.n3131 VSS.n480 4.5005
R10495 VSS.n3132 VSS.n3131 4.5005
R10496 VSS.n477 VSS.n473 4.5005
R10497 VSS.n477 VSS.n474 4.5005
R10498 VSS.n3166 VSS.n461 4.5005
R10499 VSS.n887 VSS.n881 4.5005
R10500 VSS.n2933 VSS.n867 4.5005
R10501 VSS.n2933 VSS.n2932 4.5005
R10502 VSS.n2859 VSS.n2858 4.5005
R10503 VSS.n1220 VSS.n1215 4.5005
R10504 VSS.n1777 VSS.n1776 4.5005
R10505 VSS.n1787 VSS.n1786 4.5005
R10506 VSS.n1719 VSS.n1718 4.5005
R10507 VSS.n1710 VSS.n1365 4.5005
R10508 VSS.n894 VSS.n889 4.5005
R10509 VSS.n1696 VSS.n1376 4.5005
R10510 VSS.n1697 VSS.n1696 4.5005
R10511 VSS.n1692 VSS.n1375 4.5005
R10512 VSS.n1430 VSS.n1427 4.5005
R10513 VSS.n1594 VSS.n1427 4.5005
R10514 VSS.n1583 VSS.n1432 4.5005
R10515 VSS.n1432 VSS.n1399 4.5005
R10516 VSS.n1657 VSS.n1396 4.5005
R10517 VSS.n1658 VSS.n1657 4.5005
R10518 VSS.n1674 VSS.n1385 4.5005
R10519 VSS.n1683 VSS.n1380 4.5005
R10520 VSS.n1687 VSS.n1381 4.5005
R10521 VSS.n1688 VSS.n1687 4.5005
R10522 VSS.n1701 VSS.n1370 4.5005
R10523 VSS.n1705 VSS.n1371 4.5005
R10524 VSS.n1706 VSS.n1705 4.5005
R10525 VSS.n1714 VSS.n1366 4.5005
R10526 VSS.n1715 VSS.n1714 4.5005
R10527 VSS.n1363 VSS.n1357 4.5005
R10528 VSS.n1363 VSS.n1358 4.5005
R10529 VSS.n1785 VSS.n1336 4.5005
R10530 VSS.n1785 VSS.n1784 4.5005
R10531 VSS.n1773 VSS.n1340 4.5005
R10532 VSS.n1340 VSS.n1219 4.5005
R10533 VSS.n2445 VSS.n1216 4.5005
R10534 VSS.n2446 VSS.n2445 4.5005
R10535 VSS.n1213 VSS.n1207 4.5005
R10536 VSS.n1213 VSS.n1208 4.5005
R10537 VSS.n2935 VSS.n2934 4.5005
R10538 VSS.n887 VSS.n882 4.5005
R10539 VSS.n2903 VSS.n2902 4.5005
R10540 VSS.n484 VSS.n479 4.5005
R10541 VSS.n3136 VSS.n3135 4.5005
R10542 VSS.n3168 VSS.n3167 4.5005
R10543 VSS.n2447 VSS.n1205 4.5005
R10544 VSS.n1656 VSS.n1655 4.5005
R10545 VSS.n1593 VSS.n1592 4.5005
R10546 VSS.n1604 VSS.n1603 4.5005
R10547 VSS.n1447 VSS.n1422 4.5005
R10548 VSS.n1447 VSS.n1446 4.5005
R10549 VSS.n1668 VSS.n1667 4.5005
R10550 VSS.n1662 VSS.n1393 4.5005
R10551 VSS.n1393 VSS.n1392 4.5005
R10552 VSS.n1673 VSS.n1388 4.5005
R10553 VSS.n1388 VSS.n1387 4.5005
R10554 VSS.n2847 VSS.n892 4.5005
R10555 VSS.n892 VSS.n891 4.5005
R10556 VSS.n2907 VSS.n2895 4.5005
R10557 VSS.n2907 VSS.n2906 4.5005
R10558 VSS.n3124 VSS.n482 4.5005
R10559 VSS.n482 VSS.n481 4.5005
R10560 VSS.n3140 VSS.n472 4.5005
R10561 VSS.n3140 VSS.n3139 4.5005
R10562 VSS.n3163 VSS.n459 4.5005
R10563 VSS.n3164 VSS.n3163 4.5005
R10564 VSS.n2863 VSS.n880 4.5005
R10565 VSS.n2931 VSS.n2930 4.5005
R10566 VSS.n2930 VSS.n866 4.5005
R10567 VSS.n2856 VSS.n879 4.5005
R10568 VSS.n2444 VSS.n2443 4.5005
R10569 VSS.n1783 VSS.n1782 4.5005
R10570 VSS.n1337 VSS.n1333 4.5005
R10571 VSS.n1716 VSS.n1355 4.5005
R10572 VSS.n1713 VSS.n1712 4.5005
R10573 VSS.n2853 VSS.n2852 4.5005
R10574 VSS.n1691 VSS.n1378 4.5005
R10575 VSS.n1378 VSS.n1377 4.5005
R10576 VSS.n1695 VSS.n1694 4.5005
R10577 VSS.n1602 VSS.n1428 4.5005
R10578 VSS.n1602 VSS.n1601 4.5005
R10579 VSS.n1591 VSS.n1433 4.5005
R10580 VSS.n1591 VSS.n1590 4.5005
R10581 VSS.n1650 VSS.n1398 4.5005
R10582 VSS.n1398 VSS.n1397 4.5005
R10583 VSS.n1677 VSS.n1676 4.5005
R10584 VSS.n1686 VSS.n1685 4.5005
R10585 VSS.n1682 VSS.n1383 4.5005
R10586 VSS.n1383 VSS.n1382 4.5005
R10587 VSS.n1704 VSS.n1703 4.5005
R10588 VSS.n1700 VSS.n1373 4.5005
R10589 VSS.n1373 VSS.n1372 4.5005
R10590 VSS.n1709 VSS.n1368 4.5005
R10591 VSS.n1368 VSS.n1367 4.5005
R10592 VSS.n1723 VSS.n1356 4.5005
R10593 VSS.n1723 VSS.n1722 4.5005
R10594 VSS.n1735 VSS.n1334 4.5005
R10595 VSS.n1735 VSS.n1734 4.5005
R10596 VSS.n1781 VSS.n1341 4.5005
R10597 VSS.n1781 VSS.n1780 4.5005
R10598 VSS.n2438 VSS.n1218 4.5005
R10599 VSS.n1218 VSS.n1217 4.5005
R10600 VSS.n2454 VSS.n1206 4.5005
R10601 VSS.n2454 VSS.n2453 4.5005
R10602 VSS.n868 VSS.n865 4.5005
R10603 VSS.n2863 VSS.n2862 4.5005
R10604 VSS.n2900 VSS.n2894 4.5005
R10605 VSS.n3130 VSS.n3129 4.5005
R10606 VSS.n3133 VSS.n471 4.5005
R10607 VSS.n462 VSS.n458 4.5005
R10608 VSS.n2520 VSS.n2519 4.5005
R10609 VSS.n1185 VSS.n1182 4.5005
R10610 VSS.n1188 VSS.n1182 4.5005
R10611 VSS.n2518 VSS.n2517 4.5005
R10612 VSS.n2516 VSS.n1186 4.5005
R10613 VSS.n2516 VSS.n2515 4.5005
R10614 VSS.n1187 VSS.n1183 4.5005
R10615 VSS.n2466 VSS.n1184 4.5005
R10616 VSS.n2466 VSS.n2465 4.5005
R10617 VSS.n2522 VSS.n1179 4.5005
R10618 VSS.n2526 VSS.n2523 4.5005
R10619 VSS.n2527 VSS.n2526 4.5005
R10620 VSS.n2525 VSS.n2524 4.5005
R10621 VSS.n2521 VSS.n1180 4.5005
R10622 VSS.n1180 VSS.n907 4.5005
R10623 VSS.n2531 VSS.n2530 4.5005
R10624 VSS.n2529 VSS.n1181 4.5005
R10625 VSS.n2529 VSS.n2528 4.5005
R10626 VSS.n2817 VSS.n2816 4.5005
R10627 VSS.n2815 VSS.n2814 4.5005
R10628 VSS.n2815 VSS.n916 4.5005
R10629 VSS.n922 VSS.n917 4.5005
R10630 VSS.n2820 VSS.n918 4.5005
R10631 VSS.n2821 VSS.n2820 4.5005
R10632 VSS.n2819 VSS.n2818 4.5005
R10633 VSS.n2813 VSS.n920 4.5005
R10634 VSS.n920 VSS.n919 4.5005
R10635 VSS.n2806 VSS.n927 4.5005
R10636 VSS.n2809 VSS.n928 4.5005
R10637 VSS.n2810 VSS.n2809 4.5005
R10638 VSS.n2808 VSS.n2807 4.5005
R10639 VSS.n929 VSS.n925 4.5005
R10640 VSS.n929 VSS.n926 4.5005
R10641 VSS.n2805 VSS.n923 4.5005
R10642 VSS.n2812 VSS.n924 4.5005
R10643 VSS.n2812 VSS.n2811 4.5005
R10644 VSS.n940 VSS.n384 4.5005
R10645 VSS.n1036 VSS.n1033 4.5005
R10646 VSS.n1037 VSS.n1036 4.5005
R10647 VSS.n1035 VSS.n1034 4.5005
R10648 VSS.n943 VSS.n941 4.5005
R10649 VSS.n1032 VSS.n941 4.5005
R10650 VSS.n1041 VSS.n1040 4.5005
R10651 VSS.n1039 VSS.n942 4.5005
R10652 VSS.n1039 VSS.n1038 4.5005
R10653 VSS.n381 VSS.n223 4.5005
R10654 VSS.n3427 VSS.n3424 4.5005
R10655 VSS.n3428 VSS.n3427 4.5005
R10656 VSS.n3426 VSS.n3425 4.5005
R10657 VSS.n385 VSS.n382 4.5005
R10658 VSS.n3423 VSS.n382 4.5005
R10659 VSS.n3432 VSS.n3431 4.5005
R10660 VSS.n3430 VSS.n383 4.5005
R10661 VSS.n3430 VSS.n3429 4.5005
R10662 VSS.n3573 VSS.n215 4.5005
R10663 VSS.n3574 VSS.n3573 4.5005
R10664 VSS.n3572 VSS.n3571 4.5005
R10665 VSS.n216 VSS.n214 4.5005
R10666 VSS.n3570 VSS.n3569 4.5005
R10667 VSS.n224 VSS.n220 4.5005
R10668 VSS.n3568 VSS.n219 4.5005
R10669 VSS.n3568 VSS.n3567 4.5005
R10670 VSS.n3566 VSS.n3565 4.5005
R10671 VSS.n3564 VSS.n3563 4.5005
R10672 VSS.n2471 VSS.n2470 4.5005
R10673 VSS.n2459 VSS.n2458 4.5005
R10674 VSS.n1567 VSS.n1473 4.5005
R10675 VSS.n1582 VSS.n1581 4.5005
R10676 VSS.n1460 VSS.n1429 4.5005
R10677 VSS.n1452 VSS.n1451 4.5005
R10678 VSS.n1450 VSS.n1449 4.5005
R10679 VSS.n1450 VSS.n1440 4.5005
R10680 VSS.n1556 VSS.n1477 4.5005
R10681 VSS.n1560 VSS.n1557 4.5005
R10682 VSS.n1561 VSS.n1560 4.5005
R10683 VSS.n1549 VSS.n1546 4.5005
R10684 VSS.n1550 VSS.n1549 4.5005
R10685 VSS.n2492 VSS.n2489 4.5005
R10686 VSS.n2493 VSS.n2492 4.5005
R10687 VSS.n2912 VSS.n2909 4.5005
R10688 VSS.n2913 VSS.n2912 4.5005
R10689 VSS.n2887 VSS.n2884 4.5005
R10690 VSS.n2888 VSS.n2887 4.5005
R10691 VSS.n3143 VSS.n3142 4.5005
R10692 VSS.n3143 VSS.n464 4.5005
R10693 VSS.n3152 VSS.n463 4.5005
R10694 VSS.n3157 VSS.n463 4.5005
R10695 VSS.n2866 VSS.n2865 4.5005
R10696 VSS.n2921 VSS.n871 4.5005
R10697 VSS.n2920 VSS.n871 4.5005
R10698 VSS.n2868 VSS.n2867 4.5005
R10699 VSS.n1757 VSS.n1753 4.5005
R10700 VSS.n1772 VSS.n1771 4.5005
R10701 VSS.n1740 VSS.n1739 4.5005
R10702 VSS.n1728 VSS.n1727 4.5005
R10703 VSS.n1501 VSS.n1497 4.5005
R10704 VSS.n2488 VSS.n2484 4.5005
R10705 VSS.n1527 VSS.n1524 4.5005
R10706 VSS.n1528 VSS.n1527 4.5005
R10707 VSS.n1523 VSS.n1489 4.5005
R10708 VSS.n1457 VSS.n1456 4.5005
R10709 VSS.n1456 VSS.n1435 4.5005
R10710 VSS.n1467 VSS.n1434 4.5005
R10711 VSS.n1472 VSS.n1434 4.5005
R10712 VSS.n1571 VSS.n1568 4.5005
R10713 VSS.n1572 VSS.n1571 4.5005
R10714 VSS.n1545 VSS.n1481 4.5005
R10715 VSS.n1534 VSS.n1485 4.5005
R10716 VSS.n1538 VSS.n1535 4.5005
R10717 VSS.n1539 VSS.n1538 4.5005
R10718 VSS.n1512 VSS.n1493 4.5005
R10719 VSS.n1516 VSS.n1513 4.5005
R10720 VSS.n1517 VSS.n1516 4.5005
R10721 VSS.n1505 VSS.n1502 4.5005
R10722 VSS.n1506 VSS.n1505 4.5005
R10723 VSS.n1726 VSS.n1725 4.5005
R10724 VSS.n1726 VSS.n1348 4.5005
R10725 VSS.n1738 VSS.n1737 4.5005
R10726 VSS.n1738 VSS.n1343 4.5005
R10727 VSS.n1747 VSS.n1342 4.5005
R10728 VSS.n1752 VSS.n1342 4.5005
R10729 VSS.n1761 VSS.n1758 4.5005
R10730 VSS.n1762 VSS.n1761 4.5005
R10731 VSS.n2457 VSS.n2456 4.5005
R10732 VSS.n2457 VSS.n1198 4.5005
R10733 VSS.n2469 VSS.n2468 4.5005
R10734 VSS.n2469 VSS.n1193 4.5005
R10735 VSS.n2929 VSS.n2928 4.5005
R10736 VSS.n2866 VSS.n872 4.5005
R10737 VSS.n2908 VSS.n2875 4.5005
R10738 VSS.n2883 VSS.n2879 4.5005
R10739 VSS.n3145 VSS.n3144 4.5005
R10740 VSS.n3162 VSS.n3161 4.5005
R10741 VSS.n2464 VSS.n1194 4.5005
R10742 VSS.n1204 VSS.n1199 4.5005
R10743 VSS.n1570 VSS.n1569 4.5005
R10744 VSS.n1580 VSS.n1579 4.5005
R10745 VSS.n1459 VSS.n1436 4.5005
R10746 VSS.n1445 VSS.n1441 4.5005
R10747 VSS.n1454 VSS.n1442 4.5005
R10748 VSS.n1455 VSS.n1454 4.5005
R10749 VSS.n1559 VSS.n1558 4.5005
R10750 VSS.n1480 VSS.n1478 4.5005
R10751 VSS.n1555 VSS.n1478 4.5005
R10752 VSS.n1484 VSS.n1482 4.5005
R10753 VSS.n1544 VSS.n1482 4.5005
R10754 VSS.n2487 VSS.n2485 4.5005
R10755 VSS.n2485 VSS.n877 4.5005
R10756 VSS.n2878 VSS.n2876 4.5005
R10757 VSS.n2893 VSS.n2876 4.5005
R10758 VSS.n2882 VSS.n2880 4.5005
R10759 VSS.n2880 VSS.n469 4.5005
R10760 VSS.n3148 VSS.n466 4.5005
R10761 VSS.n3149 VSS.n3148 4.5005
R10762 VSS.n3158 VSS.n3153 4.5005
R10763 VSS.n2871 VSS.n874 4.5005
R10764 VSS.n2925 VSS.n2918 4.5005
R10765 VSS.n2925 VSS.n2924 4.5005
R10766 VSS.n878 VSS.n873 4.5005
R10767 VSS.n1760 VSS.n1759 4.5005
R10768 VSS.n1770 VSS.n1769 4.5005
R10769 VSS.n1733 VSS.n1344 4.5005
R10770 VSS.n1354 VSS.n1349 4.5005
R10771 VSS.n1504 VSS.n1503 4.5005
R10772 VSS.n2491 VSS.n2490 4.5005
R10773 VSS.n1492 VSS.n1490 4.5005
R10774 VSS.n1522 VSS.n1490 4.5005
R10775 VSS.n1526 VSS.n1525 4.5005
R10776 VSS.n1463 VSS.n1437 4.5005
R10777 VSS.n1464 VSS.n1463 4.5005
R10778 VSS.n1578 VSS.n1468 4.5005
R10779 VSS.n1578 VSS.n1577 4.5005
R10780 VSS.n1476 VSS.n1474 4.5005
R10781 VSS.n1566 VSS.n1474 4.5005
R10782 VSS.n1548 VSS.n1547 4.5005
R10783 VSS.n1537 VSS.n1536 4.5005
R10784 VSS.n1488 VSS.n1486 4.5005
R10785 VSS.n1533 VSS.n1486 4.5005
R10786 VSS.n1515 VSS.n1514 4.5005
R10787 VSS.n1496 VSS.n1494 4.5005
R10788 VSS.n1511 VSS.n1494 4.5005
R10789 VSS.n1500 VSS.n1498 4.5005
R10790 VSS.n1498 VSS.n1353 4.5005
R10791 VSS.n1731 VSS.n1350 4.5005
R10792 VSS.n1732 VSS.n1731 4.5005
R10793 VSS.n1743 VSS.n1345 4.5005
R10794 VSS.n1744 VSS.n1743 4.5005
R10795 VSS.n1768 VSS.n1748 4.5005
R10796 VSS.n1768 VSS.n1767 4.5005
R10797 VSS.n1756 VSS.n1754 4.5005
R10798 VSS.n1754 VSS.n1203 4.5005
R10799 VSS.n2462 VSS.n1200 4.5005
R10800 VSS.n2463 VSS.n2462 4.5005
R10801 VSS.n2474 VSS.n1195 4.5005
R10802 VSS.n2475 VSS.n2474 4.5005
R10803 VSS.n2927 VSS.n2926 4.5005
R10804 VSS.n2872 VSS.n2871 4.5005
R10805 VSS.n2911 VSS.n2910 4.5005
R10806 VSS.n2886 VSS.n2885 4.5005
R10807 VSS.n470 VSS.n465 4.5005
R10808 VSS.n3160 VSS.n3159 4.5005
R10809 VSS.n2473 VSS.n2472 4.5005
R10810 VSS.n2461 VSS.n2460 4.5005
R10811 VSS.n1576 VSS.n1575 4.5005
R10812 VSS.n1469 VSS.n1465 4.5005
R10813 VSS.n1462 VSS.n1461 4.5005
R10814 VSS.n1448 VSS.n1444 4.5005
R10815 VSS.n1444 VSS.n1443 4.5005
R10816 VSS.n1565 VSS.n1564 4.5005
R10817 VSS.n1563 VSS.n1479 4.5005
R10818 VSS.n1563 VSS.n1562 4.5005
R10819 VSS.n1552 VSS.n1483 4.5005
R10820 VSS.n1552 VSS.n1551 4.5005
R10821 VSS.n2495 VSS.n2486 4.5005
R10822 VSS.n2495 VSS.n2494 4.5005
R10823 VSS.n2915 VSS.n2877 4.5005
R10824 VSS.n2915 VSS.n2914 4.5005
R10825 VSS.n2890 VSS.n2881 4.5005
R10826 VSS.n2890 VSS.n2889 4.5005
R10827 VSS.n3141 VSS.n468 4.5005
R10828 VSS.n468 VSS.n467 4.5005
R10829 VSS.n3155 VSS.n3151 4.5005
R10830 VSS.n3156 VSS.n3155 4.5005
R10831 VSS.n2864 VSS.n876 4.5005
R10832 VSS.n2923 VSS.n2922 4.5005
R10833 VSS.n2922 VSS.n2874 4.5005
R10834 VSS.n2870 VSS.n2869 4.5005
R10835 VSS.n1766 VSS.n1765 4.5005
R10836 VSS.n1749 VSS.n1745 4.5005
R10837 VSS.n1742 VSS.n1741 4.5005
R10838 VSS.n1730 VSS.n1729 4.5005
R10839 VSS.n1510 VSS.n1509 4.5005
R10840 VSS.n2497 VSS.n2496 4.5005
R10841 VSS.n1530 VSS.n1491 4.5005
R10842 VSS.n1530 VSS.n1529 4.5005
R10843 VSS.n1532 VSS.n1531 4.5005
R10844 VSS.n1458 VSS.n1439 4.5005
R10845 VSS.n1439 VSS.n1438 4.5005
R10846 VSS.n1470 VSS.n1466 4.5005
R10847 VSS.n1471 VSS.n1470 4.5005
R10848 VSS.n1574 VSS.n1475 4.5005
R10849 VSS.n1574 VSS.n1573 4.5005
R10850 VSS.n1554 VSS.n1553 4.5005
R10851 VSS.n1543 VSS.n1542 4.5005
R10852 VSS.n1541 VSS.n1487 4.5005
R10853 VSS.n1541 VSS.n1540 4.5005
R10854 VSS.n1521 VSS.n1520 4.5005
R10855 VSS.n1519 VSS.n1495 4.5005
R10856 VSS.n1519 VSS.n1518 4.5005
R10857 VSS.n1508 VSS.n1499 4.5005
R10858 VSS.n1508 VSS.n1507 4.5005
R10859 VSS.n1724 VSS.n1352 4.5005
R10860 VSS.n1352 VSS.n1351 4.5005
R10861 VSS.n1736 VSS.n1347 4.5005
R10862 VSS.n1347 VSS.n1346 4.5005
R10863 VSS.n1750 VSS.n1746 4.5005
R10864 VSS.n1751 VSS.n1750 4.5005
R10865 VSS.n1764 VSS.n1755 4.5005
R10866 VSS.n1764 VSS.n1763 4.5005
R10867 VSS.n2455 VSS.n1202 4.5005
R10868 VSS.n1202 VSS.n1201 4.5005
R10869 VSS.n2467 VSS.n1197 4.5005
R10870 VSS.n1197 VSS.n1196 4.5005
R10871 VSS.n2919 VSS.n2873 4.5005
R10872 VSS.n876 VSS.n875 4.5005
R10873 VSS.n2917 VSS.n2916 4.5005
R10874 VSS.n2892 VSS.n2891 4.5005
R10875 VSS.n3147 VSS.n3146 4.5005
R10876 VSS.n3154 VSS.n3150 4.5005
R10877 VSS.n2478 VSS.n1192 4.5005
R10878 VSS.n2483 VSS.n1192 4.5005
R10879 VSS.n2503 VSS.n2502 4.5005
R10880 VSS.n2499 VSS.n2479 4.5005
R10881 VSS.n2499 VSS.n2498 4.5005
R10882 VSS.n2501 VSS.n2500 4.5005
R10883 VSS.n2481 VSS.n2477 4.5005
R10884 VSS.n2482 VSS.n2481 4.5005
R10885 VSS.n2480 VSS.n2476 4.5005
R10886 VSS.n2509 VSS.n2506 4.5005
R10887 VSS.n2510 VSS.n2509 4.5005
R10888 VSS.n2505 VSS.n1189 4.5005
R10889 VSS.n2504 VSS.n1190 4.5005
R10890 VSS.n1190 VSS.n893 4.5005
R10891 VSS.n2508 VSS.n2507 4.5005
R10892 VSS.n2512 VSS.n1191 4.5005
R10893 VSS.n2512 VSS.n2511 4.5005
R10894 VSS.n2514 VSS.n2513 4.5005
R10895 VSS.n2832 VSS.n2831 4.5005
R10896 VSS.n2832 VSS.n902 4.5005
R10897 VSS.n2834 VSS.n2833 4.5005
R10898 VSS.n2837 VSS.n904 4.5005
R10899 VSS.n2838 VSS.n2837 4.5005
R10900 VSS.n908 VSS.n903 4.5005
R10901 VSS.n2830 VSS.n906 4.5005
R10902 VSS.n906 VSS.n905 4.5005
R10903 VSS.n2836 VSS.n2835 4.5005
R10904 VSS.n2826 VSS.n914 4.5005
R10905 VSS.n2827 VSS.n2826 4.5005
R10906 VSS.n2823 VSS.n913 4.5005
R10907 VSS.n915 VSS.n911 4.5005
R10908 VSS.n915 VSS.n912 4.5005
R10909 VSS.n2825 VSS.n2824 4.5005
R10910 VSS.n2829 VSS.n910 4.5005
R10911 VSS.n2829 VSS.n2828 4.5005
R10912 VSS.n2822 VSS.n909 4.5005
R10913 VSS.n959 VSS.n958 4.5005
R10914 VSS.n958 VSS.n953 4.5005
R10915 VSS.n962 VSS.n947 4.5005
R10916 VSS.n965 VSS.n955 4.5005
R10917 VSS.n966 VSS.n965 4.5005
R10918 VSS.n961 VSS.n954 4.5005
R10919 VSS.n960 VSS.n957 4.5005
R10920 VSS.n957 VSS.n956 4.5005
R10921 VSS.n964 VSS.n963 4.5005
R10922 VSS.n1026 VSS.n1023 4.5005
R10923 VSS.n1027 VSS.n1026 4.5005
R10924 VSS.n944 VSS.n389 4.5005
R10925 VSS.n948 VSS.n945 4.5005
R10926 VSS.n1022 VSS.n945 4.5005
R10927 VSS.n1025 VSS.n1024 4.5005
R10928 VSS.n1029 VSS.n946 4.5005
R10929 VSS.n1029 VSS.n1028 4.5005
R10930 VSS.n1031 VSS.n1030 4.5005
R10931 VSS.n3417 VSS.n3414 4.5005
R10932 VSS.n3418 VSS.n3417 4.5005
R10933 VSS.n3413 VSS.n386 4.5005
R10934 VSS.n390 VSS.n387 4.5005
R10935 VSS.n391 VSS.n387 4.5005
R10936 VSS.n3416 VSS.n3415 4.5005
R10937 VSS.n3420 VSS.n388 4.5005
R10938 VSS.n3420 VSS.n3419 4.5005
R10939 VSS.n3422 VSS.n3421 4.5005
R10940 VSS.n3402 VSS.n393 4.5005
R10941 VSS.n3409 VSS.n3408 4.5005
R10942 VSS.n3408 VSS.n3407 4.5005
R10943 VSS.n3406 VSS.n392 4.5005
R10944 VSS.n3412 VSS.n3411 4.5005
R10945 VSS.n819 VSS.n395 4.5005
R10946 VSS.n820 VSS.n396 4.5005
R10947 VSS.n821 VSS.n820 4.5005
R10948 VSS.n818 VSS.n394 4.5005
R10949 VSS.n3401 VSS.n3400 4.5005
R10950 VSS.n3398 VSS.n3397 4.47833
R10951 VSS.n13 VSS.t311 4.33583
R10952 VSS.n3974 VSS.t496 4.33563
R10953 VSS.n3533 VSS.t490 4.06986
R10954 VSS.n3584 VSS.t43 4.06986
R10955 VSS.t424 VSS.n65 4.03665
R10956 VSS.n315 VSS.t92 3.99557
R10957 VSS.t508 VSS.t240 3.93132
R10958 VSS.t97 VSS.t134 3.89272
R10959 VSS.n2187 VSS.n1807 3.83642
R10960 VSS.n8 VSS.t174 3.75744
R10961 VSS.n1 VSS.t102 3.75744
R10962 VSS.n3 VSS.t105 3.75744
R10963 VSS.n6 VSS.t171 3.75744
R10964 VSS.n3514 VSS.n3513 3.61354
R10965 VSS.n2192 VSS.t40 3.58597
R10966 VSS.t39 VSS.t380 3.49566
R10967 VSS.n3979 VSS.t411 3.43886
R10968 VSS.n2195 VSS.t78 3.38138
R10969 VSS.n3601 VSS.n3600 3.28265
R10970 VSS.n2759 VSS.n2753 3.28265
R10971 VSS.n2577 VSS.n2576 3.28265
R10972 VSS.n2413 VSS.n2412 3.28265
R10973 VSS.n2426 VSS.n1235 3.28265
R10974 VSS.n1784 VSS.n1783 3.28265
R10975 VSS.n1745 VSS.n1744 3.28265
R10976 VSS.n63 VSS.t312 3.13973
R10977 VSS.n3358 VSS.n416 3.00441
R10978 VSS.n2157 VSS.t361 2.99635
R10979 VSS.n3019 VSS.n3018 2.91833
R10980 VSS.n1900 VSS.n1899 2.66137
R10981 VSS.n2072 VSS.n35 2.66137
R10982 VSS.n3507 VSS.n254 2.66137
R10983 VSS.n3397 VSS.n3395 2.66137
R10984 VSS.n306 VSS.t112 2.63564
R10985 VSS.n271 VSS.n251 2.5492
R10986 VSS.n17 VSS.t177 2.54178
R10987 VSS.n2219 VSS.n1798 2.46709
R10988 VSS.n3847 VSS.n3846 2.39261
R10989 VSS.n1838 VSS.t90 2.35899
R10990 VSS.n3578 VSS.n212 2.3092
R10991 VSS.n2191 VSS.n1803 2.3009
R10992 VSS.n1918 VSS.n1917 2.28264
R10993 VSS.n1970 VSS.n1969 2.28264
R10994 VSS.n2066 VSS.n2065 2.28264
R10995 VSS.n3501 VSS.n3500 2.28264
R10996 VSS.n714 VSS.n713 2.28264
R10997 VSS.n810 VSS.n809 2.28264
R10998 VSS.n3389 VSS.n3388 2.28264
R10999 VSS.n3246 VSS.n3245 2.28264
R11000 VSS.n3298 VSS.n3297 2.28264
R11001 VSS.n2633 VSS.n24 2.27351
R11002 VSS.n1944 VSS.n1943 2.26818
R11003 VSS.n1996 VSS.n1995 2.26818
R11004 VSS.n2034 VSS.n2033 2.26818
R11005 VSS.n702 VSS.n701 2.26818
R11006 VSS.n740 VSS.n739 2.26818
R11007 VSS.n778 VSS.n777 2.26818
R11008 VSS.n3234 VSS.n3233 2.26818
R11009 VSS.n3272 VSS.n3271 2.26818
R11010 VSS.n3551 VSS.n230 2.20905
R11011 VSS.n1 VSS.n0 2.11787
R11012 VSS.n3 VSS.n2 2.11787
R11013 VSS.n6 VSS.n5 2.11787
R11014 VSS.n9 VSS.n8 2.11787
R11015 VSS.n2198 VSS.t215 2.02992
R11016 VSS.n3222 VSS.n417 1.96485
R11017 VSS.n2190 VSS.n1804 1.9568
R11018 VSS.n336 VSS.n335 1.91789
R11019 VSS.n3027 VSS.n3026 1.85398
R11020 VSS.n3925 VSS.t242 1.78484
R11021 VSS.n2146 VSS.n2090 1.7474
R11022 VSS.n1830 VSS.n1829 1.71717
R11023 VSS.n2198 VSS.n2197 1.55655
R11024 VSS.n3986 VSS.n3985 1.52695
R11025 VSS.n3561 VSS.n3560 1.51452
R11026 VSS.n2123 VSS.t364 1.49843
R11027 VSS.n2094 VSS.t191 1.49843
R11028 VSS.n2150 VSS.t13 1.49843
R11029 VSS.n3959 VSS.n27 1.46313
R11030 VSS.n3968 VSS.n3967 1.46313
R11031 VSS.n25 VSS.n24 1.46313
R11032 VSS.n367 VSS.n350 1.45294
R11033 VSS.n2190 VSS.n2189 1.3659
R11034 VSS VSS.n3949 1.35572
R11035 VSS.n3941 VSS 1.35572
R11036 VSS.n2074 VSS 1.35572
R11037 VSS.n3514 VSS 1.35572
R11038 VSS.n335 VSS 1.35572
R11039 VSS.n823 VSS 1.35572
R11040 VSS VSS.n3363 1.35572
R11041 VSS.n2179 VSS.n1794 1.31855
R11042 VSS.n3024 VSS.n683 1.30876
R11043 VSS.n3552 VSS.n3551 1.30668
R11044 VSS.n3560 VSS.n226 1.30375
R11045 VSS.n367 VSS.n366 1.28738
R11046 VSS.n816 VSS.n684 1.26833
R11047 VSS.n2269 VSS.n2268 1.2551
R11048 VSS.n2625 VSS 1.25458
R11049 VSS.n3552 VSS.n229 1.23208
R11050 VSS.n3363 VSS.n415 1.22267
R11051 VSS VSS.n3986 1.22024
R11052 VSS.n2625 VSS.n2624 1.18116
R11053 VSS.n2227 VSS.t481 1.17975
R11054 VSS.n2234 VSS.t291 1.17975
R11055 VSS.t18 VSS.t17 1.17975
R11056 VSS.t90 VSS.t89 1.17975
R11057 VSS.n2240 VSS.n2239 1.11335
R11058 VSS.n2147 VSS.n2085 1.08383
R11059 VSS.n1534 VSS.n1383 1.0823
R11060 VSS.n2883 VSS.n482 1.0823
R11061 VSS.n2930 VSS.n2929 1.0823
R11062 VSS.n2867 VSS.n2863 1.0823
R11063 VSS.n3144 VSS.n3140 1.0823
R11064 VSS.n3163 VSS.n3162 1.0823
R11065 VSS.n1739 VSS.n1735 1.0823
R11066 VSS.n1501 VSS.n1368 1.0823
R11067 VSS.n1727 VSS.n1723 1.0823
R11068 VSS.n1512 VSS.n1373 1.0823
R11069 VSS.n1523 VSS.n1378 1.0823
R11070 VSS.n1757 VSS.n1218 1.0823
R11071 VSS.n1781 VSS.n1772 1.0823
R11072 VSS.n2908 VSS.n2907 1.0823
R11073 VSS.n2488 VSS.n892 1.0823
R11074 VSS.n1545 VSS.n1388 1.0823
R11075 VSS.n1556 VSS.n1393 1.0823
R11076 VSS.n1451 VSS.n1447 1.0823
R11077 VSS.n1602 VSS.n1429 1.0823
R11078 VSS.n1591 VSS.n1582 1.0823
R11079 VSS.n1567 VSS.n1398 1.0823
R11080 VSS.n2458 VSS.n2454 1.0823
R11081 VSS.n2470 VSS.n2466 1.0823
R11082 VSS.n2512 VSS.n2503 1.0823
R11083 VSS.t148 VSS.t149 1.07111
R11084 VSS.t361 VSS.t362 1.07111
R11085 VSS.n2239 VSS.n1795 1.06655
R11086 VSS.n2660 VSS.n1111 1.0575
R11087 VSS.n591 VSS.n587 1.0575
R11088 VSS.n3090 VSS.n3088 1.0575
R11089 VSS.n2963 VSS.n2962 1.0575
R11090 VSS.n626 VSS.n625 1.0575
R11091 VSS.n3187 VSS.n3186 1.0575
R11092 VSS.n2585 VSS.n1152 1.0575
R11093 VSS.n2607 VSS.n1142 1.0575
R11094 VSS.n2596 VSS.n1147 1.0575
R11095 VSS.n2380 VSS.n2376 1.0575
R11096 VSS.n2649 VSS.n1116 1.0575
R11097 VSS.n2563 VSS.n2554 1.0575
R11098 VSS.n2574 VSS.n1157 1.0575
R11099 VSS.n3079 VSS.n503 1.0575
R11100 VSS.n987 VSS.n986 1.0575
R11101 VSS.n2671 VSS.n1106 1.0575
R11102 VSS.n2341 VSS.n2337 1.0575
R11103 VSS.n3825 VSS.n3824 1.0575
R11104 VSS.n3809 VSS.n3808 1.0575
R11105 VSS.n3906 VSS.n86 1.0575
R11106 VSS.n3786 VSS.n3785 1.0575
R11107 VSS.n2539 VSS.n934 1.0575
R11108 VSS.n2816 VSS.n2812 1.0575
R11109 VSS.n957 VSS.n913 1.0575
R11110 VSS.n2306 VSS.n1272 1.0564
R11111 VSS.n569 VSS.n489 1.0564
R11112 VSS.n3094 VSS.n510 1.0564
R11113 VSS.n2954 VSS.n2953 1.0564
R11114 VSS.n617 VSS.n616 1.0564
R11115 VSS.n3179 VSS.n3178 1.0564
R11116 VSS.n2284 VSS.n1262 1.0564
R11117 VSS.n2295 VSS.n1267 1.0564
R11118 VSS.n1227 VSS.n1226 1.0564
R11119 VSS.n2424 VSS.n2420 1.0564
R11120 VSS.n3110 VSS.n3106 1.0564
R11121 VSS.n978 VSS.n899 1.0564
R11122 VSS.n2317 VSS.n1277 1.0564
R11123 VSS.n2334 VSS.n2332 1.0564
R11124 VSS.n1619 VSS.n1615 1.0564
R11125 VSS.n3816 VSS.n132 1.0564
R11126 VSS.n3803 VSS.n137 1.0564
R11127 VSS.n3793 VSS.n142 1.0564
R11128 VSS.n2546 VSS.n2537 1.0564
R11129 VSS.n2522 VSS.n920 1.0564
R11130 VSS.n2833 VSS.n2829 1.0564
R11131 VSS.n2210 VSS.n2209 0.999974
R11132 VSS.n2212 VSS.n2211 0.994053
R11133 VSS.n1923 VSS.n1922 0.972821
R11134 VSS.n1949 VSS.n1948 0.972821
R11135 VSS.n1975 VSS.n1974 0.972821
R11136 VSS.n1894 VSS.n1889 0.972821
R11137 VSS.n2070 VSS.n1886 0.972821
R11138 VSS.n2054 VSS.n2053 0.972821
R11139 VSS.n3505 VSS.n256 0.972821
R11140 VSS.n3489 VSS.n3488 0.972821
R11141 VSS.n719 VSS.n718 0.972821
R11142 VSS.n694 VSS.n689 0.972821
R11143 VSS.n814 VSS.n686 0.972821
R11144 VSS.n798 VSS.n797 0.972821
R11145 VSS.n3393 VSS.n399 0.972821
R11146 VSS.n3377 VSS.n3376 0.972821
R11147 VSS.n3251 VSS.n3250 0.972821
R11148 VSS.n3277 VSS.n3276 0.972821
R11149 VSS.n3303 VSS.n3302 0.972821
R11150 VSS.n3324 VSS.n3208 0.972821
R11151 VSS.n2653 VSS.n1087 0.959
R11152 VSS.n577 VSS.n576 0.959
R11153 VSS.n3059 VSS.n516 0.959
R11154 VSS.n2974 VSS.n2973 0.959
R11155 VSS.n646 VSS.n634 0.959
R11156 VSS.n3195 VSS.n3194 0.959
R11157 VSS.n2578 VSS.n1062 0.959
R11158 VSS.n2600 VSS.n1072 0.959
R11159 VSS.n2589 VSS.n1067 0.959
R11160 VSS.n2556 VSS.n1052 0.959
R11161 VSS.n2567 VSS.n1057 0.959
R11162 VSS.n3072 VSS.n3071 0.959
R11163 VSS.n1019 VSS.n995 0.959
R11164 VSS.n2664 VSS.n1092 0.959
R11165 VSS.n2681 VSS.n2679 0.959
R11166 VSS.n3899 VSS.n3898 0.959
R11167 VSS.n3775 VSS.n3774 0.959
R11168 VSS.n2799 VSS.n2795 0.959
R11169 VSS.n1039 VSS.n927 0.959
R11170 VSS.n1029 VSS.n947 0.959
R11171 VSS.n2313 VSS.n1296 0.9455
R11172 VSS.n3127 VSS.n3123 0.9455
R11173 VSS.n2945 VSS.n2937 0.9455
R11174 VSS.n885 VSS.n884 0.9455
R11175 VSS.n608 VSS.n475 0.9455
R11176 VSS.n3171 VSS.n3170 0.9455
R11177 VSS.n2251 VSS.n1789 0.9455
R11178 VSS.n2280 VSS.n1311 0.9455
R11179 VSS.n1361 VSS.n1360 0.9455
R11180 VSS.n2291 VSS.n1306 0.9455
R11181 VSS.n2302 VSS.n1301 0.9455
R11182 VSS.n2441 VSS.n2437 0.9455
R11183 VSS.n1774 VSS.n1234 0.9455
R11184 VSS.n2897 VSS.n496 0.9455
R11185 VSS.n2850 VSS.n2846 0.9455
R11186 VSS.n2324 VSS.n1291 0.9455
R11187 VSS.n1665 VSS.n1661 0.9455
R11188 VSS.n1612 VSS.n1610 0.9455
R11189 VSS.n1595 VSS.n1416 0.9455
R11190 VSS.n1584 VSS.n1411 0.9455
R11191 VSS.n1653 VSS.n1649 0.9455
R11192 VSS.n1211 VSS.n1210 0.9455
R11193 VSS.n2529 VSS.n2520 0.9455
R11194 VSS.n2505 VSS.n906 0.9455
R11195 VSS.n3846 VSS.n70 0.908789
R11196 VSS.n1929 VSS.n1905 0.886036
R11197 VSS.n1981 VSS.n1895 0.886036
R11198 VSS.n2022 VSS.n2016 0.886036
R11199 VSS.n264 VSS.n258 0.886036
R11200 VSS.n725 VSS.n695 0.886036
R11201 VSS.n766 VSS.n760 0.886036
R11202 VSS.n407 VSS.n401 0.886036
R11203 VSS.n3257 VSS.n3227 0.886036
R11204 VSS.n3309 VSS.n3213 0.886036
R11205 VSS.n1871 VSS.n1870 0.884812
R11206 VSS.n1866 VSS.n1863 0.884812
R11207 VSS.n1874 VSS.n1873 0.884399
R11208 VSS VSS.n3221 0.880935
R11209 VSS.n1955 VSS.n1902 0.871571
R11210 VSS.n2002 VSS.n2001 0.871571
R11211 VSS.n2047 VSS.n2026 0.871571
R11212 VSS.n3482 VSS.n268 0.871571
R11213 VSS.n746 VSS.n745 0.871571
R11214 VSS.n791 VSS.n770 0.871571
R11215 VSS.n3370 VSS.n411 0.871571
R11216 VSS.n3283 VSS.n3224 0.871571
R11217 VSS.n3577 VSS.n3575 0.854848
R11218 VSS.n3716 VSS.n169 0.8445
R11219 VSS.n676 VSS.n654 0.8445
R11220 VSS.n3055 VSS.n3053 0.8445
R11221 VSS.n2983 VSS.n2982 0.8445
R11222 VSS.n639 VSS.n638 0.8445
R11223 VSS.n3341 VSS.n3202 0.8445
R11224 VSS.n3608 VSS.n194 0.8445
R11225 VSS.n3628 VSS.n184 0.8445
R11226 VSS.n3618 VSS.n189 0.8445
R11227 VSS.n3638 VSS.n179 0.8445
R11228 VSS.n3706 VSS.n174 0.8445
R11229 VSS.n2782 VSS.n2778 0.8445
R11230 VSS.n3598 VSS.n199 0.8445
R11231 VSS.n3044 VSS.n527 0.8445
R11232 VSS.n1012 VSS.n1011 0.8445
R11233 VSS.n3726 VSS.n164 0.8445
R11234 VSS.n3736 VSS.n159 0.8445
R11235 VSS.n3863 VSS.n3861 0.8445
R11236 VSS.n3885 VSS.n3881 0.8445
R11237 VSS.n3744 VSS.n93 0.8445
R11238 VSS.n3764 VSS.n3763 0.8445
R11239 VSS.n1045 VSS.n1044 0.8445
R11240 VSS.n3430 VSS.n384 0.8445
R11241 VSS.n3420 VSS.n389 0.8445
R11242 VSS.n1900 VSS 0.78963
R11243 VSS VSS.n2072 0.78963
R11244 VSS VSS.n3507 0.78963
R11245 VSS VSS.n816 0.78963
R11246 VSS.n3395 VSS 0.78963
R11247 VSS.n3364 VSS 0.78963
R11248 VSS.n3222 VSS 0.78963
R11249 VSS.t459 VSS.t458 0.786664
R11250 VSS.t460 VSS.t457 0.786664
R11251 VSS.n305 VSS.n304 0.784638
R11252 VSS.n2216 VSS.n2215 0.777342
R11253 VSS.n1801 VSS.n1800 0.777342
R11254 VSS.n100 VSS.n74 0.7589
R11255 VSS.n3854 VSS.n3853 0.7587
R11256 VSS.n66 VSS.t46 0.747936
R11257 VSS.n2155 VSS 0.746553
R11258 VSS.n2183 VSS 0.746553
R11259 VSS VSS.n57 0.746553
R11260 VSS.n60 VSS 0.746553
R11261 VSS.n47 VSS 0.746553
R11262 VSS.n3458 VSS 0.740632
R11263 VSS.n2196 VSS.n2194 0.739625
R11264 VSS.n3529 VSS 0.732342
R11265 VSS.n309 VSS 0.732342
R11266 VSS.n1911 VSS 0.718893
R11267 VSS.n1918 VSS 0.718893
R11268 VSS.n1937 VSS 0.718893
R11269 VSS.n1944 VSS 0.718893
R11270 VSS.n1963 VSS 0.718893
R11271 VSS.n1970 VSS 0.718893
R11272 VSS.n1989 VSS 0.718893
R11273 VSS.n1996 VSS 0.718893
R11274 VSS.n2011 VSS 0.718893
R11275 VSS.n2066 VSS 0.718893
R11276 VSS.n2061 VSS 0.718893
R11277 VSS.n2033 VSS 0.718893
R11278 VSS VSS.n2028 0.718893
R11279 VSS.n3501 VSS 0.718893
R11280 VSS.n3496 VSS 0.718893
R11281 VSS.n701 VSS 0.718893
R11282 VSS.n707 VSS 0.718893
R11283 VSS.n714 VSS 0.718893
R11284 VSS.n733 VSS 0.718893
R11285 VSS.n740 VSS 0.718893
R11286 VSS.n755 VSS 0.718893
R11287 VSS.n810 VSS 0.718893
R11288 VSS.n805 VSS 0.718893
R11289 VSS.n777 VSS 0.718893
R11290 VSS VSS.n772 0.718893
R11291 VSS.n3389 VSS 0.718893
R11292 VSS.n3384 VSS 0.718893
R11293 VSS.n3233 VSS 0.718893
R11294 VSS.n3239 VSS 0.718893
R11295 VSS.n3246 VSS 0.718893
R11296 VSS.n3265 VSS 0.718893
R11297 VSS.n3272 VSS 0.718893
R11298 VSS.n3291 VSS 0.718893
R11299 VSS.n3298 VSS 0.718893
R11300 VSS.n3317 VSS 0.718893
R11301 VSS.n1922 VSS 0.718893
R11302 VSS VSS.n1929 0.718893
R11303 VSS.n1948 VSS 0.718893
R11304 VSS VSS.n1955 0.718893
R11305 VSS.n1974 VSS 0.718893
R11306 VSS VSS.n1981 0.718893
R11307 VSS VSS.n1894 0.718893
R11308 VSS.n2002 VSS 0.718893
R11309 VSS VSS.n2070 0.718893
R11310 VSS VSS.n2022 0.718893
R11311 VSS.n2054 VSS 0.718893
R11312 VSS.n2047 VSS 0.718893
R11313 VSS VSS.n3505 0.718893
R11314 VSS VSS.n264 0.718893
R11315 VSS.n3489 VSS 0.718893
R11316 VSS.n3482 VSS 0.718893
R11317 VSS.n718 VSS 0.718893
R11318 VSS VSS.n725 0.718893
R11319 VSS VSS.n694 0.718893
R11320 VSS.n746 VSS 0.718893
R11321 VSS VSS.n814 0.718893
R11322 VSS VSS.n766 0.718893
R11323 VSS.n798 VSS 0.718893
R11324 VSS.n791 VSS 0.718893
R11325 VSS VSS.n3393 0.718893
R11326 VSS VSS.n407 0.718893
R11327 VSS.n3377 VSS 0.718893
R11328 VSS.n3370 VSS 0.718893
R11329 VSS.n3250 VSS 0.718893
R11330 VSS VSS.n3257 0.718893
R11331 VSS.n3276 VSS 0.718893
R11332 VSS VSS.n3283 0.718893
R11333 VSS.n3302 VSS 0.718893
R11334 VSS VSS.n3309 0.718893
R11335 VSS VSS.n3208 0.718893
R11336 VSS.n3019 VSS.n3005 0.716587
R11337 VSS.t11 VSS.t14 0.714237
R11338 VSS.t13 VSS.t12 0.714237
R11339 VSS.n3453 VSS.n326 0.697274
R11340 VSS.n3536 VSS.n3535 0.696816
R11341 VSS.n312 VSS.n311 0.692079
R11342 VSS.n3456 VSS.n297 0.690895
R11343 VSS.n2232 VSS.n2231 0.676922
R11344 VSS.n2145 VSS.n2091 0.676922
R11345 VSS.n2621 VSS.n1077 0.6748
R11346 VSS.n2638 VSS.n1082 0.6739
R11347 VSS.n2266 VSS.n1252 0.6331
R11348 VSS.n2116 VSS.n1247 0.6329
R11349 VSS.n2203 VSS.n1257 0.6324
R11350 VSS.n3521 VSS.n3520 0.613543
R11351 VSS.n303 VSS.n301 0.581879
R11352 VSS VSS.n238 0.572474
R11353 VSS VSS.n206 0.572474
R11354 VSS.n1914 VSS.n1906 0.571036
R11355 VSS.n1917 VSS.n1916 0.571036
R11356 VSS.n1940 VSS.n1903 0.571036
R11357 VSS.n1943 VSS.n1942 0.571036
R11358 VSS.n1966 VSS.n1896 0.571036
R11359 VSS.n1969 VSS.n1968 0.571036
R11360 VSS.n1992 VSS.n1892 0.571036
R11361 VSS.n1995 VSS.n1994 0.571036
R11362 VSS.n2014 VSS.n1887 0.571036
R11363 VSS.n2065 VSS.n2064 0.571036
R11364 VSS.n2030 VSS.n2029 0.571036
R11365 VSS.n2035 VSS.n2034 0.571036
R11366 VSS.n2040 VSS.n2039 0.571036
R11367 VSS.n3500 VSS.n3499 0.571036
R11368 VSS.n698 VSS.n697 0.571036
R11369 VSS.n704 VSS.n702 0.571036
R11370 VSS.n710 VSS.n696 0.571036
R11371 VSS.n713 VSS.n712 0.571036
R11372 VSS.n736 VSS.n692 0.571036
R11373 VSS.n739 VSS.n738 0.571036
R11374 VSS.n758 VSS.n687 0.571036
R11375 VSS.n809 VSS.n808 0.571036
R11376 VSS.n774 VSS.n773 0.571036
R11377 VSS.n779 VSS.n778 0.571036
R11378 VSS.n784 VSS.n783 0.571036
R11379 VSS.n3388 VSS.n3387 0.571036
R11380 VSS.n3230 VSS.n3229 0.571036
R11381 VSS.n3236 VSS.n3234 0.571036
R11382 VSS.n3242 VSS.n3228 0.571036
R11383 VSS.n3245 VSS.n3244 0.571036
R11384 VSS.n3268 VSS.n3225 0.571036
R11385 VSS.n3271 VSS.n3270 0.571036
R11386 VSS.n3294 VSS.n3214 0.571036
R11387 VSS.n3297 VSS.n3296 0.571036
R11388 VSS.n3320 VSS.n3211 0.571036
R11389 VSS.n3954 VSS.n29 0.571036
R11390 VSS.n3951 VSS.n30 0.571036
R11391 VSS.n1930 VSS.n1904 0.571036
R11392 VSS.n1934 VSS.n1933 0.571036
R11393 VSS.n1956 VSS.n1897 0.571036
R11394 VSS.n1960 VSS.n1959 0.571036
R11395 VSS.n1982 VSS.n1893 0.571036
R11396 VSS.n1986 VSS.n1985 0.571036
R11397 VSS.n2007 VSS.n2006 0.571036
R11398 VSS.n2008 VSS.n1885 0.571036
R11399 VSS.n2023 VSS.n2015 0.571036
R11400 VSS.n2058 VSS.n2057 0.571036
R11401 VSS.n2046 VSS.n2043 0.571036
R11402 VSS.n2027 VSS.n255 0.571036
R11403 VSS.n265 VSS.n257 0.571036
R11404 VSS.n3493 VSS.n3492 0.571036
R11405 VSS.n3481 VSS.n269 0.571036
R11406 VSS.n3478 VSS.n270 0.571036
R11407 VSS.n726 VSS.n693 0.571036
R11408 VSS.n730 VSS.n729 0.571036
R11409 VSS.n751 VSS.n750 0.571036
R11410 VSS.n752 VSS.n685 0.571036
R11411 VSS.n767 VSS.n759 0.571036
R11412 VSS.n802 VSS.n801 0.571036
R11413 VSS.n790 VSS.n787 0.571036
R11414 VSS.n771 VSS.n398 0.571036
R11415 VSS.n408 VSS.n400 0.571036
R11416 VSS.n3381 VSS.n3380 0.571036
R11417 VSS.n3369 VSS.n412 0.571036
R11418 VSS.n3366 VSS.n413 0.571036
R11419 VSS.n3258 VSS.n3226 0.571036
R11420 VSS.n3262 VSS.n3261 0.571036
R11421 VSS.n3284 VSS.n3215 0.571036
R11422 VSS.n3288 VSS.n3287 0.571036
R11423 VSS.n3310 VSS.n3212 0.571036
R11424 VSS.n3314 VSS.n3313 0.571036
R11425 VSS.n1867 VSS 0.570105
R11426 VSS.n3454 VSS.n325 0.563726
R11427 VSS.n1825 VSS 0.560632
R11428 VSS.n2130 VSS 0.560632
R11429 VSS VSS.n2107 0.560632
R11430 VSS.n2122 VSS 0.560632
R11431 VSS.n2225 VSS 0.560632
R11432 VSS.n3923 VSS 0.560632
R11433 VSS.n68 VSS 0.560632
R11434 VSS.n3982 VSS 0.560632
R11435 VSS.n3447 VSS 0.555895
R11436 VSS.n2180 VSS.n2177 0.551158
R11437 VSS.n1909 VSS.n30 0.546365
R11438 VSS.n1935 VSS.n1934 0.546365
R11439 VSS.n1961 VSS.n1960 0.546365
R11440 VSS.n1987 VSS.n1986 0.546365
R11441 VSS.n2009 VSS.n2008 0.546365
R11442 VSS.n2059 VSS.n2058 0.546365
R11443 VSS.n2042 VSS.n2027 0.546365
R11444 VSS.n3494 VSS.n3493 0.546365
R11445 VSS.n705 VSS.n270 0.546365
R11446 VSS.n731 VSS.n730 0.546365
R11447 VSS.n753 VSS.n752 0.546365
R11448 VSS.n803 VSS.n802 0.546365
R11449 VSS.n786 VSS.n771 0.546365
R11450 VSS.n3382 VSS.n3381 0.546365
R11451 VSS.n3237 VSS.n413 0.546365
R11452 VSS.n3263 VSS.n3262 0.546365
R11453 VSS.n3289 VSS.n3288 0.546365
R11454 VSS.n3315 VSS.n3314 0.546365
R11455 VSS.n3587 VSS.n3586 0.529842
R11456 VSS.n1841 VSS.n1840 0.523921
R11457 VSS.n2096 VSS.n1796 0.521553
R11458 VSS.n1909 VSS.n29 0.521102
R11459 VSS.n1935 VSS.n1904 0.521102
R11460 VSS.n1961 VSS.n1897 0.521102
R11461 VSS.n1987 VSS.n1893 0.521102
R11462 VSS.n2009 VSS.n2007 0.521102
R11463 VSS.n2059 VSS.n2015 0.521102
R11464 VSS.n2043 VSS.n2042 0.521102
R11465 VSS.n3494 VSS.n257 0.521102
R11466 VSS.n705 VSS.n269 0.521102
R11467 VSS.n731 VSS.n693 0.521102
R11468 VSS.n753 VSS.n751 0.521102
R11469 VSS.n803 VSS.n759 0.521102
R11470 VSS.n787 VSS.n786 0.521102
R11471 VSS.n3382 VSS.n400 0.521102
R11472 VSS.n3237 VSS.n412 0.521102
R11473 VSS.n3263 VSS.n3226 0.521102
R11474 VSS.n3289 VSS.n3215 0.521102
R11475 VSS.n3315 VSS.n3212 0.521102
R11476 VSS.n2237 VSS.n2236 0.519184
R11477 VSS.n2139 VSS.n2120 0.499053
R11478 VSS.n2113 VSS.n2112 0.497868
R11479 VSS.n2153 VSS.n2152 0.494316
R11480 VSS.n2174 VSS.n1806 0.487729
R11481 VSS.n3403 VSS.n226 0.487195
R11482 VSS.n2631 VSS.n1122 0.486026
R11483 VSS.n1899 VSS.n31 0.475283
R11484 VSS.n3940 VSS.n35 0.475283
R11485 VSS.n2075 VSS.n254 0.475283
R11486 VSS.n3520 VSS.n251 0.475283
R11487 VSS.n3578 VSS.n3577 0.475283
R11488 VSS.n3026 VSS.n3024 0.475283
R11489 VSS.n3358 VSS.n3357 0.475283
R11490 VSS.n2206 VSS 0.45005
R11491 VSS.n2217 VSS.t247 0.449938
R11492 VSS.n1802 VSS.t391 0.449938
R11493 VSS.n3962 VSS.n3961 0.446
R11494 VSS.n7 VSS.n4 0.4445
R11495 VSS.n3965 VSS 0.4415
R11496 VSS.n3719 VSS.n3718 0.4403
R11497 VSS.n1001 VSS.n831 0.4403
R11498 VSS.n2705 VSS.n2699 0.4403
R11499 VSS.n997 VSS.n837 0.4403
R11500 VSS.n2663 VSS.n2662 0.4403
R11501 VSS.n990 VSS.n843 0.4403
R11502 VSS.n2361 VSS.n2355 0.4403
R11503 VSS.n981 VSS.n849 0.4403
R11504 VSS.n2316 VSS.n2315 0.4403
R11505 VSS.n898 VSS.n855 0.4403
R11506 VSS.n1685 VSS.n1679 0.4403
R11507 VSS.n2856 VSS.n2855 0.4403
R11508 VSS.n1544 VSS.n1543 0.4403
R11509 VSS.n2869 VSS.n877 0.4403
R11510 VSS.n2187 VSS.n2186 0.432619
R11511 VSS.n3454 VSS.n3453 0.426306
R11512 VSS.n1121 VSS.n23 0.420895
R11513 VSS.n3357 VSS.n3355 0.419196
R11514 VSS.n3739 VSS.n3738 0.41735
R11515 VSS.n3423 VSS.n3422 0.41735
R11516 VSS.n2687 VSS.n152 0.41735
R11517 VSS.n1032 VSS.n1031 0.41735
R11518 VSS.n1097 VSS.n148 0.41735
R11519 VSS.n963 VSS.n926 0.41735
R11520 VSS.n2343 VSS.n144 0.41735
R11521 VSS.n2822 VSS.n2821 0.41735
R11522 VSS.n1404 VSS.n1282 0.41735
R11523 VSS.n2835 VSS.n907 0.41735
R11524 VSS.n1667 VSS.n1658 0.41735
R11525 VSS.n2515 VSS.n2514 0.41735
R11526 VSS.n1566 VSS.n1565 0.41735
R11527 VSS.n2476 VSS.n2475 0.41735
R11528 VSS.n3641 VSS.n3640 0.4154
R11529 VSS.n3047 VSS.n3046 0.4154
R11530 VSS.n2723 VSS.n2717 0.4154
R11531 VSS.n3064 VSS.n3063 0.4154
R11532 VSS.n1133 VSS.n1118 0.4154
R11533 VSS.n3082 VSS.n3081 0.4154
R11534 VSS.n2382 VSS.n2373 0.4154
R11535 VSS.n3099 VSS.n3098 0.4154
R11536 VSS.n2294 VSS.n2293 0.4154
R11537 VSS.n3112 VSS.n497 0.4154
R11538 VSS.n1703 VSS.n1697 0.4154
R11539 VSS.n2900 VSS.n867 0.4154
R11540 VSS.n1522 VSS.n1521 0.4154
R11541 VSS.n2918 VSS.n2917 0.4154
R11542 VSS.n3872 VSS.n3871 0.41495
R11543 VSS.n3754 VSS.n3753 0.41495
R11544 VSS.n3729 VSS.n3728 0.41495
R11545 VSS.n3709 VSS.n3708 0.41495
R11546 VSS.n3631 VSS.n3630 0.41495
R11547 VSS.n3611 VSS.n3610 0.41495
R11548 VSS.n2771 VSS.n201 0.41495
R11549 VSS.n3433 VSS.n3432 0.41495
R11550 VSS.n1002 VSS.n391 0.41495
R11551 VSS.n2988 VSS.n2987 0.41495
R11552 VSS.n679 VSS.n678 0.41495
R11553 VSS.n3344 VSS.n3343 0.41495
R11554 VSS.n3887 VSS.n101 0.41495
R11555 VSS.n3767 VSS.n92 0.41495
R11556 VSS.n2696 VSS.n2690 0.41495
R11557 VSS.n2714 VSS.n2708 0.41495
R11558 VSS.n2732 VSS.n2726 0.41495
R11559 VSS.n2750 VSS.n2744 0.41495
R11560 VSS.n2784 VSS.n2762 0.41495
R11561 VSS.n1042 VSS.n1041 0.41495
R11562 VSS.n1022 VSS.n1021 0.41495
R11563 VSS.n2977 VSS.n534 0.41495
R11564 VSS.n549 VSS.n526 0.41495
R11565 VSS.n636 VSS.n434 0.41495
R11566 VSS.n3828 VSS.n77 0.41495
R11567 VSS.n3778 VSS.n88 0.41495
R11568 VSS.n2674 VSS.n2673 0.41495
R11569 VSS.n2652 VSS.n2651 0.41495
R11570 VSS.n2610 VSS.n2609 0.41495
R11571 VSS.n2588 VSS.n2587 0.41495
R11572 VSS.n2566 VSS.n2565 0.41495
R11573 VSS.n2805 VSS.n2804 0.41495
R11574 VSS.n967 VSS.n966 0.41495
R11575 VSS.n2968 VSS.n2967 0.41495
R11576 VSS.n580 VSS.n522 0.41495
R11577 VSS.n629 VSS.n440 0.41495
R11578 VSS.n3819 VSS.n3818 0.41495
R11579 VSS.n3796 VSS.n3795 0.41495
R11580 VSS.n2352 VSS.n2346 0.41495
R11581 VSS.n2370 VSS.n2364 0.41495
R11582 VSS.n2391 VSS.n2385 0.41495
R11583 VSS.n2409 VSS.n2403 0.41495
R11584 VSS.n1240 VSS.n1163 0.41495
R11585 VSS.n2818 VSS.n921 0.41495
R11586 VSS.n973 VSS.n912 0.41495
R11587 VSS.n2957 VSS.n511 0.41495
R11588 VSS.n593 VSS.n502 0.41495
R11589 VSS.n620 VSS.n446 0.41495
R11590 VSS.n1629 VSS.n1623 0.41495
R11591 VSS.n1642 VSS.n1641 0.41495
R11592 VSS.n2327 VSS.n2326 0.41495
R11593 VSS.n2305 VSS.n2304 0.41495
R11594 VSS.n2283 VSS.n2282 0.41495
R11595 VSS.n2254 VSS.n2253 0.41495
R11596 VSS.n2430 VSS.n2429 0.41495
R11597 VSS.n2532 VSS.n2531 0.41495
R11598 VSS.n2839 VSS.n2838 0.41495
R11599 VSS.n2948 VSS.n2947 0.41495
R11600 VSS.n3116 VSS.n3115 0.41495
R11601 VSS.n611 VSS.n452 0.41495
R11602 VSS.n1605 VSS.n1604 0.41495
R11603 VSS.n1655 VSS.n1399 0.41495
R11604 VSS.n1676 VSS.n1670 0.41495
R11605 VSS.n1694 VSS.n1688 0.41495
R11606 VSS.n1712 VSS.n1706 0.41495
R11607 VSS.n1358 VSS.n1333 0.41495
R11608 VSS.n2443 VSS.n1219 0.41495
R11609 VSS.n1208 VSS.n1183 0.41495
R11610 VSS.n2852 VSS.n893 0.41495
R11611 VSS.n882 VSS.n865 0.41495
R11612 VSS.n3129 VSS.n483 0.41495
R11613 VSS.n474 VSS.n458 0.41495
R11614 VSS.n1461 VSS.n1455 0.41495
R11615 VSS.n1577 VSS.n1576 0.41495
R11616 VSS.n1555 VSS.n1554 0.41495
R11617 VSS.n1533 VSS.n1532 0.41495
R11618 VSS.n1511 VSS.n1510 0.41495
R11619 VSS.n1741 VSS.n1732 0.41495
R11620 VSS.n1767 VSS.n1766 0.41495
R11621 VSS.n2472 VSS.n2463 0.41495
R11622 VSS.n2498 VSS.n2497 0.41495
R11623 VSS.n2873 VSS.n2872 0.41495
R11624 VSS.n2893 VSS.n2892 0.41495
R11625 VSS.n3150 VSS.n3149 0.41495
R11626 VSS.n3750 VSS.n106 0.4148
R11627 VSS.n3621 VSS.n3620 0.4148
R11628 VSS.n2767 VSS.n375 0.4148
R11629 VSS.n656 VSS.n424 0.4148
R11630 VSS.n3891 VSS.n3890 0.4148
R11631 VSS.n2741 VSS.n2735 0.4148
R11632 VSS.n2788 VSS.n2787 0.4148
R11633 VSS.n649 VSS.n648 0.4148
R11634 VSS.n3909 VSS.n3908 0.4148
R11635 VSS.n2599 VSS.n2598 0.4148
R11636 VSS.n2801 VSS.n935 0.4148
R11637 VSS.n574 VSS.n559 0.4148
R11638 VSS.n3806 VSS.n3805 0.4148
R11639 VSS.n2400 VSS.n2394 0.4148
R11640 VSS.n2549 VSS.n2548 0.4148
R11641 VSS.n597 VSS.n596 0.4148
R11642 VSS.n1638 VSS.n1632 0.4148
R11643 VSS.n1323 VSS.n1313 0.4148
R11644 VSS.n1224 VSS.n1173 0.4148
R11645 VSS.n603 VSS.n488 0.4148
R11646 VSS.n1594 VSS.n1593 0.4148
R11647 VSS.n1716 VSS.n1715 0.4148
R11648 VSS.n2447 VSS.n2446 0.4148
R11649 VSS.n3133 VSS.n3132 0.4148
R11650 VSS.n1465 VSS.n1464 0.4148
R11651 VSS.n1729 VSS.n1353 0.4148
R11652 VSS.n2460 VSS.n1203 0.4148
R11653 VSS.n3146 VSS.n469 0.4148
R11654 VSS.n304 VSS.n303 0.414293
R11655 VSS.n2273 VSS.n2272 0.4117
R11656 VSS.n2244 VSS.n2243 0.4112
R11657 VSS.n2263 VSS.n2259 0.411
R11658 VSS.n2189 VSS.n1805 0.403504
R11659 VSS.n1872 VSS 0.401214
R11660 VSS.n1827 VSS.t457 0.393582
R11661 VSS.n1880 VSS.n1859 0.377079
R11662 VSS.n3985 VSS.n11 0.374711
R11663 VSS VSS.n272 0.363109
R11664 VSS.n55 VSS.t443 0.357368
R11665 VSS VSS.n1128 0.356947
R11666 VSS.n2632 VSS.n2631 0.352211
R11667 VSS VSS.n286 0.341553
R11668 VSS.n669 VSS.n668 0.3317
R11669 VSS.n3037 VSS.n3036 0.3316
R11670 VSS.n2994 VSS.n2993 0.3314
R11671 VSS.n3350 VSS.n3349 0.3309
R11672 VSS.n3334 VSS.n3333 0.3306
R11673 VSS.n3013 VSS.n539 0.3303
R11674 VSS.n3680 VSS.n3648 0.322106
R11675 VSS.n3983 VSS.n3982 0.3155
R11676 VSS.n1125 VSS.n1124 0.314316
R11677 VSS.n57 VSS.n53 0.314316
R11678 VSS.n60 VSS.n59 0.314316
R11679 VSS.n48 VSS.n47 0.314316
R11680 VSS.n1865 VSS.n1860 0.303603
R11681 VSS VSS.n1906 0.302643
R11682 VSS VSS.n1903 0.302643
R11683 VSS VSS.n1896 0.302643
R11684 VSS VSS.n1892 0.302643
R11685 VSS VSS.n1887 0.302643
R11686 VSS.n2029 VSS 0.302643
R11687 VSS VSS.n2040 0.302643
R11688 VSS.n697 VSS 0.302643
R11689 VSS VSS.n696 0.302643
R11690 VSS VSS.n692 0.302643
R11691 VSS VSS.n687 0.302643
R11692 VSS.n773 VSS 0.302643
R11693 VSS VSS.n784 0.302643
R11694 VSS.n3229 VSS 0.302643
R11695 VSS VSS.n3228 0.302643
R11696 VSS VSS.n3225 0.302643
R11697 VSS VSS.n3214 0.302643
R11698 VSS VSS.n3211 0.302643
R11699 VSS.n1911 VSS.n1910 0.299429
R11700 VSS.n1937 VSS.n1936 0.299429
R11701 VSS.n1963 VSS.n1962 0.299429
R11702 VSS.n1989 VSS.n1988 0.299429
R11703 VSS.n2011 VSS.n2010 0.299429
R11704 VSS.n2061 VSS.n2060 0.299429
R11705 VSS.n2041 VSS.n2028 0.299429
R11706 VSS.n3496 VSS.n3495 0.299429
R11707 VSS.n707 VSS.n706 0.299429
R11708 VSS.n733 VSS.n732 0.299429
R11709 VSS.n755 VSS.n754 0.299429
R11710 VSS.n805 VSS.n804 0.299429
R11711 VSS.n785 VSS.n772 0.299429
R11712 VSS.n3384 VSS.n3383 0.299429
R11713 VSS.n3239 VSS.n3238 0.299429
R11714 VSS.n3265 VSS.n3264 0.299429
R11715 VSS.n3291 VSS.n3290 0.299429
R11716 VSS.n3317 VSS.n3316 0.299429
R11717 VSS.n1128 VSS.n1122 0.295368
R11718 VSS VSS.n300 0.287052
R11719 VSS.n301 VSS 0.287052
R11720 VSS VSS.n305 0.287052
R11721 VSS.n3923 VSS.n3922 0.281158
R11722 VSS.n69 VSS.n68 0.279974
R11723 VSS.n3521 VSS.n249 0.278326
R11724 VSS.n3475 VSS.n272 0.278326
R11725 VSS.n337 VSS.n212 0.278326
R11726 VSS.n684 VSS.n213 0.278326
R11727 VSS.n3005 VSS.n828 0.278326
R11728 VSS.n3006 VSS.n683 0.278326
R11729 VSS.n3028 VSS.n414 0.278326
R11730 VSS.n659 VSS.n416 0.278326
R11731 VSS.n3355 VSS.n417 0.278326
R11732 VSS.n3398 VSS.n397 0.277022
R11733 VSS.n2197 VSS.t214 0.2765
R11734 VSS.n2195 VSS.t79 0.2765
R11735 VSS.n2193 VSS.t49 0.2765
R11736 VSS.n2192 VSS.t50 0.2765
R11737 VSS.n317 VSS.n316 0.27425
R11738 VSS.n2642 VSS.n2641 0.2728
R11739 VSS.n2616 VSS.n2615 0.2719
R11740 VSS.n3679 VSS.n3662 0.2705
R11741 VSS.n3681 VSS.n3661 0.2705
R11742 VSS.n3693 VSS.n3649 0.2705
R11743 VSS.n3695 VSS.n3645 0.2705
R11744 VSS.n325 VSS 0.2705
R11745 VSS.n3364 VSS.n414 0.269196
R11746 VSS VSS.n3445 0.266947
R11747 VSS.n2996 VSS.n828 0.262674
R11748 VSS.n3513 VSS.n249 0.26137
R11749 VSS.n337 VSS.n336 0.26137
R11750 VSS.n3575 VSS.n213 0.26137
R11751 VSS.n822 VSS.n397 0.26137
R11752 VSS.n3018 VSS.n3006 0.26137
R11753 VSS.n3028 VSS.n3027 0.26137
R11754 VSS.n659 VSS.n415 0.26137
R11755 VSS.n3221 VSS.n3207 0.26137
R11756 VSS.n1910 VSS 0.256036
R11757 VSS.n1936 VSS 0.256036
R11758 VSS.n1962 VSS 0.256036
R11759 VSS.n1988 VSS 0.256036
R11760 VSS.n2010 VSS 0.256036
R11761 VSS.n2060 VSS 0.256036
R11762 VSS.n2041 VSS 0.256036
R11763 VSS.n3495 VSS 0.256036
R11764 VSS.n706 VSS 0.256036
R11765 VSS.n732 VSS 0.256036
R11766 VSS.n754 VSS 0.256036
R11767 VSS.n804 VSS 0.256036
R11768 VSS.n785 VSS 0.256036
R11769 VSS.n3383 VSS 0.256036
R11770 VSS.n3238 VSS 0.256036
R11771 VSS.n3264 VSS 0.256036
R11772 VSS.n3290 VSS 0.256036
R11773 VSS.n3316 VSS 0.256036
R11774 VSS.n3404 VSS.n229 0.253921
R11775 VSS.n3960 VSS.n3959 0.252748
R11776 VSS.n3848 VSS.n3847 0.252737
R11777 VSS.n3968 VSS.n22 0.252335
R11778 VSS.n3963 VSS.n25 0.252335
R11779 VSS.n2113 VSS 0.249184
R11780 VSS VSS.n2120 0.248
R11781 VSS.n3561 VSS.n225 0.248
R11782 VSS VSS.n322 0.245339
R11783 VSS VSS.n326 0.245339
R11784 VSS.n9 VSS.t176 0.245069
R11785 VSS.n10 VSS.t175 0.245069
R11786 VSS.n0 VSS.t104 0.245069
R11787 VSS.n2 VSS.t30 0.245069
R11788 VSS.n5 VSS.t166 0.245069
R11789 VSS.n2221 VSS.n2220 0.24236
R11790 VSS.n2136 VSS.n2135 0.24236
R11791 VSS VSS.n1908 0.239964
R11792 VSS VSS.n1914 0.239964
R11793 VSS.n1916 VSS 0.239964
R11794 VSS VSS.n1940 0.239964
R11795 VSS.n1942 VSS 0.239964
R11796 VSS VSS.n1966 0.239964
R11797 VSS.n1968 VSS 0.239964
R11798 VSS VSS.n1992 0.239964
R11799 VSS.n1994 VSS 0.239964
R11800 VSS VSS.n2014 0.239964
R11801 VSS.n2064 VSS 0.239964
R11802 VSS.n2030 VSS 0.239964
R11803 VSS.n2035 VSS 0.239964
R11804 VSS.n2039 VSS 0.239964
R11805 VSS.n3499 VSS 0.239964
R11806 VSS.n698 VSS 0.239964
R11807 VSS VSS.n704 0.239964
R11808 VSS VSS.n710 0.239964
R11809 VSS.n712 VSS 0.239964
R11810 VSS VSS.n736 0.239964
R11811 VSS.n738 VSS 0.239964
R11812 VSS VSS.n758 0.239964
R11813 VSS.n808 VSS 0.239964
R11814 VSS.n774 VSS 0.239964
R11815 VSS.n779 VSS 0.239964
R11816 VSS.n783 VSS 0.239964
R11817 VSS.n3387 VSS 0.239964
R11818 VSS.n3230 VSS 0.239964
R11819 VSS VSS.n3236 0.239964
R11820 VSS VSS.n3242 0.239964
R11821 VSS.n3244 VSS 0.239964
R11822 VSS VSS.n3268 0.239964
R11823 VSS.n3270 VSS 0.239964
R11824 VSS VSS.n3294 0.239964
R11825 VSS.n3296 VSS 0.239964
R11826 VSS VSS.n3320 0.239964
R11827 VSS VSS.n3954 0.239964
R11828 VSS.n1930 VSS 0.239964
R11829 VSS.n1933 VSS 0.239964
R11830 VSS.n1956 VSS 0.239964
R11831 VSS.n1982 VSS 0.239964
R11832 VSS.n1985 VSS 0.239964
R11833 VSS.n2006 VSS 0.239964
R11834 VSS.n2023 VSS 0.239964
R11835 VSS.n2057 VSS 0.239964
R11836 VSS VSS.n2046 0.239964
R11837 VSS.n265 VSS 0.239964
R11838 VSS.n3492 VSS 0.239964
R11839 VSS VSS.n3481 0.239964
R11840 VSS.n726 VSS 0.239964
R11841 VSS.n729 VSS 0.239964
R11842 VSS.n750 VSS 0.239964
R11843 VSS.n767 VSS 0.239964
R11844 VSS.n801 VSS 0.239964
R11845 VSS VSS.n790 0.239964
R11846 VSS.n408 VSS 0.239964
R11847 VSS.n3380 VSS 0.239964
R11848 VSS VSS.n3369 0.239964
R11849 VSS.n3258 VSS 0.239964
R11850 VSS.n3261 VSS 0.239964
R11851 VSS.n3284 VSS 0.239964
R11852 VSS.n3310 VSS 0.239964
R11853 VSS.n3313 VSS 0.239964
R11854 VSS.n225 VSS.n221 0.239711
R11855 VSS.n3445 VSS.n329 0.237342
R11856 VSS.n349 VSS.n329 0.237342
R11857 VSS.n3848 VSS.n11 0.237342
R11858 VSS.n3920 VSS.n70 0.237342
R11859 VSS.n3404 VSS.n3403 0.236158
R11860 VSS.n2237 VSS 0.227868
R11861 VSS VSS.n1796 0.2255
R11862 VSS.n823 VSS.n822 0.224848
R11863 VSS.n1841 VSS 0.223132
R11864 VSS.n3463 VSS.n286 0.221947
R11865 VSS VSS.n1860 0.215672
R11866 VSS.n3330 VSS.n3207 0.214413
R11867 VSS.n2206 VSS.n2205 0.21065
R11868 VSS.n366 VSS.n221 0.209505
R11869 VSS.n2632 VSS 0.208921
R11870 VSS.n3648 VSS.t163 0.204015
R11871 VSS.n25 VSS.t170 0.204015
R11872 VSS.n3968 VSS.t65 0.204015
R11873 VSS.n3959 VSS.t126 0.204015
R11874 VSS.n1861 VSS.t98 0.204015
R11875 VSS.n1863 VSS.t388 0.204015
R11876 VSS.n1875 VSS.t172 0.204015
R11877 VSS.n1874 VSS.t168 0.204015
R11878 VSS.n1868 VSS.t194 0.204015
R11879 VSS.n1870 VSS.t193 0.204015
R11880 VSS.n1864 VSS.t100 0.204015
R11881 VSS.n1923 VSS.n1905 0.198179
R11882 VSS.n1949 VSS.n1902 0.198179
R11883 VSS.n1975 VSS.n1895 0.198179
R11884 VSS.n2001 VSS.n1889 0.198179
R11885 VSS.n2016 VSS.n1886 0.198179
R11886 VSS.n2053 VSS.n2026 0.198179
R11887 VSS.n258 VSS.n256 0.198179
R11888 VSS.n3488 VSS.n268 0.198179
R11889 VSS.n719 VSS.n695 0.198179
R11890 VSS.n745 VSS.n689 0.198179
R11891 VSS.n760 VSS.n686 0.198179
R11892 VSS.n797 VSS.n770 0.198179
R11893 VSS.n401 VSS.n399 0.198179
R11894 VSS.n3376 VSS.n411 0.198179
R11895 VSS.n3251 VSS.n3227 0.198179
R11896 VSS.n3277 VSS.n3224 0.198179
R11897 VSS.n3303 VSS.n3213 0.198179
R11898 VSS.n3951 VSS.n3950 0.196571
R11899 VSS.n1959 VSS.n1901 0.196571
R11900 VSS.n2071 VSS.n1885 0.196571
R11901 VSS.n3506 VSS.n255 0.196571
R11902 VSS.n3478 VSS.n3477 0.196571
R11903 VSS.n815 VSS.n685 0.196571
R11904 VSS.n3394 VSS.n398 0.196571
R11905 VSS.n3366 VSS.n3365 0.196571
R11906 VSS.n3287 VSS.n3223 0.196571
R11907 VSS.n820 VSS 0.1881
R11908 VSS.n3834 VSS.n3833 0.188
R11909 VSS.n3915 VSS.n3914 0.1878
R11910 VSS VSS.n1859 0.186421
R11911 VSS.n3969 VSS.n3968 0.182956
R11912 VSS.n3646 VSS.n25 0.182956
R11913 VSS.n3959 VSS.n3958 0.182956
R11914 VSS.n3648 VSS.n3647 0.182956
R11915 VSS.n3448 VSS.n3447 0.182868
R11916 VSS.n1881 VSS.n1880 0.181684
R11917 VSS.n3537 VSS.n237 0.181684
R11918 VSS.n3534 VSS.n238 0.181684
R11919 VSS.n3585 VSS.n206 0.181684
R11920 VSS.n313 VSS.n309 0.181684
R11921 VSS.n3458 VSS.n3457 0.1805
R11922 VSS.n1840 VSS.n1818 0.179316
R11923 VSS.n2155 VSS.n2154 0.179316
R11924 VSS.n2139 VSS.n2138 0.179316
R11925 VSS.n2112 VSS.n2108 0.179316
R11926 VSS.n2183 VSS.n2182 0.179316
R11927 VSS.n2097 VSS.n2096 0.179316
R11928 VSS.n2236 VSS.n1797 0.179316
R11929 VSS.n3413 VSS.n3412 0.1787
R11930 VSS.n1125 VSS.n23 0.178132
R11931 VSS.n1823 VSS 0.176947
R11932 VSS.n2088 VSS 0.176947
R11933 VSS.n2128 VSS 0.176947
R11934 VSS.n2101 VSS 0.176947
R11935 VSS.n1809 VSS 0.176947
R11936 VSS.n2125 VSS 0.176947
R11937 VSS.n2223 VSS 0.176947
R11938 VSS.n2768 VSS.n282 0.1751
R11939 VSS.n3356 VSS 0.175078
R11940 VSS.n3025 VSS 0.175078
R11941 VSS.n3396 VSS 0.175078
R11942 VSS.n3576 VSS 0.175078
R11943 VSS.n250 VSS 0.175078
R11944 VSS.n253 VSS 0.175078
R11945 VSS.n34 VSS 0.175078
R11946 VSS.n1898 VSS 0.175078
R11947 VSS.n3591 VSS.n3590 0.175
R11948 VSS.n3564 VSS.n223 0.175
R11949 VSS.n3439 VSS.n3438 0.1746
R11950 VSS.n3699 VSS.n3698 0.1738
R11951 VSS.n1867 VSS.n237 0.172211
R11952 VSS.n2213 VSS.n2212 0.172211
R11953 VSS.n3457 VSS.n3456 0.169842
R11954 VSS.n371 VSS.n350 0.169842
R11955 VSS.n3448 VSS.n297 0.168658
R11956 VSS.n1831 VSS.n1830 0.168242
R11957 VSS.n1832 VSS.n1820 0.168242
R11958 VSS.n1836 VSS.n1819 0.168242
R11959 VSS.n2149 VSS.n2085 0.168242
R11960 VSS.n2159 VSS.n2158 0.168242
R11961 VSS.n2162 VSS.n2161 0.168242
R11962 VSS.n2084 VSS.n1847 0.168242
R11963 VSS.n3537 VSS.n3536 0.167474
R11964 VSS.n3587 VSS.n205 0.167474
R11965 VSS.n313 VSS.n312 0.167474
R11966 VSS.n2211 VSS.n2210 0.167474
R11967 VSS.n372 VSS.n371 0.165105
R11968 VSS.n1881 VSS.n1858 0.163921
R11969 VSS.n3535 VSS.n3534 0.163921
R11970 VSS.n3586 VSS.n3585 0.163921
R11971 VSS.n1869 VSS.n1868 0.158637
R11972 VSS.n1876 VSS.n1875 0.158637
R11973 VSS.n1862 VSS.n1861 0.158637
R11974 VSS.n1863 VSS.n1862 0.158637
R11975 VSS.n1876 VSS.n1874 0.158637
R11976 VSS.n1870 VSS.n1869 0.158637
R11977 VSS.n3360 VSS.n231 0.15839
R11978 VSS.n3528 VSS.n242 0.155632
R11979 VSS.n3464 VSS.n285 0.152079
R11980 VSS.n62 VSS.t334 0.149987
R11981 VSS.n3476 VSS.n3475 0.149196
R11982 VSS VSS.n1121 0.148526
R11983 VSS.n2219 VSS.n2218 0.14706
R11984 VSS.n3526 VSS.n3524 0.1429
R11985 VSS.n3470 VSS.n3469 0.1428
R11986 VSS.n3443 VSS.n345 0.1428
R11987 VSS.n3569 VSS.n3568 0.1428
R11988 VSS.n3408 VSS.n3401 0.1428
R11989 VSS.n2199 VSS.n2191 0.1355
R11990 VSS.n2090 VSS.n1803 0.131
R11991 VSS.n3960 VSS.n26 0.127656
R11992 VSS.n3966 VSS.n22 0.127656
R11993 VSS.n3964 VSS.n3963 0.127656
R11994 VSS.n3961 VSS 0.122
R11995 VSS.n3476 VSS.n271 0.112674
R11996 VSS.n320 VSS.n289 0.109974
R11997 VSS.n323 VSS.n292 0.109974
R11998 VSS.n359 VSS.n357 0.109974
R11999 VSS.n354 VSS.n351 0.109974
R12000 VSS.n1842 VSS.n1795 0.10985
R12001 VSS VSS.n3942 0.104711
R12002 VSS.n3948 VSS 0.104711
R12003 VSS.n2073 VSS 0.104711
R12004 VSS.n3325 VSS 0.104711
R12005 VSS.n3329 VSS 0.104711
R12006 VSS.n3362 VSS 0.104711
R12007 VSS VSS.n3020 0.104711
R12008 VSS VSS.n824 0.104711
R12009 VSS VSS.n3515 0.104711
R12010 VSS.n334 VSS 0.104711
R12011 VSS.n2996 VSS 0.0996304
R12012 VSS.n2269 VSS.n1317 0.09635
R12013 VSS.n2205 VSS.n1317 0.0905
R12014 VSS.n2268 VSS.n1318 0.0905
R12015 VSS.n243 VSS.n205 0.0857632
R12016 VSS.n310 VSS.n285 0.0857632
R12017 VSS.n1824 VSS.n1823 0.084579
R12018 VSS.n2088 VSS.n2087 0.084579
R12019 VSS.n2129 VSS.n2128 0.084579
R12020 VSS.n2101 VSS.n2100 0.084579
R12021 VSS.n1809 VSS.n1808 0.084579
R12022 VSS.n2125 VSS.n2121 0.084579
R12023 VSS.n2224 VSS.n2223 0.084579
R12024 VSS.n311 VSS.n310 0.0833947
R12025 VSS.n243 VSS.n242 0.0822105
R12026 VSS.n2178 VSS.n1318 0.08105
R12027 VSS.n2619 VSS.n2618 0.0771116
R12028 VSS.n2635 VSS.n2634 0.0748802
R12029 VSS.n2240 VSS.n1794 0.0716
R12030 VSS.n3656 VSS.n3655 0.0716
R12031 VSS VSS.n1924 0.0696667
R12032 VSS VSS.n1950 0.0696667
R12033 VSS VSS.n1976 0.0696667
R12034 VSS VSS.n1890 0.0696667
R12035 VSS VSS.n2017 0.0696667
R12036 VSS.n2052 VSS 0.0696667
R12037 VSS VSS.n259 0.0696667
R12038 VSS.n3487 VSS 0.0696667
R12039 VSS VSS.n720 0.0696667
R12040 VSS VSS.n690 0.0696667
R12041 VSS VSS.n761 0.0696667
R12042 VSS.n796 VSS 0.0696667
R12043 VSS VSS.n402 0.0696667
R12044 VSS.n3375 VSS 0.0696667
R12045 VSS VSS.n3252 0.0696667
R12046 VSS VSS.n3278 0.0696667
R12047 VSS VSS.n3304 0.0696667
R12048 VSS VSS.n3209 0.0696667
R12049 VSS.n3690 VSS.n3684 0.0691
R12050 VSS.n2179 VSS.n2178 0.06755
R12051 VSS VSS.n2153 0.0668158
R12052 VSS.n3327 VSS 0.0644474
R12053 VSS.n2640 VSS.n2639 0.0574008
R12054 VSS.n75 VSS.n72 0.0574008
R12055 VSS.n3669 VSS.n3668 0.0571
R12056 VSS.n3950 VSS 0.0438929
R12057 VSS.n1901 VSS 0.0438929
R12058 VSS.n2071 VSS 0.0438929
R12059 VSS.n3506 VSS 0.0438929
R12060 VSS.n3477 VSS 0.0438929
R12061 VSS.n815 VSS 0.0438929
R12062 VSS.n3394 VSS 0.0438929
R12063 VSS.n3365 VSS 0.0438929
R12064 VSS.n3223 VSS 0.0438929
R12065 VSS.n2118 VSS.n2117 0.0414091
R12066 VSS.n667 VSS.n666 0.0402934
R12067 VSS.n3012 VSS.n3009 0.0402934
R12068 VSS.n3004 VSS.n829 0.0402934
R12069 VSS.n344 VSS.n343 0.0402934
R12070 VSS.n3570 VSS.n218 0.0402934
R12071 VSS.n421 VSS.n419 0.0402934
R12072 VSS.n3332 VSS.n3331 0.0402934
R12073 VSS.n2242 VSS.n2241 0.0402934
R12074 VSS.n2271 VSS.n2270 0.0402934
R12075 VSS.n3678 VSS.n3663 0.0402934
R12076 VSS.n3683 VSS.n3682 0.0402934
R12077 VSS.n3692 VSS.n3650 0.0402934
R12078 VSS.n3697 VSS.n3696 0.0402934
R12079 VSS.n3440 VSS.n373 0.0402934
R12080 VSS.n277 VSS.n274 0.0402934
R12081 VSS.n283 VSS.n281 0.0402934
R12082 VSS.n3523 VSS.n3522 0.0402934
R12083 VSS.n3589 VSS.n3588 0.0402934
R12084 VSS.n3035 VSS.n3034 0.0402934
R12085 VSS.n3835 VSS.n117 0.0402934
R12086 VSS.n3400 VSS.n3399 0.0399215
R12087 VSS.n2623 VSS.n1131 0.0399215
R12088 VSS.n3411 VSS.n3410 0.0399215
R12089 VSS.n661 VSS.n660 0.0391777
R12090 VSS.n3010 VSS.n3007 0.0391777
R12091 VSS.n2999 VSS.n2998 0.0391777
R12092 VSS.n339 VSS.n338 0.0391777
R12093 VSS.n217 VSS.n214 0.0391777
R12094 VSS.n818 VSS.n817 0.0391777
R12095 VSS.n3354 VSS.n418 0.0391777
R12096 VSS.n3217 VSS.n3216 0.0391777
R12097 VSS.n2201 VSS.n2200 0.0391777
R12098 VSS.n2260 VSS.n1319 0.0391777
R12099 VSS.n3674 VSS.n3673 0.0391777
R12100 VSS.n3666 VSS.n3665 0.0391777
R12101 VSS.n3688 VSS.n3687 0.0391777
R12102 VSS.n3653 VSS.n3652 0.0391777
R12103 VSS.n348 VSS.n330 0.0391777
R12104 VSS.n3474 VSS.n273 0.0391777
R12105 VSS.n3466 VSS.n3465 0.0391777
R12106 VSS.n3509 VSS.n3508 0.0391777
R12107 VSS.n245 VSS.n244 0.0391777
R12108 VSS.n3566 VSS.n222 0.0391777
R12109 VSS.n3405 VSS.n393 0.0391777
R12110 VSS.n3030 VSS.n3029 0.0391777
R12111 VSS.n3850 VSS.n3849 0.0391777
R12112 VSS.n3919 VSS.n71 0.0391777
R12113 VSS.n3563 VSS.n3562 0.0388058
R12114 VSS.n660 VSS.n658 0.0384339
R12115 VSS.n3011 VSS.n3010 0.0384339
R12116 VSS.n3000 VSS.n2999 0.0384339
R12117 VSS.n338 VSS.n332 0.0384339
R12118 VSS.n3571 VSS.n217 0.0384339
R12119 VSS.n817 VSS.n395 0.0384339
R12120 VSS.n3354 VSS.n3353 0.0384339
R12121 VSS.n3216 VSS.n3205 0.0384339
R12122 VSS.n2200 VSS.n1315 0.0384339
R12123 VSS.n2261 VSS.n2260 0.0384339
R12124 VSS.n3673 VSS.n3672 0.0384339
R12125 VSS.n3665 VSS.n3659 0.0384339
R12126 VSS.n3687 VSS.n3686 0.0384339
R12127 VSS.n3652 VSS.n3643 0.0384339
R12128 VSS.n3441 VSS.n348 0.0384339
R12129 VSS.n3474 VSS.n3473 0.0384339
R12130 VSS.n3465 VSS.n284 0.0384339
R12131 VSS.n3508 VSS.n247 0.0384339
R12132 VSS.n244 VSS.n203 0.0384339
R12133 VSS.n224 VSS.n222 0.0384339
R12134 VSS.n3406 VSS.n3405 0.0384339
R12135 VSS.n3029 VSS.n681 0.0384339
R12136 VSS.n3849 VSS.n3836 0.0384339
R12137 VSS.n3919 VSS.n3918 0.0384339
R12138 VSS.n2118 VSS.n1792 0.0362025
R12139 VSS.n1925 VSS 0.0338333
R12140 VSS.n1951 VSS 0.0338333
R12141 VSS.n1977 VSS 0.0338333
R12142 VSS.n2000 VSS 0.0338333
R12143 VSS.n2018 VSS 0.0338333
R12144 VSS VSS.n2051 0.0338333
R12145 VSS.n260 VSS 0.0338333
R12146 VSS VSS.n3486 0.0338333
R12147 VSS.n721 VSS 0.0338333
R12148 VSS.n744 VSS 0.0338333
R12149 VSS.n762 VSS 0.0338333
R12150 VSS VSS.n795 0.0338333
R12151 VSS.n403 VSS 0.0338333
R12152 VSS VSS.n3374 0.0338333
R12153 VSS.n3253 VSS 0.0338333
R12154 VSS.n3279 VSS 0.0338333
R12155 VSS.n3305 VSS 0.0338333
R12156 VSS.n3323 VSS 0.0338333
R12157 VSS.n3865 VSS.n3864 0.03215
R12158 VSS.n3862 VSS.n109 0.03215
R12159 VSS.n3876 VSS.n104 0.03215
R12160 VSS.n3880 VSS.n105 0.03215
R12161 VSS.n3746 VSS.n3745 0.03215
R12162 VSS.n3743 VSS.n3742 0.03215
R12163 VSS.n3758 VSS.n154 0.03215
R12164 VSS.n3762 VSS.n155 0.03215
R12165 VSS.n3731 VSS.n158 0.03215
R12166 VSS.n3735 VSS.n160 0.03215
R12167 VSS.n3720 VSS.n163 0.03215
R12168 VSS.n3725 VSS.n165 0.03215
R12169 VSS.n3711 VSS.n168 0.03215
R12170 VSS.n3715 VSS.n170 0.03215
R12171 VSS.n3701 VSS.n173 0.03215
R12172 VSS.n3705 VSS.n175 0.03215
R12173 VSS.n3633 VSS.n178 0.03215
R12174 VSS.n3637 VSS.n180 0.03215
R12175 VSS.n3623 VSS.n183 0.03215
R12176 VSS.n3627 VSS.n185 0.03215
R12177 VSS.n3613 VSS.n188 0.03215
R12178 VSS.n3617 VSS.n190 0.03215
R12179 VSS.n3603 VSS.n193 0.03215
R12180 VSS.n3607 VSS.n195 0.03215
R12181 VSS.n3593 VSS.n198 0.03215
R12182 VSS.n3597 VSS.n200 0.03215
R12183 VSS.n2773 VSS.n2765 0.03215
R12184 VSS.n2777 VSS.n2766 0.03215
R12185 VSS.n3436 VSS.n376 0.03215
R12186 VSS.n1043 VSS.n378 0.03215
R12187 VSS.n3425 VSS.n383 0.03215
R12188 VSS.n3429 VSS.n385 0.03215
R12189 VSS.n3415 VSS.n388 0.03215
R12190 VSS.n3419 VSS.n390 0.03215
R12191 VSS.n1005 VSS.n999 0.03215
R12192 VSS.n1010 VSS.n1000 0.03215
R12193 VSS.n2991 VSS.n832 0.03215
R12194 VSS.n2984 VSS.n834 0.03215
R12195 VSS.n3052 VSS.n537 0.03215
R12196 VSS.n538 VSS.n536 0.03215
R12197 VSS.n3038 VSS.n543 0.03215
R12198 VSS.n3043 VSS.n544 0.03215
R12199 VSS.n671 VSS.n547 0.03215
R12200 VSS.n675 VSS.n655 0.03215
R12201 VSS.n3347 VSS.n425 0.03215
R12202 VSS.n637 VSS.n427 0.03215
R12203 VSS.n3336 VSS.n432 0.03215
R12204 VSS.n3340 VSS.n3203 0.03215
R12205 VSS.n3859 VSS.n112 0.03215
R12206 VSS.n3856 VSS.n3855 0.03215
R12207 VSS.n3882 VSS.n102 0.03215
R12208 VSS.n99 VSS.n98 0.03215
R12209 VSS.n3893 VSS.n90 0.03215
R12210 VSS.n3897 VSS.n91 0.03215
R12211 VSS.n3769 VSS.n150 0.03215
R12212 VSS.n3773 VSS.n151 0.03215
R12213 VSS.n2685 VSS.n2684 0.03215
R12214 VSS.n2680 VSS.n1095 0.03215
R12215 VSS.n2694 VSS.n2693 0.03215
R12216 VSS.n1091 VSS.n1090 0.03215
R12217 VSS.n2703 VSS.n2702 0.03215
R12218 VSS.n1086 VSS.n1085 0.03215
R12219 VSS.n2712 VSS.n2711 0.03215
R12220 VSS.n1081 VSS.n1080 0.03215
R12221 VSS.n2721 VSS.n2720 0.03215
R12222 VSS.n1076 VSS.n1075 0.03215
R12223 VSS.n2730 VSS.n2729 0.03215
R12224 VSS.n1071 VSS.n1070 0.03215
R12225 VSS.n2739 VSS.n2738 0.03215
R12226 VSS.n1066 VSS.n1065 0.03215
R12227 VSS.n2748 VSS.n2747 0.03215
R12228 VSS.n1061 VSS.n1060 0.03215
R12229 VSS.n2757 VSS.n2756 0.03215
R12230 VSS.n1056 VSS.n1055 0.03215
R12231 VSS.n2779 VSS.n2763 0.03215
R12232 VSS.n1051 VSS.n1050 0.03215
R12233 VSS.n2790 VSS.n938 0.03215
R12234 VSS.n2794 VSS.n939 0.03215
R12235 VSS.n1034 VSS.n942 0.03215
R12236 VSS.n1038 VSS.n943 0.03215
R12237 VSS.n1024 VSS.n946 0.03215
R12238 VSS.n1028 VSS.n948 0.03215
R12239 VSS.n1014 VSS.n951 0.03215
R12240 VSS.n1018 VSS.n996 0.03215
R12241 VSS.n2980 VSS.n838 0.03215
R12242 VSS.n2975 VSS.n840 0.03215
R12243 VSS.n3058 VSS.n3057 0.03215
R12244 VSS.n3061 VSS.n3060 0.03215
R12245 VSS.n3066 VSS.n524 0.03215
R12246 VSS.n3070 VSS.n525 0.03215
R12247 VSS.n652 VSS.n550 0.03215
R12248 VSS.n575 VSS.n552 0.03215
R12249 VSS.n641 VSS.n557 0.03215
R12250 VSS.n645 VSS.n635 0.03215
R12251 VSS.n3200 VSS.n435 0.03215
R12252 VSS.n3196 VSS.n437 0.03215
R12253 VSS.n3831 VSS.n120 0.03215
R12254 VSS.n3826 VSS.n122 0.03215
R12255 VSS.n3912 VSS.n78 0.03215
R12256 VSS.n3807 VSS.n80 0.03215
R12257 VSS.n3901 VSS.n85 0.03215
R12258 VSS.n3905 VSS.n87 0.03215
R12259 VSS.n3780 VSS.n146 0.03215
R12260 VSS.n3784 VSS.n147 0.03215
R12261 VSS.n2677 VSS.n1098 0.03215
R12262 VSS.n2336 VSS.n1100 0.03215
R12263 VSS.n2666 VSS.n1105 0.03215
R12264 VSS.n2670 VSS.n1107 0.03215
R12265 VSS.n2655 VSS.n1110 0.03215
R12266 VSS.n2659 VSS.n1112 0.03215
R12267 VSS.n2644 VSS.n1115 0.03215
R12268 VSS.n2648 VSS.n1117 0.03215
R12269 VSS.n2613 VSS.n1134 0.03215
R12270 VSS.n2375 VSS.n1136 0.03215
R12271 VSS.n2602 VSS.n1141 0.03215
R12272 VSS.n2606 VSS.n1143 0.03215
R12273 VSS.n2591 VSS.n1146 0.03215
R12274 VSS.n2595 VSS.n1148 0.03215
R12275 VSS.n2580 VSS.n1151 0.03215
R12276 VSS.n2584 VSS.n1153 0.03215
R12277 VSS.n2569 VSS.n1156 0.03215
R12278 VSS.n2573 VSS.n1158 0.03215
R12279 VSS.n2558 VSS.n1161 0.03215
R12280 VSS.n2562 VSS.n2555 0.03215
R12281 VSS.n2796 VSS.n936 0.03215
R12282 VSS.n933 VSS.n932 0.03215
R12283 VSS.n2807 VSS.n924 0.03215
R12284 VSS.n2811 VSS.n925 0.03215
R12285 VSS.n961 VSS.n960 0.03215
R12286 VSS.n956 VSS.n955 0.03215
R12287 VSS.n993 VSS.n968 0.03215
R12288 VSS.n988 VSS.n970 0.03215
R12289 VSS.n2971 VSS.n844 0.03215
R12290 VSS.n2964 VSS.n846 0.03215
R12291 VSS.n3087 VSS.n514 0.03215
R12292 VSS.n515 VSS.n513 0.03215
R12293 VSS.n3074 VSS.n520 0.03215
R12294 VSS.n3078 VSS.n521 0.03215
R12295 VSS.n582 VSS.n572 0.03215
R12296 VSS.n586 VSS.n573 0.03215
R12297 VSS.n632 VSS.n560 0.03215
R12298 VSS.n627 VSS.n562 0.03215
R12299 VSS.n3192 VSS.n441 0.03215
R12300 VSS.n3188 VSS.n443 0.03215
R12301 VSS.n3822 VSS.n125 0.03215
R12302 VSS.n1614 VSS.n127 0.03215
R12303 VSS.n3811 VSS.n131 0.03215
R12304 VSS.n3815 VSS.n133 0.03215
R12305 VSS.n3798 VSS.n136 0.03215
R12306 VSS.n3802 VSS.n138 0.03215
R12307 VSS.n3788 VSS.n141 0.03215
R12308 VSS.n3792 VSS.n143 0.03215
R12309 VSS.n2338 VSS.n2335 0.03215
R12310 VSS.n2333 VSS.n1280 0.03215
R12311 VSS.n2350 VSS.n2349 0.03215
R12312 VSS.n1276 VSS.n1275 0.03215
R12313 VSS.n2359 VSS.n2358 0.03215
R12314 VSS.n1271 VSS.n1270 0.03215
R12315 VSS.n2368 VSS.n2367 0.03215
R12316 VSS.n1266 VSS.n1265 0.03215
R12317 VSS.n2377 VSS.n2374 0.03215
R12318 VSS.n1261 VSS.n1260 0.03215
R12319 VSS.n2389 VSS.n2388 0.03215
R12320 VSS.n1256 VSS.n1255 0.03215
R12321 VSS.n2398 VSS.n2397 0.03215
R12322 VSS.n1251 VSS.n1250 0.03215
R12323 VSS.n2407 VSS.n2406 0.03215
R12324 VSS.n1246 VSS.n1245 0.03215
R12325 VSS.n2415 VSS.n1238 0.03215
R12326 VSS.n2419 VSS.n1239 0.03215
R12327 VSS.n2552 VSS.n1164 0.03215
R12328 VSS.n1225 VSS.n1166 0.03215
R12329 VSS.n2541 VSS.n1171 0.03215
R12330 VSS.n2545 VSS.n2538 0.03215
R12331 VSS.n2813 VSS.n922 0.03215
R12332 VSS.n919 VSS.n918 0.03215
R12333 VSS.n2824 VSS.n910 0.03215
R12334 VSS.n2828 VSS.n911 0.03215
R12335 VSS.n984 VSS.n974 0.03215
R12336 VSS.n979 VSS.n976 0.03215
R12337 VSS.n2960 VSS.n850 0.03215
R12338 VSS.n2955 VSS.n852 0.03215
R12339 VSS.n3093 VSS.n3092 0.03215
R12340 VSS.n3096 VSS.n3095 0.03215
R12341 VSS.n3101 VSS.n500 0.03215
R12342 VSS.n3105 VSS.n501 0.03215
R12343 VSS.n588 VSS.n570 0.03215
R12344 VSS.n568 VSS.n567 0.03215
R12345 VSS.n623 VSS.n598 0.03215
R12346 VSS.n618 VSS.n600 0.03215
R12347 VSS.n3184 VSS.n447 0.03215
R12348 VSS.n3180 VSS.n449 0.03215
R12349 VSS.n1616 VSS.n1613 0.03215
R12350 VSS.n1611 VSS.n1419 0.03215
R12351 VSS.n1627 VSS.n1626 0.03215
R12352 VSS.n1415 VSS.n1414 0.03215
R12353 VSS.n1636 VSS.n1635 0.03215
R12354 VSS.n1410 VSS.n1409 0.03215
R12355 VSS.n1644 VSS.n1402 0.03215
R12356 VSS.n1648 VSS.n1403 0.03215
R12357 VSS.n2330 VSS.n1283 0.03215
R12358 VSS.n1660 VSS.n1285 0.03215
R12359 VSS.n2319 VSS.n1290 0.03215
R12360 VSS.n2323 VSS.n1292 0.03215
R12361 VSS.n2308 VSS.n1295 0.03215
R12362 VSS.n2312 VSS.n1297 0.03215
R12363 VSS.n2297 VSS.n1300 0.03215
R12364 VSS.n2301 VSS.n1302 0.03215
R12365 VSS.n2286 VSS.n1305 0.03215
R12366 VSS.n2290 VSS.n1307 0.03215
R12367 VSS.n2275 VSS.n1310 0.03215
R12368 VSS.n2279 VSS.n1312 0.03215
R12369 VSS.n2257 VSS.n1324 0.03215
R12370 VSS.n1359 VSS.n1326 0.03215
R12371 VSS.n2246 VSS.n1331 0.03215
R12372 VSS.n2250 VSS.n1790 0.03215
R12373 VSS.n2421 VSS.n1236 0.03215
R12374 VSS.n1233 VSS.n1232 0.03215
R12375 VSS.n2432 VSS.n1222 0.03215
R12376 VSS.n2436 VSS.n1223 0.03215
R12377 VSS.n2535 VSS.n1174 0.03215
R12378 VSS.n1209 VSS.n1176 0.03215
R12379 VSS.n2524 VSS.n1181 0.03215
R12380 VSS.n2528 VSS.n2521 0.03215
R12381 VSS.n2830 VSS.n908 0.03215
R12382 VSS.n905 VSS.n904 0.03215
R12383 VSS.n2841 VSS.n896 0.03215
R12384 VSS.n2845 VSS.n897 0.03215
R12385 VSS.n2951 VSS.n856 0.03215
R12386 VSS.n883 VSS.n858 0.03215
R12387 VSS.n2944 VSS.n2938 0.03215
R12388 VSS.n2939 VSS.n863 0.03215
R12389 VSS.n3107 VSS.n498 0.03215
R12390 VSS.n495 VSS.n494 0.03215
R12391 VSS.n3118 VSS.n486 0.03215
R12392 VSS.n3122 VSS.n487 0.03215
R12393 VSS.n614 VSS.n604 0.03215
R12394 VSS.n609 VSS.n606 0.03215
R12395 VSS.n3176 VSS.n453 0.03215
R12396 VSS.n3172 VSS.n455 0.03215
R12397 VSS.n1608 VSS.n1422 0.03215
R12398 VSS.n1446 VSS.n1424 0.03215
R12399 VSS.n1597 VSS.n1428 0.03215
R12400 VSS.n1601 VSS.n1430 0.03215
R12401 VSS.n1586 VSS.n1433 0.03215
R12402 VSS.n1590 VSS.n1583 0.03215
R12403 VSS.n1650 VSS.n1400 0.03215
R12404 VSS.n1397 VSS.n1396 0.03215
R12405 VSS.n1662 VSS.n1659 0.03215
R12406 VSS.n1392 VSS.n1391 0.03215
R12407 VSS.n1674 VSS.n1673 0.03215
R12408 VSS.n1387 VSS.n1386 0.03215
R12409 VSS.n1683 VSS.n1682 0.03215
R12410 VSS.n1382 VSS.n1381 0.03215
R12411 VSS.n1692 VSS.n1691 0.03215
R12412 VSS.n1377 VSS.n1376 0.03215
R12413 VSS.n1701 VSS.n1700 0.03215
R12414 VSS.n1372 VSS.n1371 0.03215
R12415 VSS.n1710 VSS.n1709 0.03215
R12416 VSS.n1367 VSS.n1366 0.03215
R12417 VSS.n1718 VSS.n1356 0.03215
R12418 VSS.n1722 VSS.n1357 0.03215
R12419 VSS.n1787 VSS.n1334 0.03215
R12420 VSS.n1734 VSS.n1336 0.03215
R12421 VSS.n1776 VSS.n1341 0.03215
R12422 VSS.n1780 VSS.n1773 0.03215
R12423 VSS.n2438 VSS.n1220 0.03215
R12424 VSS.n1217 VSS.n1216 0.03215
R12425 VSS.n2449 VSS.n1206 0.03215
R12426 VSS.n2453 VSS.n1207 0.03215
R12427 VSS.n2518 VSS.n1184 0.03215
R12428 VSS.n2465 VSS.n1186 0.03215
R12429 VSS.n2507 VSS.n1191 0.03215
R12430 VSS.n2511 VSS.n2504 0.03215
R12431 VSS.n2847 VSS.n894 0.03215
R12432 VSS.n891 VSS.n890 0.03215
R12433 VSS.n2858 VSS.n880 0.03215
R12434 VSS.n2862 VSS.n881 0.03215
R12435 VSS.n2935 VSS.n866 0.03215
R12436 VSS.n2932 VSS.n2931 0.03215
R12437 VSS.n2902 VSS.n2895 0.03215
R12438 VSS.n2906 VSS.n2896 0.03215
R12439 VSS.n3124 VSS.n484 0.03215
R12440 VSS.n481 VSS.n480 0.03215
R12441 VSS.n3135 VSS.n472 0.03215
R12442 VSS.n3139 VSS.n473 0.03215
R12443 VSS.n3168 VSS.n459 0.03215
R12444 VSS.n3164 VSS.n461 0.03215
R12445 VSS.n1448 VSS.n1445 0.03215
R12446 VSS.n1443 VSS.n1442 0.03215
R12447 VSS.n1459 VSS.n1458 0.03215
R12448 VSS.n1438 VSS.n1437 0.03215
R12449 VSS.n1580 VSS.n1466 0.03215
R12450 VSS.n1471 VSS.n1468 0.03215
R12451 VSS.n1569 VSS.n1475 0.03215
R12452 VSS.n1573 VSS.n1476 0.03215
R12453 VSS.n1558 VSS.n1479 0.03215
R12454 VSS.n1562 VSS.n1480 0.03215
R12455 VSS.n1547 VSS.n1483 0.03215
R12456 VSS.n1551 VSS.n1484 0.03215
R12457 VSS.n1536 VSS.n1487 0.03215
R12458 VSS.n1540 VSS.n1488 0.03215
R12459 VSS.n1525 VSS.n1491 0.03215
R12460 VSS.n1529 VSS.n1492 0.03215
R12461 VSS.n1514 VSS.n1495 0.03215
R12462 VSS.n1518 VSS.n1496 0.03215
R12463 VSS.n1503 VSS.n1499 0.03215
R12464 VSS.n1507 VSS.n1500 0.03215
R12465 VSS.n1724 VSS.n1354 0.03215
R12466 VSS.n1351 VSS.n1350 0.03215
R12467 VSS.n1736 VSS.n1733 0.03215
R12468 VSS.n1346 VSS.n1345 0.03215
R12469 VSS.n1770 VSS.n1746 0.03215
R12470 VSS.n1751 VSS.n1748 0.03215
R12471 VSS.n1759 VSS.n1755 0.03215
R12472 VSS.n1763 VSS.n1756 0.03215
R12473 VSS.n2455 VSS.n1204 0.03215
R12474 VSS.n1201 VSS.n1200 0.03215
R12475 VSS.n2467 VSS.n2464 0.03215
R12476 VSS.n1196 VSS.n1195 0.03215
R12477 VSS.n2501 VSS.n2477 0.03215
R12478 VSS.n2482 VSS.n2479 0.03215
R12479 VSS.n2490 VSS.n2486 0.03215
R12480 VSS.n2494 VSS.n2487 0.03215
R12481 VSS.n2864 VSS.n878 0.03215
R12482 VSS.n875 VSS.n874 0.03215
R12483 VSS.n2927 VSS.n2874 0.03215
R12484 VSS.n2924 VSS.n2923 0.03215
R12485 VSS.n2910 VSS.n2877 0.03215
R12486 VSS.n2914 VSS.n2878 0.03215
R12487 VSS.n2885 VSS.n2881 0.03215
R12488 VSS.n2889 VSS.n2882 0.03215
R12489 VSS.n3141 VSS.n470 0.03215
R12490 VSS.n467 VSS.n466 0.03215
R12491 VSS.n3160 VSS.n3151 0.03215
R12492 VSS.n3156 VSS.n3153 0.03215
R12493 VSS.n3464 VSS.n3463 0.0312895
R12494 VSS.n2265 VSS.n1321 0.0302521
R12495 VSS.n2262 VSS.n1321 0.0276488
R12496 VSS.n3529 VSS.n3528 0.0265526
R12497 VSS.n3717 VSS.n167 0.0196
R12498 VSS.n2707 VSS.n2706 0.0196
R12499 VSS.n2661 VSS.n1109 0.0196
R12500 VSS.n2363 VSS.n2362 0.0196
R12501 VSS.n2314 VSS.n1294 0.0196
R12502 VSS.n1687 VSS.n1686 0.0196
R12503 VSS.n1542 VSS.n1486 0.0196
R12504 VSS.n677 VSS.n546 0.0196
R12505 VSS.n650 VSS.n553 0.0196
R12506 VSS.n579 VSS.n571 0.0196
R12507 VSS.n595 VSS.n594 0.0196
R12508 VSS.n491 VSS.n485 0.0196
R12509 VSS.n3131 VSS.n3130 0.0196
R12510 VSS.n2891 VSS.n2880 0.0196
R12511 VSS.n3048 VSS.n535 0.0196
R12512 VSS.n3062 VSS.n532 0.0196
R12513 VSS.n3083 VSS.n512 0.0196
R12514 VSS.n3097 VSS.n508 0.0196
R12515 VSS.n2946 VSS.n862 0.0196
R12516 VSS.n2933 VSS.n868 0.0196
R12517 VSS.n2925 VSS.n2919 0.0196
R12518 VSS.n2989 VSS.n835 0.0196
R12519 VSS.n2978 VSS.n841 0.0196
R12520 VSS.n2969 VSS.n847 0.0196
R12521 VSS.n2958 VSS.n853 0.0196
R12522 VSS.n2949 VSS.n859 0.0196
R12523 VSS.n887 VSS.n879 0.0196
R12524 VSS.n2871 VSS.n2870 0.0196
R12525 VSS.n3345 VSS.n428 0.0196
R12526 VSS.n647 VSS.n556 0.0196
R12527 VSS.n630 VSS.n563 0.0196
R12528 VSS.n621 VSS.n601 0.0196
R12529 VSS.n612 VSS.n607 0.0196
R12530 VSS.n477 VSS.n471 0.0196
R12531 VSS.n3148 VSS.n3147 0.0196
R12532 VSS.n3342 VSS.n431 0.0196
R12533 VSS.n3198 VSS.n438 0.0196
R12534 VSS.n3190 VSS.n444 0.0196
R12535 VSS.n3182 VSS.n450 0.0196
R12536 VSS.n3174 VSS.n456 0.0196
R12537 VSS.n3166 VSS.n462 0.0196
R12538 VSS.n3158 VSS.n3154 0.0196
R12539 VSS.n3609 VSS.n192 0.0196
R12540 VSS.n2752 VSS.n2751 0.0196
R12541 VSS.n2586 VSS.n1150 0.0196
R12542 VSS.n2411 VSS.n2410 0.0196
R12543 VSS.n2252 VSS.n1330 0.0196
R12544 VSS.n1785 VSS.n1337 0.0196
R12545 VSS.n1743 VSS.n1742 0.0196
R12546 VSS.n3629 VSS.n182 0.0196
R12547 VSS.n2734 VSS.n2733 0.0196
R12548 VSS.n2608 VSS.n1140 0.0196
R12549 VSS.n2393 VSS.n2392 0.0196
R12550 VSS.n2281 VSS.n1309 0.0196
R12551 VSS.n1714 VSS.n1713 0.0196
R12552 VSS.n1509 VSS.n1498 0.0196
R12553 VSS.n3619 VSS.n187 0.0196
R12554 VSS.n2743 VSS.n2742 0.0196
R12555 VSS.n2597 VSS.n1145 0.0196
R12556 VSS.n2402 VSS.n2401 0.0196
R12557 VSS.n2255 VSS.n1327 0.0196
R12558 VSS.n1363 VSS.n1355 0.0196
R12559 VSS.n1731 VSS.n1730 0.0196
R12560 VSS.n3639 VSS.n177 0.0196
R12561 VSS.n2725 VSS.n2724 0.0196
R12562 VSS.n2611 VSS.n1137 0.0196
R12563 VSS.n2384 VSS.n2383 0.0196
R12564 VSS.n2292 VSS.n1304 0.0196
R12565 VSS.n1705 VSS.n1704 0.0196
R12566 VSS.n1520 VSS.n1494 0.0196
R12567 VSS.n3707 VSS.n172 0.0196
R12568 VSS.n2716 VSS.n2715 0.0196
R12569 VSS.n2650 VSS.n1114 0.0196
R12570 VSS.n2372 VSS.n2371 0.0196
R12571 VSS.n2303 VSS.n1299 0.0196
R12572 VSS.n1696 VSS.n1695 0.0196
R12573 VSS.n1531 VSS.n1490 0.0196
R12574 VSS.n2770 VSS.n2764 0.0196
R12575 VSS.n2786 VSS.n2785 0.0196
R12576 VSS.n2564 VSS.n1160 0.0196
R12577 VSS.n2550 VSS.n1167 0.0196
R12578 VSS.n1229 VSS.n1221 0.0196
R12579 VSS.n2445 VSS.n2444 0.0196
R12580 VSS.n1765 VSS.n1754 0.0196
R12581 VSS.n3599 VSS.n197 0.0196
R12582 VSS.n2761 VSS.n2760 0.0196
R12583 VSS.n2575 VSS.n1155 0.0196
R12584 VSS.n1242 VSS.n1237 0.0196
R12585 VSS.n2428 VSS.n2427 0.0196
R12586 VSS.n1782 VSS.n1340 0.0196
R12587 VSS.n1768 VSS.n1749 0.0196
R12588 VSS.n3045 VSS.n542 0.0196
R12589 VSS.n529 VSS.n523 0.0196
R12590 VSS.n3080 VSS.n519 0.0196
R12591 VSS.n505 VSS.n499 0.0196
R12592 VSS.n3114 VSS.n3113 0.0196
R12593 VSS.n2899 VSS.n2894 0.0196
R12594 VSS.n2916 VSS.n2876 0.0196
R12595 VSS.n1004 VSS.n998 0.0196
R12596 VSS.n1020 VSS.n950 0.0196
R12597 VSS.n991 VSS.n971 0.0196
R12598 VSS.n982 VSS.n977 0.0196
R12599 VSS.n901 VSS.n895 0.0196
R12600 VSS.n2854 VSS.n2853 0.0196
R12601 VSS.n2496 VSS.n2485 0.0196
R12602 VSS.n3727 VSS.n162 0.0196
R12603 VSS.n2698 VSS.n2697 0.0196
R12604 VSS.n2672 VSS.n1104 0.0196
R12605 VSS.n2354 VSS.n2353 0.0196
R12606 VSS.n2325 VSS.n1289 0.0196
R12607 VSS.n1678 VSS.n1677 0.0196
R12608 VSS.n1553 VSS.n1482 0.0196
R12609 VSS.n3737 VSS.n157 0.0196
R12610 VSS.n2689 VSS.n2688 0.0196
R12611 VSS.n2675 VSS.n1101 0.0196
R12612 VSS.n2345 VSS.n2344 0.0196
R12613 VSS.n2328 VSS.n1286 0.0196
R12614 VSS.n1669 VSS.n1668 0.0196
R12615 VSS.n1564 VSS.n1478 0.0196
R12616 VSS.n3870 VSS.n3869 0.0196
R12617 VSS.n3857 VSS.n111 0.0196
R12618 VSS.n3829 VSS.n119 0.0196
R12619 VSS.n3820 VSS.n124 0.0196
R12620 VSS.n1622 VSS.n1621 0.0196
R12621 VSS.n1606 VSS.n1421 0.0196
R12622 VSS.n1454 VSS.n1453 0.0196
R12623 VSS.n3875 VSS.n103 0.0196
R12624 VSS.n3889 VSS.n3888 0.0196
R12625 VSS.n3910 VSS.n81 0.0196
R12626 VSS.n3817 VSS.n130 0.0196
R12627 VSS.n1631 VSS.n1630 0.0196
R12628 VSS.n1603 VSS.n1427 0.0196
R12629 VSS.n1463 VSS.n1462 0.0196
R12630 VSS.n3752 VSS.n3751 0.0196
R12631 VSS.n95 VSS.n89 0.0196
R12632 VSS.n3907 VSS.n84 0.0196
R12633 VSS.n3804 VSS.n135 0.0196
R12634 VSS.n1640 VSS.n1639 0.0196
R12635 VSS.n1592 VSS.n1432 0.0196
R12636 VSS.n1578 VSS.n1469 0.0196
R12637 VSS.n3757 VSS.n153 0.0196
R12638 VSS.n3766 VSS.n149 0.0196
R12639 VSS.n3777 VSS.n145 0.0196
R12640 VSS.n3794 VSS.n140 0.0196
R12641 VSS.n1406 VSS.n1401 0.0196
R12642 VSS.n1657 VSS.n1656 0.0196
R12643 VSS.n1575 VSS.n1474 0.0196
R12644 VSS.n3434 VSS.n379 0.0196
R12645 VSS.n1047 VSS.n937 0.0196
R12646 VSS.n2803 VSS.n2802 0.0196
R12647 VSS.n2547 VSS.n1170 0.0196
R12648 VSS.n2533 VSS.n1177 0.0196
R12649 VSS.n1213 VSS.n1205 0.0196
R12650 VSS.n2462 VSS.n2461 0.0196
R12651 VSS.n3431 VSS.n382 0.0196
R12652 VSS.n1040 VSS.n941 0.0196
R12653 VSS.n929 VSS.n923 0.0196
R12654 VSS.n2820 VSS.n2819 0.0196
R12655 VSS.n2530 VSS.n1180 0.0196
R12656 VSS.n2516 VSS.n1187 0.0196
R12657 VSS.n2474 VSS.n2473 0.0196
R12658 VSS.n3421 VSS.n387 0.0196
R12659 VSS.n1030 VSS.n945 0.0196
R12660 VSS.n965 VSS.n964 0.0196
R12661 VSS.n915 VSS.n909 0.0196
R12662 VSS.n2837 VSS.n2836 0.0196
R12663 VSS.n2513 VSS.n1190 0.0196
R12664 VSS.n2499 VSS.n2480 0.0196
R12665 VSS.n3562 VSS.n219 0.019095
R12666 VSS.n3713 VSS.n3712 0.0189
R12667 VSS.n2700 VSS.n1084 0.0189
R12668 VSS.n2657 VSS.n2656 0.0189
R12669 VSS.n2356 VSS.n1269 0.0189
R12670 VSS.n2310 VSS.n2309 0.0189
R12671 VSS.n1680 VSS.n1380 0.0189
R12672 VSS.n1538 VSS.n1537 0.0189
R12673 VSS.n673 VSS.n672 0.0189
R12674 VSS.n651 VSS.n548 0.0189
R12675 VSS.n584 VSS.n583 0.0189
R12676 VSS.n590 VSS.n566 0.0189
R12677 VSS.n3120 VSS.n3119 0.0189
R12678 VSS.n3126 VSS.n479 0.0189
R12679 VSS.n2887 VSS.n2886 0.0189
R12680 VSS.n3050 VSS.n3049 0.0189
R12681 VSS.n3054 VSS.n531 0.0189
R12682 VSS.n3085 VSS.n3084 0.0189
R12683 VSS.n3089 VSS.n507 0.0189
R12684 VSS.n2942 VSS.n2941 0.0189
R12685 VSS.n2934 VSS.n864 0.0189
R12686 VSS.n2926 VSS.n871 0.0189
R12687 VSS.n2990 VSS.n830 0.0189
R12688 VSS.n2979 VSS.n836 0.0189
R12689 VSS.n2970 VSS.n842 0.0189
R12690 VSS.n2959 VSS.n848 0.0189
R12691 VSS.n2950 VSS.n854 0.0189
R12692 VSS.n2860 VSS.n2859 0.0189
R12693 VSS.n2866 VSS.n873 0.0189
R12694 VSS.n3346 VSS.n423 0.0189
R12695 VSS.n643 VSS.n642 0.0189
R12696 VSS.n631 VSS.n558 0.0189
R12697 VSS.n622 VSS.n564 0.0189
R12698 VSS.n613 VSS.n602 0.0189
R12699 VSS.n3137 VSS.n3136 0.0189
R12700 VSS.n3143 VSS.n465 0.0189
R12701 VSS.n3338 VSS.n3337 0.0189
R12702 VSS.n3199 VSS.n433 0.0189
R12703 VSS.n3191 VSS.n439 0.0189
R12704 VSS.n3183 VSS.n445 0.0189
R12705 VSS.n3175 VSS.n451 0.0189
R12706 VSS.n3167 VSS.n457 0.0189
R12707 VSS.n3159 VSS.n463 0.0189
R12708 VSS.n3605 VSS.n3604 0.0189
R12709 VSS.n2745 VSS.n1059 0.0189
R12710 VSS.n2582 VSS.n2581 0.0189
R12711 VSS.n2404 VSS.n1244 0.0189
R12712 VSS.n2248 VSS.n2247 0.0189
R12713 VSS.n1786 VSS.n1332 0.0189
R12714 VSS.n1738 VSS.n1344 0.0189
R12715 VSS.n3625 VSS.n3624 0.0189
R12716 VSS.n2727 VSS.n1069 0.0189
R12717 VSS.n2604 VSS.n2603 0.0189
R12718 VSS.n2386 VSS.n1254 0.0189
R12719 VSS.n2277 VSS.n2276 0.0189
R12720 VSS.n1707 VSS.n1365 0.0189
R12721 VSS.n1505 VSS.n1504 0.0189
R12722 VSS.n3615 VSS.n3614 0.0189
R12723 VSS.n2736 VSS.n1064 0.0189
R12724 VSS.n2593 VSS.n2592 0.0189
R12725 VSS.n2395 VSS.n1249 0.0189
R12726 VSS.n2256 VSS.n1322 0.0189
R12727 VSS.n1720 VSS.n1719 0.0189
R12728 VSS.n1726 VSS.n1349 0.0189
R12729 VSS.n3635 VSS.n3634 0.0189
R12730 VSS.n2718 VSS.n1074 0.0189
R12731 VSS.n2612 VSS.n1132 0.0189
R12732 VSS.n2379 VSS.n1259 0.0189
R12733 VSS.n2288 VSS.n2287 0.0189
R12734 VSS.n1698 VSS.n1370 0.0189
R12735 VSS.n1516 VSS.n1515 0.0189
R12736 VSS.n3703 VSS.n3702 0.0189
R12737 VSS.n2709 VSS.n1079 0.0189
R12738 VSS.n2646 VSS.n2645 0.0189
R12739 VSS.n2365 VSS.n1264 0.0189
R12740 VSS.n2299 VSS.n2298 0.0189
R12741 VSS.n1689 VSS.n1375 0.0189
R12742 VSS.n1527 VSS.n1526 0.0189
R12743 VSS.n2775 VSS.n2774 0.0189
R12744 VSS.n2781 VSS.n1049 0.0189
R12745 VSS.n2560 VSS.n2559 0.0189
R12746 VSS.n2551 VSS.n1162 0.0189
R12747 VSS.n2434 VSS.n2433 0.0189
R12748 VSS.n2440 VSS.n1215 0.0189
R12749 VSS.n1761 VSS.n1760 0.0189
R12750 VSS.n3595 VSS.n3594 0.0189
R12751 VSS.n2754 VSS.n1054 0.0189
R12752 VSS.n2571 VSS.n2570 0.0189
R12753 VSS.n2417 VSS.n2416 0.0189
R12754 VSS.n2423 VSS.n1231 0.0189
R12755 VSS.n1778 VSS.n1777 0.0189
R12756 VSS.n1769 VSS.n1342 0.0189
R12757 VSS.n3041 VSS.n3039 0.0189
R12758 VSS.n3068 VSS.n3067 0.0189
R12759 VSS.n3076 VSS.n3075 0.0189
R12760 VSS.n3103 VSS.n3102 0.0189
R12761 VSS.n3109 VSS.n493 0.0189
R12762 VSS.n2904 VSS.n2903 0.0189
R12763 VSS.n2912 VSS.n2911 0.0189
R12764 VSS.n1008 VSS.n1006 0.0189
R12765 VSS.n1016 VSS.n1015 0.0189
R12766 VSS.n992 VSS.n952 0.0189
R12767 VSS.n983 VSS.n972 0.0189
R12768 VSS.n2843 VSS.n2842 0.0189
R12769 VSS.n2849 VSS.n889 0.0189
R12770 VSS.n2492 VSS.n2491 0.0189
R12771 VSS.n3723 VSS.n3721 0.0189
R12772 VSS.n2691 VSS.n1089 0.0189
R12773 VSS.n2668 VSS.n2667 0.0189
R12774 VSS.n2347 VSS.n1274 0.0189
R12775 VSS.n2321 VSS.n2320 0.0189
R12776 VSS.n1671 VSS.n1385 0.0189
R12777 VSS.n1549 VSS.n1548 0.0189
R12778 VSS.n3733 VSS.n3732 0.0189
R12779 VSS.n2682 VSS.n1094 0.0189
R12780 VSS.n2676 VSS.n1096 0.0189
R12781 VSS.n2340 VSS.n1279 0.0189
R12782 VSS.n2329 VSS.n1281 0.0189
R12783 VSS.n1664 VSS.n1390 0.0189
R12784 VSS.n1560 VSS.n1559 0.0189
R12785 VSS.n3867 VSS.n108 0.0189
R12786 VSS.n3858 VSS.n110 0.0189
R12787 VSS.n3830 VSS.n118 0.0189
R12788 VSS.n3821 VSS.n123 0.0189
R12789 VSS.n1618 VSS.n1418 0.0189
R12790 VSS.n1607 VSS.n1420 0.0189
R12791 VSS.n1450 VSS.n1441 0.0189
R12792 VSS.n3878 VSS.n3877 0.0189
R12793 VSS.n3884 VSS.n97 0.0189
R12794 VSS.n3911 VSS.n76 0.0189
R12795 VSS.n3813 VSS.n3812 0.0189
R12796 VSS.n1624 VSS.n1413 0.0189
R12797 VSS.n1599 VSS.n1598 0.0189
R12798 VSS.n1456 VSS.n1436 0.0189
R12799 VSS.n3748 VSS.n3741 0.0189
R12800 VSS.n3895 VSS.n3894 0.0189
R12801 VSS.n3903 VSS.n3902 0.0189
R12802 VSS.n3800 VSS.n3799 0.0189
R12803 VSS.n1633 VSS.n1408 0.0189
R12804 VSS.n1588 VSS.n1587 0.0189
R12805 VSS.n1579 VSS.n1434 0.0189
R12806 VSS.n3760 VSS.n3759 0.0189
R12807 VSS.n3771 VSS.n3770 0.0189
R12808 VSS.n3782 VSS.n3781 0.0189
R12809 VSS.n3790 VSS.n3789 0.0189
R12810 VSS.n1646 VSS.n1645 0.0189
R12811 VSS.n1652 VSS.n1395 0.0189
R12812 VSS.n1571 VSS.n1570 0.0189
R12813 VSS.n3435 VSS.n374 0.0189
R12814 VSS.n2792 VSS.n2791 0.0189
R12815 VSS.n2798 VSS.n931 0.0189
R12816 VSS.n2543 VSS.n2542 0.0189
R12817 VSS.n2534 VSS.n1172 0.0189
R12818 VSS.n2451 VSS.n2450 0.0189
R12819 VSS.n2457 VSS.n1199 0.0189
R12820 VSS.n3427 VSS.n3426 0.0189
R12821 VSS.n1036 VSS.n1035 0.0189
R12822 VSS.n2809 VSS.n2808 0.0189
R12823 VSS.n2815 VSS.n917 0.0189
R12824 VSS.n2526 VSS.n2525 0.0189
R12825 VSS.n2517 VSS.n1182 0.0189
R12826 VSS.n2469 VSS.n1194 0.0189
R12827 VSS.n3417 VSS.n3416 0.0189
R12828 VSS.n1026 VSS.n1025 0.0189
R12829 VSS.n958 VSS.n954 0.0189
R12830 VSS.n2826 VSS.n2825 0.0189
R12831 VSS.n2832 VSS.n903 0.0189
R12832 VSS.n2509 VSS.n2508 0.0189
R12833 VSS.n2500 VSS.n1192 0.0189
R12834 VSS.n3399 VSS.n396 0.0179793
R12835 VSS.n2623 VSS.n2622 0.0179793
R12836 VSS.n3410 VSS.n3409 0.0179793
R12837 VSS.n666 VSS.n665 0.0176074
R12838 VSS.n3015 VSS.n3009 0.0176074
R12839 VSS.n3004 VSS.n3003 0.0176074
R12840 VSS.n343 VSS.n342 0.0176074
R12841 VSS.n218 VSS.n215 0.0176074
R12842 VSS.n422 VSS.n421 0.0176074
R12843 VSS.n3331 VSS.n3206 0.0176074
R12844 VSS.n2241 VSS.n1793 0.0176074
R12845 VSS.n2270 VSS.n1316 0.0176074
R12846 VSS.n3678 VSS.n3677 0.0176074
R12847 VSS.n3682 VSS.n3660 0.0176074
R12848 VSS.n3692 VSS.n3691 0.0176074
R12849 VSS.n3696 VSS.n3644 0.0176074
R12850 VSS.n373 VSS.n346 0.0176074
R12851 VSS.n278 VSS.n277 0.0176074
R12852 VSS.n3468 VSS.n281 0.0176074
R12853 VSS.n3522 VSS.n248 0.0176074
R12854 VSS.n3588 VSS.n204 0.0176074
R12855 VSS.n3034 VSS.n3033 0.0176074
R12856 VSS.n3852 VSS.n117 0.0176074
R12857 VSS.n372 VSS.n349 0.0158947
R12858 VSS.n3694 VSS.n3648 0.0149495
R12859 VSS.n1862 VSS.n1857 0.0134096
R12860 VSS.n1877 VSS.n1876 0.0134096
R12861 VSS.n1869 VSS.n233 0.0134096
R12862 VSS.n663 VSS.n657 0.0131
R12863 VSS.n3014 VSS.n3008 0.0131
R12864 VSS.n3001 VSS.n2995 0.0131
R12865 VSS.n3352 VSS.n3351 0.0131
R12866 VSS.n3218 VSS.n3204 0.0131
R12867 VSS.n2115 VSS.n1791 0.0131
R12868 VSS.n2202 VSS.n1314 0.0131
R12869 VSS.n2264 VSS.n1320 0.0131
R12870 VSS.n2620 VSS.n2617 0.0131
R12871 VSS.n3671 VSS.n3670 0.0131
R12872 VSS.n3664 VSS.n3658 0.0131
R12873 VSS.n3685 VSS.n3657 0.0131
R12874 VSS.n3651 VSS.n3642 0.0131
R12875 VSS.n2637 VSS.n1119 0.0131
R12876 VSS.n3472 VSS.n3471 0.0131
R12877 VSS.n3467 VSS.n280 0.0131
R12878 VSS.n3510 VSS.n246 0.0131
R12879 VSS.n3525 VSS.n202 0.0131
R12880 VSS.n682 VSS.n680 0.0131
R12881 VSS.n3851 VSS.n116 0.0131
R12882 VSS.n3917 VSS.n3916 0.0131
R12883 VSS.n333 VSS.n331 0.0131
R12884 VSS.n3442 VSS.n347 0.0131
R12885 VSS.n3572 VSS.n216 0.0131
R12886 VSS.n3565 VSS.n220 0.0131
R12887 VSS.n819 VSS.n394 0.0131
R12888 VSS.n3402 VSS.n392 0.0131
R12889 VSS VSS.n2180 0.00997368
R12890 VSS.n2119 VSS.n2114 0.00554
R12891 VSS.n1815 VSS 0.00405263
R12892 VSS.n1816 VSS 0.00405263
R12893 VSS.n1826 VSS 0.00405263
R12894 VSS.n2151 VSS 0.00405263
R12895 VSS.n2131 VSS 0.00405263
R12896 VSS.n2106 VSS 0.00405263
R12897 VSS.n2176 VSS 0.00405263
R12898 VSS VSS.n2124 0.00405263
R12899 VSS.n2226 VSS 0.00405263
R12900 VSS.n2081 VSS 0.00405263
R12901 VSS.n1855 VSS 0.00405263
R12902 VSS.n1130 VSS 0.00405263
R12903 VSS.n2630 VSS 0.00405263
R12904 VSS.n2626 VSS 0.00405263
R12905 VSS.n67 VSS 0.00405263
R12906 VSS.n3924 VSS 0.00405263
R12907 VSS.n3981 VSS 0.00405263
R12908 VSS.n3843 VSS 0.00405263
R12909 VSS.n3838 VSS 0.00405263
R12910 VSS.n3837 VSS 0.00405263
R12911 VSS.n3840 VSS 0.00405263
R12912 VSS.n362 VSS 0.00405263
R12913 VSS.n3446 VSS 0.00405263
R12914 VSS.n3459 VSS 0.00405263
R12915 VSS.n3462 VSS 0.00405263
R12916 VSS.n308 VSS 0.00405263
R12917 VSS.n3530 VSS 0.00405263
R12918 VSS.n236 VSS 0.00405263
R12919 VSS.n3543 VSS 0.00405263
R12920 VSS.n3550 VSS 0.00405263
R12921 VSS.n3556 VSS 0.00405263
R12922 VSS.n3559 VSS 0.00405263
R12923 VSS.n365 VSS 0.00405263
R12924 VSS.n368 VSS 0.00405263
R12925 VSS.n1834 VSS 0.00286842
R12926 VSS.n1839 VSS 0.00286842
R12927 VSS.n2156 VSS 0.00286842
R12928 VSS.n2140 VSS 0.00286842
R12929 VSS.n2111 VSS 0.00286842
R12930 VSS.n2184 VSS 0.00286842
R12931 VSS.n2095 VSS 0.00286842
R12932 VSS.n2235 VSS 0.00286842
R12933 VSS.n1845 VSS 0.00286842
R12934 VSS.n1852 VSS 0.00286842
R12935 VSS.n1850 VSS 0.00286842
R12936 VSS.n1126 VSS 0.00286842
R12937 VSS.n61 VSS 0.00286842
R12938 VSS.n56 VSS 0.00286842
R12939 VSS.n46 VSS 0.00286842
R12940 VSS.n207 VSS 0.00286842
R12941 VSS.n3532 VSS 0.00286842
R12942 VSS.n1879 VSS 0.00286842
R12943 VSS.n2634 VSS.n1120 0.00273141
R12944 VSS.n662 VSS.n661 0.0019876
R12945 VSS.n667 VSS.n658 0.0019876
R12946 VSS.n3017 VSS.n3007 0.0019876
R12947 VSS.n3012 VSS.n3011 0.0019876
R12948 VSS.n2998 VSS.n2997 0.0019876
R12949 VSS.n3000 VSS.n829 0.0019876
R12950 VSS.n340 VSS.n339 0.0019876
R12951 VSS.n344 VSS.n332 0.0019876
R12952 VSS.n3574 VSS.n214 0.0019876
R12953 VSS.n3571 VSS.n3570 0.0019876
R12954 VSS.n821 VSS.n818 0.0019876
R12955 VSS.n3400 VSS.n395 0.0019876
R12956 VSS.n3353 VSS.n419 0.0019876
R12957 VSS.n3220 VSS.n3217 0.0019876
R12958 VSS.n3332 VSS.n3205 0.0019876
R12959 VSS.n2242 VSS.n1792 0.0019876
R12960 VSS.n2204 VSS.n2201 0.0019876
R12961 VSS.n2271 VSS.n1315 0.0019876
R12962 VSS.n2267 VSS.n1319 0.0019876
R12963 VSS.n2262 VSS.n2261 0.0019876
R12964 VSS.n2619 VSS.n1131 0.0019876
R12965 VSS.n3675 VSS.n3674 0.0019876
R12966 VSS.n3672 VSS.n3663 0.0019876
R12967 VSS.n3667 VSS.n3666 0.0019876
R12968 VSS.n3683 VSS.n3659 0.0019876
R12969 VSS.n3689 VSS.n3688 0.0019876
R12970 VSS.n3686 VSS.n3650 0.0019876
R12971 VSS.n3654 VSS.n3653 0.0019876
R12972 VSS.n3697 VSS.n3643 0.0019876
R12973 VSS.n2636 VSS.n2635 0.0019876
R12974 VSS.n2640 VSS.n1120 0.0019876
R12975 VSS.n3444 VSS.n330 0.0019876
R12976 VSS.n3441 VSS.n3440 0.0019876
R12977 VSS.n275 VSS.n273 0.0019876
R12978 VSS.n3473 VSS.n274 0.0019876
R12979 VSS.n3466 VSS.n279 0.0019876
R12980 VSS.n284 VSS.n283 0.0019876
R12981 VSS.n3512 VSS.n3509 0.0019876
R12982 VSS.n3523 VSS.n247 0.0019876
R12983 VSS.n3527 VSS.n245 0.0019876
R12984 VSS.n3589 VSS.n203 0.0019876
R12985 VSS.n3567 VSS.n3566 0.0019876
R12986 VSS.n3563 VSS.n224 0.0019876
R12987 VSS.n3407 VSS.n3406 0.0019876
R12988 VSS.n3411 VSS.n393 0.0019876
R12989 VSS.n3031 VSS.n3030 0.0019876
R12990 VSS.n3035 VSS.n681 0.0019876
R12991 VSS.n3850 VSS.n115 0.0019876
R12992 VSS.n3836 VSS.n3835 0.0019876
R12993 VSS.n73 VSS.n71 0.0019876
R12994 VSS.n3918 VSS.n72 0.0019876
R12995 VSS.n3545 VSS 0.00168421
R12996 VSS.n3553 VSS 0.00168421
R12997 VSS.n321 VSS.n290 0.00114823
R12998 VSS.n361 VSS.n360 0.00114823
R12999 VSS.n319 VSS.n298 0.00114812
R13000 VSS.n3452 VSS.n327 0.00114812
R13001 VSS.n324 VSS.n293 0.00114806
R13002 VSS.n356 VSS.n355 0.00114806
R13003 VSS.n3868 VSS.n3864 0.00095
R13004 VSS.n3866 VSS.n109 0.00095
R13005 VSS.n3871 VSS.n107 0.00095
R13006 VSS.n3876 VSS.n3873 0.00095
R13007 VSS.n3874 VSS.n105 0.00095
R13008 VSS.n3879 VSS.n106 0.00095
R13009 VSS.n3749 VSS.n3745 0.00095
R13010 VSS.n3747 VSS.n3742 0.00095
R13011 VSS.n3753 VSS.n3740 0.00095
R13012 VSS.n3758 VSS.n3755 0.00095
R13013 VSS.n3756 VSS.n155 0.00095
R13014 VSS.n3761 VSS.n3739 0.00095
R13015 VSS.n3731 VSS.n156 0.00095
R13016 VSS.n3730 VSS.n160 0.00095
R13017 VSS.n3734 VSS.n3729 0.00095
R13018 VSS.n3720 VSS.n161 0.00095
R13019 VSS.n3722 VSS.n165 0.00095
R13020 VSS.n3724 VSS.n3719 0.00095
R13021 VSS.n3711 VSS.n166 0.00095
R13022 VSS.n3710 VSS.n170 0.00095
R13023 VSS.n3714 VSS.n3709 0.00095
R13024 VSS.n3701 VSS.n171 0.00095
R13025 VSS.n3700 VSS.n175 0.00095
R13026 VSS.n3704 VSS.n3641 0.00095
R13027 VSS.n3633 VSS.n176 0.00095
R13028 VSS.n3632 VSS.n180 0.00095
R13029 VSS.n3636 VSS.n3631 0.00095
R13030 VSS.n3623 VSS.n181 0.00095
R13031 VSS.n3622 VSS.n185 0.00095
R13032 VSS.n3626 VSS.n3621 0.00095
R13033 VSS.n3613 VSS.n186 0.00095
R13034 VSS.n3612 VSS.n190 0.00095
R13035 VSS.n3616 VSS.n3611 0.00095
R13036 VSS.n3603 VSS.n191 0.00095
R13037 VSS.n3602 VSS.n195 0.00095
R13038 VSS.n3606 VSS.n3601 0.00095
R13039 VSS.n3593 VSS.n196 0.00095
R13040 VSS.n3592 VSS.n200 0.00095
R13041 VSS.n3596 VSS.n201 0.00095
R13042 VSS.n2773 VSS.n2772 0.00095
R13043 VSS.n2769 VSS.n2766 0.00095
R13044 VSS.n2776 VSS.n2767 0.00095
R13045 VSS.n3437 VSS.n3436 0.00095
R13046 VSS.n378 VSS.n377 0.00095
R13047 VSS.n3433 VSS.n380 0.00095
R13048 VSS.n3425 VSS.n381 0.00095
R13049 VSS.n3424 VSS.n385 0.00095
R13050 VSS.n3428 VSS.n3423 0.00095
R13051 VSS.n3415 VSS.n386 0.00095
R13052 VSS.n3414 VSS.n390 0.00095
R13053 VSS.n3418 VSS.n391 0.00095
R13054 VSS.n1005 VSS.n1003 0.00095
R13055 VSS.n1007 VSS.n1000 0.00095
R13056 VSS.n1009 VSS.n1001 0.00095
R13057 VSS.n2992 VSS.n2991 0.00095
R13058 VSS.n834 VSS.n833 0.00095
R13059 VSS.n2988 VSS.n2985 0.00095
R13060 VSS.n2986 VSS.n537 0.00095
R13061 VSS.n3051 VSS.n538 0.00095
R13062 VSS.n3047 VSS.n540 0.00095
R13063 VSS.n3038 VSS.n541 0.00095
R13064 VSS.n3040 VSS.n544 0.00095
R13065 VSS.n3042 VSS.n679 0.00095
R13066 VSS.n671 VSS.n545 0.00095
R13067 VSS.n670 VSS.n655 0.00095
R13068 VSS.n674 VSS.n656 0.00095
R13069 VSS.n3348 VSS.n3347 0.00095
R13070 VSS.n427 VSS.n426 0.00095
R13071 VSS.n3344 VSS.n429 0.00095
R13072 VSS.n3336 VSS.n430 0.00095
R13073 VSS.n3335 VSS.n3203 0.00095
R13074 VSS.n3860 VSS.n3859 0.00095
R13075 VSS.n3856 VSS.n113 0.00095
R13076 VSS.n114 VSS.n101 0.00095
R13077 VSS.n3886 VSS.n102 0.00095
R13078 VSS.n3883 VSS.n98 0.00095
R13079 VSS.n3890 VSS.n96 0.00095
R13080 VSS.n3893 VSS.n3892 0.00095
R13081 VSS.n94 VSS.n91 0.00095
R13082 VSS.n3896 VSS.n92 0.00095
R13083 VSS.n3769 VSS.n3768 0.00095
R13084 VSS.n3765 VSS.n151 0.00095
R13085 VSS.n3772 VSS.n152 0.00095
R13086 VSS.n2686 VSS.n2685 0.00095
R13087 VSS.n2683 VSS.n1095 0.00095
R13088 VSS.n2690 VSS.n1093 0.00095
R13089 VSS.n2695 VSS.n2694 0.00095
R13090 VSS.n2692 VSS.n1090 0.00095
R13091 VSS.n2699 VSS.n1088 0.00095
R13092 VSS.n2704 VSS.n2703 0.00095
R13093 VSS.n2701 VSS.n1085 0.00095
R13094 VSS.n2708 VSS.n1083 0.00095
R13095 VSS.n2713 VSS.n2712 0.00095
R13096 VSS.n2710 VSS.n1080 0.00095
R13097 VSS.n2717 VSS.n1078 0.00095
R13098 VSS.n2722 VSS.n2721 0.00095
R13099 VSS.n2719 VSS.n1075 0.00095
R13100 VSS.n2726 VSS.n1073 0.00095
R13101 VSS.n2731 VSS.n2730 0.00095
R13102 VSS.n2728 VSS.n1070 0.00095
R13103 VSS.n2735 VSS.n1068 0.00095
R13104 VSS.n2740 VSS.n2739 0.00095
R13105 VSS.n2737 VSS.n1065 0.00095
R13106 VSS.n2744 VSS.n1063 0.00095
R13107 VSS.n2749 VSS.n2748 0.00095
R13108 VSS.n2746 VSS.n1060 0.00095
R13109 VSS.n2753 VSS.n1058 0.00095
R13110 VSS.n2758 VSS.n2757 0.00095
R13111 VSS.n2755 VSS.n1055 0.00095
R13112 VSS.n2762 VSS.n1053 0.00095
R13113 VSS.n2783 VSS.n2763 0.00095
R13114 VSS.n2780 VSS.n1050 0.00095
R13115 VSS.n2787 VSS.n1048 0.00095
R13116 VSS.n2790 VSS.n2789 0.00095
R13117 VSS.n1046 VSS.n939 0.00095
R13118 VSS.n2793 VSS.n1042 0.00095
R13119 VSS.n1034 VSS.n940 0.00095
R13120 VSS.n1033 VSS.n943 0.00095
R13121 VSS.n1037 VSS.n1032 0.00095
R13122 VSS.n1024 VSS.n944 0.00095
R13123 VSS.n1023 VSS.n948 0.00095
R13124 VSS.n1027 VSS.n1022 0.00095
R13125 VSS.n1014 VSS.n949 0.00095
R13126 VSS.n1013 VSS.n996 0.00095
R13127 VSS.n1017 VSS.n997 0.00095
R13128 VSS.n2981 VSS.n2980 0.00095
R13129 VSS.n840 VSS.n839 0.00095
R13130 VSS.n2977 VSS.n2976 0.00095
R13131 VSS.n3057 VSS.n3056 0.00095
R13132 VSS.n3061 VSS.n533 0.00095
R13133 VSS.n3063 VSS.n530 0.00095
R13134 VSS.n3066 VSS.n3065 0.00095
R13135 VSS.n528 VSS.n525 0.00095
R13136 VSS.n3069 VSS.n526 0.00095
R13137 VSS.n653 VSS.n652 0.00095
R13138 VSS.n552 VSS.n551 0.00095
R13139 VSS.n649 VSS.n554 0.00095
R13140 VSS.n641 VSS.n555 0.00095
R13141 VSS.n640 VSS.n635 0.00095
R13142 VSS.n644 VSS.n636 0.00095
R13143 VSS.n3201 VSS.n3200 0.00095
R13144 VSS.n437 VSS.n436 0.00095
R13145 VSS.n3832 VSS.n3831 0.00095
R13146 VSS.n122 VSS.n121 0.00095
R13147 VSS.n3828 VSS.n3827 0.00095
R13148 VSS.n3913 VSS.n3912 0.00095
R13149 VSS.n80 VSS.n79 0.00095
R13150 VSS.n3909 VSS.n82 0.00095
R13151 VSS.n3901 VSS.n83 0.00095
R13152 VSS.n3900 VSS.n87 0.00095
R13153 VSS.n3904 VSS.n88 0.00095
R13154 VSS.n3780 VSS.n3779 0.00095
R13155 VSS.n3776 VSS.n147 0.00095
R13156 VSS.n3783 VSS.n148 0.00095
R13157 VSS.n2678 VSS.n2677 0.00095
R13158 VSS.n1100 VSS.n1099 0.00095
R13159 VSS.n2674 VSS.n1102 0.00095
R13160 VSS.n2666 VSS.n1103 0.00095
R13161 VSS.n2665 VSS.n1107 0.00095
R13162 VSS.n2669 VSS.n2663 0.00095
R13163 VSS.n2655 VSS.n1108 0.00095
R13164 VSS.n2654 VSS.n1112 0.00095
R13165 VSS.n2658 VSS.n2652 0.00095
R13166 VSS.n2644 VSS.n1113 0.00095
R13167 VSS.n2643 VSS.n1117 0.00095
R13168 VSS.n2647 VSS.n1118 0.00095
R13169 VSS.n2614 VSS.n2613 0.00095
R13170 VSS.n1136 VSS.n1135 0.00095
R13171 VSS.n2610 VSS.n1138 0.00095
R13172 VSS.n2602 VSS.n1139 0.00095
R13173 VSS.n2601 VSS.n1143 0.00095
R13174 VSS.n2605 VSS.n2599 0.00095
R13175 VSS.n2591 VSS.n1144 0.00095
R13176 VSS.n2590 VSS.n1148 0.00095
R13177 VSS.n2594 VSS.n2588 0.00095
R13178 VSS.n2580 VSS.n1149 0.00095
R13179 VSS.n2579 VSS.n1153 0.00095
R13180 VSS.n2583 VSS.n2577 0.00095
R13181 VSS.n2569 VSS.n1154 0.00095
R13182 VSS.n2568 VSS.n1158 0.00095
R13183 VSS.n2572 VSS.n2566 0.00095
R13184 VSS.n2558 VSS.n1159 0.00095
R13185 VSS.n2557 VSS.n2555 0.00095
R13186 VSS.n2561 VSS.n935 0.00095
R13187 VSS.n2800 VSS.n936 0.00095
R13188 VSS.n2797 VSS.n932 0.00095
R13189 VSS.n2804 VSS.n930 0.00095
R13190 VSS.n2807 VSS.n2806 0.00095
R13191 VSS.n928 VSS.n925 0.00095
R13192 VSS.n2810 VSS.n926 0.00095
R13193 VSS.n962 VSS.n961 0.00095
R13194 VSS.n959 VSS.n955 0.00095
R13195 VSS.n966 VSS.n953 0.00095
R13196 VSS.n994 VSS.n993 0.00095
R13197 VSS.n970 VSS.n969 0.00095
R13198 VSS.n990 VSS.n989 0.00095
R13199 VSS.n2972 VSS.n2971 0.00095
R13200 VSS.n846 VSS.n845 0.00095
R13201 VSS.n2968 VSS.n2965 0.00095
R13202 VSS.n2966 VSS.n514 0.00095
R13203 VSS.n3086 VSS.n515 0.00095
R13204 VSS.n3082 VSS.n517 0.00095
R13205 VSS.n3074 VSS.n518 0.00095
R13206 VSS.n3073 VSS.n521 0.00095
R13207 VSS.n3077 VSS.n522 0.00095
R13208 VSS.n582 VSS.n581 0.00095
R13209 VSS.n578 VSS.n573 0.00095
R13210 VSS.n585 VSS.n574 0.00095
R13211 VSS.n633 VSS.n632 0.00095
R13212 VSS.n562 VSS.n561 0.00095
R13213 VSS.n629 VSS.n628 0.00095
R13214 VSS.n3193 VSS.n3192 0.00095
R13215 VSS.n443 VSS.n442 0.00095
R13216 VSS.n3823 VSS.n3822 0.00095
R13217 VSS.n127 VSS.n126 0.00095
R13218 VSS.n3819 VSS.n128 0.00095
R13219 VSS.n3811 VSS.n129 0.00095
R13220 VSS.n3810 VSS.n133 0.00095
R13221 VSS.n3814 VSS.n3806 0.00095
R13222 VSS.n3798 VSS.n134 0.00095
R13223 VSS.n3797 VSS.n138 0.00095
R13224 VSS.n3801 VSS.n3796 0.00095
R13225 VSS.n3788 VSS.n139 0.00095
R13226 VSS.n3787 VSS.n143 0.00095
R13227 VSS.n3791 VSS.n144 0.00095
R13228 VSS.n2342 VSS.n2335 0.00095
R13229 VSS.n2339 VSS.n1280 0.00095
R13230 VSS.n2346 VSS.n1278 0.00095
R13231 VSS.n2351 VSS.n2350 0.00095
R13232 VSS.n2348 VSS.n1275 0.00095
R13233 VSS.n2355 VSS.n1273 0.00095
R13234 VSS.n2360 VSS.n2359 0.00095
R13235 VSS.n2357 VSS.n1270 0.00095
R13236 VSS.n2364 VSS.n1268 0.00095
R13237 VSS.n2369 VSS.n2368 0.00095
R13238 VSS.n2366 VSS.n1265 0.00095
R13239 VSS.n2373 VSS.n1263 0.00095
R13240 VSS.n2381 VSS.n2374 0.00095
R13241 VSS.n2378 VSS.n1260 0.00095
R13242 VSS.n2385 VSS.n1258 0.00095
R13243 VSS.n2390 VSS.n2389 0.00095
R13244 VSS.n2387 VSS.n1255 0.00095
R13245 VSS.n2394 VSS.n1253 0.00095
R13246 VSS.n2399 VSS.n2398 0.00095
R13247 VSS.n2396 VSS.n1250 0.00095
R13248 VSS.n2403 VSS.n1248 0.00095
R13249 VSS.n2408 VSS.n2407 0.00095
R13250 VSS.n2405 VSS.n1245 0.00095
R13251 VSS.n2412 VSS.n1243 0.00095
R13252 VSS.n2415 VSS.n2414 0.00095
R13253 VSS.n1241 VSS.n1239 0.00095
R13254 VSS.n2418 VSS.n1240 0.00095
R13255 VSS.n2553 VSS.n2552 0.00095
R13256 VSS.n1166 VSS.n1165 0.00095
R13257 VSS.n2549 VSS.n1168 0.00095
R13258 VSS.n2541 VSS.n1169 0.00095
R13259 VSS.n2540 VSS.n2538 0.00095
R13260 VSS.n2544 VSS.n921 0.00095
R13261 VSS.n2817 VSS.n922 0.00095
R13262 VSS.n2814 VSS.n918 0.00095
R13263 VSS.n2821 VSS.n916 0.00095
R13264 VSS.n2824 VSS.n2823 0.00095
R13265 VSS.n914 VSS.n911 0.00095
R13266 VSS.n2827 VSS.n912 0.00095
R13267 VSS.n985 VSS.n984 0.00095
R13268 VSS.n976 VSS.n975 0.00095
R13269 VSS.n981 VSS.n980 0.00095
R13270 VSS.n2961 VSS.n2960 0.00095
R13271 VSS.n852 VSS.n851 0.00095
R13272 VSS.n2957 VSS.n2956 0.00095
R13273 VSS.n3092 VSS.n3091 0.00095
R13274 VSS.n3096 VSS.n509 0.00095
R13275 VSS.n3098 VSS.n506 0.00095
R13276 VSS.n3101 VSS.n3100 0.00095
R13277 VSS.n504 VSS.n501 0.00095
R13278 VSS.n3104 VSS.n502 0.00095
R13279 VSS.n592 VSS.n570 0.00095
R13280 VSS.n589 VSS.n567 0.00095
R13281 VSS.n596 VSS.n565 0.00095
R13282 VSS.n624 VSS.n623 0.00095
R13283 VSS.n600 VSS.n599 0.00095
R13284 VSS.n620 VSS.n619 0.00095
R13285 VSS.n3185 VSS.n3184 0.00095
R13286 VSS.n449 VSS.n448 0.00095
R13287 VSS.n1620 VSS.n1613 0.00095
R13288 VSS.n1617 VSS.n1419 0.00095
R13289 VSS.n1623 VSS.n1417 0.00095
R13290 VSS.n1628 VSS.n1627 0.00095
R13291 VSS.n1625 VSS.n1414 0.00095
R13292 VSS.n1632 VSS.n1412 0.00095
R13293 VSS.n1637 VSS.n1636 0.00095
R13294 VSS.n1634 VSS.n1409 0.00095
R13295 VSS.n1641 VSS.n1407 0.00095
R13296 VSS.n1644 VSS.n1643 0.00095
R13297 VSS.n1405 VSS.n1403 0.00095
R13298 VSS.n1647 VSS.n1404 0.00095
R13299 VSS.n2331 VSS.n2330 0.00095
R13300 VSS.n1285 VSS.n1284 0.00095
R13301 VSS.n2327 VSS.n1287 0.00095
R13302 VSS.n2319 VSS.n1288 0.00095
R13303 VSS.n2318 VSS.n1292 0.00095
R13304 VSS.n2322 VSS.n2316 0.00095
R13305 VSS.n2308 VSS.n1293 0.00095
R13306 VSS.n2307 VSS.n1297 0.00095
R13307 VSS.n2311 VSS.n2305 0.00095
R13308 VSS.n2297 VSS.n1298 0.00095
R13309 VSS.n2296 VSS.n1302 0.00095
R13310 VSS.n2300 VSS.n2294 0.00095
R13311 VSS.n2286 VSS.n1303 0.00095
R13312 VSS.n2285 VSS.n1307 0.00095
R13313 VSS.n2289 VSS.n2283 0.00095
R13314 VSS.n2275 VSS.n1308 0.00095
R13315 VSS.n2274 VSS.n1312 0.00095
R13316 VSS.n2278 VSS.n1313 0.00095
R13317 VSS.n2258 VSS.n2257 0.00095
R13318 VSS.n1326 VSS.n1325 0.00095
R13319 VSS.n2254 VSS.n1328 0.00095
R13320 VSS.n2246 VSS.n1329 0.00095
R13321 VSS.n2245 VSS.n1790 0.00095
R13322 VSS.n2249 VSS.n1235 0.00095
R13323 VSS.n2425 VSS.n1236 0.00095
R13324 VSS.n2422 VSS.n1232 0.00095
R13325 VSS.n2429 VSS.n1230 0.00095
R13326 VSS.n2432 VSS.n2431 0.00095
R13327 VSS.n1228 VSS.n1223 0.00095
R13328 VSS.n2435 VSS.n1224 0.00095
R13329 VSS.n2536 VSS.n2535 0.00095
R13330 VSS.n1176 VSS.n1175 0.00095
R13331 VSS.n2532 VSS.n1178 0.00095
R13332 VSS.n2524 VSS.n1179 0.00095
R13333 VSS.n2523 VSS.n2521 0.00095
R13334 VSS.n2527 VSS.n907 0.00095
R13335 VSS.n2834 VSS.n908 0.00095
R13336 VSS.n2831 VSS.n904 0.00095
R13337 VSS.n2838 VSS.n902 0.00095
R13338 VSS.n2841 VSS.n2840 0.00095
R13339 VSS.n900 VSS.n897 0.00095
R13340 VSS.n2844 VSS.n898 0.00095
R13341 VSS.n2952 VSS.n2951 0.00095
R13342 VSS.n858 VSS.n857 0.00095
R13343 VSS.n2948 VSS.n860 0.00095
R13344 VSS.n2938 VSS.n861 0.00095
R13345 VSS.n2943 VSS.n2939 0.00095
R13346 VSS.n2940 VSS.n497 0.00095
R13347 VSS.n3111 VSS.n498 0.00095
R13348 VSS.n3108 VSS.n494 0.00095
R13349 VSS.n3115 VSS.n492 0.00095
R13350 VSS.n3118 VSS.n3117 0.00095
R13351 VSS.n490 VSS.n487 0.00095
R13352 VSS.n3121 VSS.n488 0.00095
R13353 VSS.n615 VSS.n614 0.00095
R13354 VSS.n606 VSS.n605 0.00095
R13355 VSS.n611 VSS.n610 0.00095
R13356 VSS.n3177 VSS.n3176 0.00095
R13357 VSS.n455 VSS.n454 0.00095
R13358 VSS.n1609 VSS.n1608 0.00095
R13359 VSS.n1424 VSS.n1423 0.00095
R13360 VSS.n1605 VSS.n1425 0.00095
R13361 VSS.n1597 VSS.n1426 0.00095
R13362 VSS.n1596 VSS.n1430 0.00095
R13363 VSS.n1600 VSS.n1594 0.00095
R13364 VSS.n1586 VSS.n1431 0.00095
R13365 VSS.n1585 VSS.n1583 0.00095
R13366 VSS.n1589 VSS.n1399 0.00095
R13367 VSS.n1654 VSS.n1400 0.00095
R13368 VSS.n1651 VSS.n1396 0.00095
R13369 VSS.n1658 VSS.n1394 0.00095
R13370 VSS.n1666 VSS.n1659 0.00095
R13371 VSS.n1663 VSS.n1391 0.00095
R13372 VSS.n1670 VSS.n1389 0.00095
R13373 VSS.n1675 VSS.n1674 0.00095
R13374 VSS.n1672 VSS.n1386 0.00095
R13375 VSS.n1679 VSS.n1384 0.00095
R13376 VSS.n1684 VSS.n1683 0.00095
R13377 VSS.n1681 VSS.n1381 0.00095
R13378 VSS.n1688 VSS.n1379 0.00095
R13379 VSS.n1693 VSS.n1692 0.00095
R13380 VSS.n1690 VSS.n1376 0.00095
R13381 VSS.n1697 VSS.n1374 0.00095
R13382 VSS.n1702 VSS.n1701 0.00095
R13383 VSS.n1699 VSS.n1371 0.00095
R13384 VSS.n1706 VSS.n1369 0.00095
R13385 VSS.n1711 VSS.n1710 0.00095
R13386 VSS.n1708 VSS.n1366 0.00095
R13387 VSS.n1715 VSS.n1364 0.00095
R13388 VSS.n1718 VSS.n1717 0.00095
R13389 VSS.n1362 VSS.n1357 0.00095
R13390 VSS.n1721 VSS.n1358 0.00095
R13391 VSS.n1788 VSS.n1787 0.00095
R13392 VSS.n1336 VSS.n1335 0.00095
R13393 VSS.n1784 VSS.n1338 0.00095
R13394 VSS.n1776 VSS.n1339 0.00095
R13395 VSS.n1775 VSS.n1773 0.00095
R13396 VSS.n1779 VSS.n1219 0.00095
R13397 VSS.n2442 VSS.n1220 0.00095
R13398 VSS.n2439 VSS.n1216 0.00095
R13399 VSS.n2446 VSS.n1214 0.00095
R13400 VSS.n2449 VSS.n2448 0.00095
R13401 VSS.n1212 VSS.n1207 0.00095
R13402 VSS.n2452 VSS.n1208 0.00095
R13403 VSS.n2519 VSS.n2518 0.00095
R13404 VSS.n1186 VSS.n1185 0.00095
R13405 VSS.n2515 VSS.n1188 0.00095
R13406 VSS.n2507 VSS.n1189 0.00095
R13407 VSS.n2506 VSS.n2504 0.00095
R13408 VSS.n2510 VSS.n893 0.00095
R13409 VSS.n2851 VSS.n894 0.00095
R13410 VSS.n2848 VSS.n890 0.00095
R13411 VSS.n2855 VSS.n888 0.00095
R13412 VSS.n2858 VSS.n2857 0.00095
R13413 VSS.n886 VSS.n881 0.00095
R13414 VSS.n2861 VSS.n882 0.00095
R13415 VSS.n2936 VSS.n2935 0.00095
R13416 VSS.n2932 VSS.n869 0.00095
R13417 VSS.n870 VSS.n867 0.00095
R13418 VSS.n2902 VSS.n2901 0.00095
R13419 VSS.n2898 VSS.n2896 0.00095
R13420 VSS.n2905 VSS.n483 0.00095
R13421 VSS.n3128 VSS.n484 0.00095
R13422 VSS.n3125 VSS.n480 0.00095
R13423 VSS.n3132 VSS.n478 0.00095
R13424 VSS.n3135 VSS.n3134 0.00095
R13425 VSS.n476 VSS.n473 0.00095
R13426 VSS.n3138 VSS.n474 0.00095
R13427 VSS.n3169 VSS.n3168 0.00095
R13428 VSS.n461 VSS.n460 0.00095
R13429 VSS.n1452 VSS.n1445 0.00095
R13430 VSS.n1449 VSS.n1442 0.00095
R13431 VSS.n1455 VSS.n1440 0.00095
R13432 VSS.n1460 VSS.n1459 0.00095
R13433 VSS.n1457 VSS.n1437 0.00095
R13434 VSS.n1464 VSS.n1435 0.00095
R13435 VSS.n1581 VSS.n1580 0.00095
R13436 VSS.n1468 VSS.n1467 0.00095
R13437 VSS.n1577 VSS.n1472 0.00095
R13438 VSS.n1569 VSS.n1473 0.00095
R13439 VSS.n1568 VSS.n1476 0.00095
R13440 VSS.n1572 VSS.n1566 0.00095
R13441 VSS.n1558 VSS.n1477 0.00095
R13442 VSS.n1557 VSS.n1480 0.00095
R13443 VSS.n1561 VSS.n1555 0.00095
R13444 VSS.n1547 VSS.n1481 0.00095
R13445 VSS.n1546 VSS.n1484 0.00095
R13446 VSS.n1550 VSS.n1544 0.00095
R13447 VSS.n1536 VSS.n1485 0.00095
R13448 VSS.n1535 VSS.n1488 0.00095
R13449 VSS.n1539 VSS.n1533 0.00095
R13450 VSS.n1525 VSS.n1489 0.00095
R13451 VSS.n1524 VSS.n1492 0.00095
R13452 VSS.n1528 VSS.n1522 0.00095
R13453 VSS.n1514 VSS.n1493 0.00095
R13454 VSS.n1513 VSS.n1496 0.00095
R13455 VSS.n1517 VSS.n1511 0.00095
R13456 VSS.n1503 VSS.n1497 0.00095
R13457 VSS.n1502 VSS.n1500 0.00095
R13458 VSS.n1506 VSS.n1353 0.00095
R13459 VSS.n1728 VSS.n1354 0.00095
R13460 VSS.n1725 VSS.n1350 0.00095
R13461 VSS.n1732 VSS.n1348 0.00095
R13462 VSS.n1740 VSS.n1733 0.00095
R13463 VSS.n1737 VSS.n1345 0.00095
R13464 VSS.n1744 VSS.n1343 0.00095
R13465 VSS.n1771 VSS.n1770 0.00095
R13466 VSS.n1748 VSS.n1747 0.00095
R13467 VSS.n1767 VSS.n1752 0.00095
R13468 VSS.n1759 VSS.n1753 0.00095
R13469 VSS.n1758 VSS.n1756 0.00095
R13470 VSS.n1762 VSS.n1203 0.00095
R13471 VSS.n2459 VSS.n1204 0.00095
R13472 VSS.n2456 VSS.n1200 0.00095
R13473 VSS.n2463 VSS.n1198 0.00095
R13474 VSS.n2471 VSS.n2464 0.00095
R13475 VSS.n2468 VSS.n1195 0.00095
R13476 VSS.n2475 VSS.n1193 0.00095
R13477 VSS.n2502 VSS.n2501 0.00095
R13478 VSS.n2479 VSS.n2478 0.00095
R13479 VSS.n2498 VSS.n2483 0.00095
R13480 VSS.n2490 VSS.n2484 0.00095
R13481 VSS.n2489 VSS.n2487 0.00095
R13482 VSS.n2493 VSS.n877 0.00095
R13483 VSS.n2868 VSS.n878 0.00095
R13484 VSS.n2865 VSS.n874 0.00095
R13485 VSS.n2872 VSS.n872 0.00095
R13486 VSS.n2928 VSS.n2927 0.00095
R13487 VSS.n2924 VSS.n2920 0.00095
R13488 VSS.n2921 VSS.n2918 0.00095
R13489 VSS.n2910 VSS.n2875 0.00095
R13490 VSS.n2909 VSS.n2878 0.00095
R13491 VSS.n2913 VSS.n2893 0.00095
R13492 VSS.n2885 VSS.n2879 0.00095
R13493 VSS.n2884 VSS.n2882 0.00095
R13494 VSS.n2888 VSS.n469 0.00095
R13495 VSS.n3145 VSS.n470 0.00095
R13496 VSS.n3142 VSS.n466 0.00095
R13497 VSS.n3149 VSS.n464 0.00095
R13498 VSS.n3161 VSS.n3160 0.00095
R13499 VSS.n3153 VSS.n3152 0.00095
R13500 VSS.n3712 VSS.n167 0.0007
R13501 VSS.n3717 VSS.n3716 0.0007
R13502 VSS.n2700 VSS.n169 0.0007
R13503 VSS.n2707 VSS.n1084 0.0007
R13504 VSS.n2706 VSS.n1087 0.0007
R13505 VSS.n2657 VSS.n2653 0.0007
R13506 VSS.n2656 VSS.n1109 0.0007
R13507 VSS.n2661 VSS.n2660 0.0007
R13508 VSS.n2356 VSS.n1111 0.0007
R13509 VSS.n2363 VSS.n1269 0.0007
R13510 VSS.n2362 VSS.n1272 0.0007
R13511 VSS.n2310 VSS.n2306 0.0007
R13512 VSS.n2309 VSS.n1294 0.0007
R13513 VSS.n2314 VSS.n2313 0.0007
R13514 VSS.n1680 VSS.n1296 0.0007
R13515 VSS.n1687 VSS.n1380 0.0007
R13516 VSS.n1686 VSS.n1383 0.0007
R13517 VSS.n1538 VSS.n1534 0.0007
R13518 VSS.n1537 VSS.n1486 0.0007
R13519 VSS.n1542 VSS.n1541 0.0007
R13520 VSS.n673 VSS.n669 0.0007
R13521 VSS.n672 VSS.n546 0.0007
R13522 VSS.n677 VSS.n676 0.0007
R13523 VSS.n654 VSS.n548 0.0007
R13524 VSS.n651 VSS.n650 0.0007
R13525 VSS.n576 VSS.n553 0.0007
R13526 VSS.n584 VSS.n577 0.0007
R13527 VSS.n583 VSS.n579 0.0007
R13528 VSS.n587 VSS.n571 0.0007
R13529 VSS.n591 VSS.n590 0.0007
R13530 VSS.n595 VSS.n566 0.0007
R13531 VSS.n594 VSS.n569 0.0007
R13532 VSS.n3120 VSS.n489 0.0007
R13533 VSS.n3119 VSS.n491 0.0007
R13534 VSS.n3123 VSS.n485 0.0007
R13535 VSS.n3127 VSS.n3126 0.0007
R13536 VSS.n3131 VSS.n479 0.0007
R13537 VSS.n3130 VSS.n482 0.0007
R13538 VSS.n2887 VSS.n2883 0.0007
R13539 VSS.n2886 VSS.n2880 0.0007
R13540 VSS.n2891 VSS.n2890 0.0007
R13541 VSS.n3050 VSS.n539 0.0007
R13542 VSS.n3049 VSS.n3048 0.0007
R13543 VSS.n3053 VSS.n535 0.0007
R13544 VSS.n3055 VSS.n3054 0.0007
R13545 VSS.n3062 VSS.n531 0.0007
R13546 VSS.n3059 VSS.n532 0.0007
R13547 VSS.n3085 VSS.n516 0.0007
R13548 VSS.n3084 VSS.n3083 0.0007
R13549 VSS.n3088 VSS.n512 0.0007
R13550 VSS.n3090 VSS.n3089 0.0007
R13551 VSS.n3097 VSS.n507 0.0007
R13552 VSS.n3094 VSS.n508 0.0007
R13553 VSS.n2942 VSS.n510 0.0007
R13554 VSS.n2941 VSS.n862 0.0007
R13555 VSS.n2946 VSS.n2945 0.0007
R13556 VSS.n2937 VSS.n864 0.0007
R13557 VSS.n2934 VSS.n2933 0.0007
R13558 VSS.n2930 VSS.n868 0.0007
R13559 VSS.n2929 VSS.n871 0.0007
R13560 VSS.n2926 VSS.n2925 0.0007
R13561 VSS.n2922 VSS.n2919 0.0007
R13562 VSS.n2993 VSS.n830 0.0007
R13563 VSS.n2990 VSS.n2989 0.0007
R13564 VSS.n2983 VSS.n835 0.0007
R13565 VSS.n2982 VSS.n836 0.0007
R13566 VSS.n2979 VSS.n2978 0.0007
R13567 VSS.n2974 VSS.n841 0.0007
R13568 VSS.n2973 VSS.n842 0.0007
R13569 VSS.n2970 VSS.n2969 0.0007
R13570 VSS.n2963 VSS.n847 0.0007
R13571 VSS.n2962 VSS.n848 0.0007
R13572 VSS.n2959 VSS.n2958 0.0007
R13573 VSS.n2954 VSS.n853 0.0007
R13574 VSS.n2953 VSS.n854 0.0007
R13575 VSS.n2950 VSS.n2949 0.0007
R13576 VSS.n884 VSS.n859 0.0007
R13577 VSS.n2860 VSS.n885 0.0007
R13578 VSS.n2859 VSS.n887 0.0007
R13579 VSS.n2863 VSS.n879 0.0007
R13580 VSS.n2867 VSS.n2866 0.0007
R13581 VSS.n2871 VSS.n873 0.0007
R13582 VSS.n2870 VSS.n876 0.0007
R13583 VSS.n3349 VSS.n423 0.0007
R13584 VSS.n3346 VSS.n3345 0.0007
R13585 VSS.n638 VSS.n428 0.0007
R13586 VSS.n643 VSS.n639 0.0007
R13587 VSS.n642 VSS.n556 0.0007
R13588 VSS.n647 VSS.n646 0.0007
R13589 VSS.n634 VSS.n558 0.0007
R13590 VSS.n631 VSS.n630 0.0007
R13591 VSS.n626 VSS.n563 0.0007
R13592 VSS.n625 VSS.n564 0.0007
R13593 VSS.n622 VSS.n621 0.0007
R13594 VSS.n617 VSS.n601 0.0007
R13595 VSS.n616 VSS.n602 0.0007
R13596 VSS.n613 VSS.n612 0.0007
R13597 VSS.n608 VSS.n607 0.0007
R13598 VSS.n3137 VSS.n475 0.0007
R13599 VSS.n3136 VSS.n477 0.0007
R13600 VSS.n3140 VSS.n471 0.0007
R13601 VSS.n3144 VSS.n3143 0.0007
R13602 VSS.n3148 VSS.n465 0.0007
R13603 VSS.n3147 VSS.n468 0.0007
R13604 VSS.n3338 VSS.n3334 0.0007
R13605 VSS.n3337 VSS.n431 0.0007
R13606 VSS.n3342 VSS.n3341 0.0007
R13607 VSS.n3202 VSS.n433 0.0007
R13608 VSS.n3199 VSS.n3198 0.0007
R13609 VSS.n3195 VSS.n438 0.0007
R13610 VSS.n3194 VSS.n439 0.0007
R13611 VSS.n3191 VSS.n3190 0.0007
R13612 VSS.n3187 VSS.n444 0.0007
R13613 VSS.n3186 VSS.n445 0.0007
R13614 VSS.n3183 VSS.n3182 0.0007
R13615 VSS.n3179 VSS.n450 0.0007
R13616 VSS.n3178 VSS.n451 0.0007
R13617 VSS.n3175 VSS.n3174 0.0007
R13618 VSS.n3171 VSS.n456 0.0007
R13619 VSS.n3170 VSS.n457 0.0007
R13620 VSS.n3167 VSS.n3166 0.0007
R13621 VSS.n3163 VSS.n462 0.0007
R13622 VSS.n3162 VSS.n463 0.0007
R13623 VSS.n3159 VSS.n3158 0.0007
R13624 VSS.n3155 VSS.n3154 0.0007
R13625 VSS.n3604 VSS.n192 0.0007
R13626 VSS.n3609 VSS.n3608 0.0007
R13627 VSS.n2745 VSS.n194 0.0007
R13628 VSS.n2752 VSS.n1059 0.0007
R13629 VSS.n2751 VSS.n1062 0.0007
R13630 VSS.n2582 VSS.n2578 0.0007
R13631 VSS.n2581 VSS.n1150 0.0007
R13632 VSS.n2586 VSS.n2585 0.0007
R13633 VSS.n2404 VSS.n1152 0.0007
R13634 VSS.n2411 VSS.n1244 0.0007
R13635 VSS.n2410 VSS.n1247 0.0007
R13636 VSS.n2248 VSS.n2244 0.0007
R13637 VSS.n2247 VSS.n1330 0.0007
R13638 VSS.n2252 VSS.n2251 0.0007
R13639 VSS.n1789 VSS.n1332 0.0007
R13640 VSS.n1786 VSS.n1785 0.0007
R13641 VSS.n1735 VSS.n1337 0.0007
R13642 VSS.n1739 VSS.n1738 0.0007
R13643 VSS.n1743 VSS.n1344 0.0007
R13644 VSS.n1742 VSS.n1347 0.0007
R13645 VSS.n3624 VSS.n182 0.0007
R13646 VSS.n3629 VSS.n3628 0.0007
R13647 VSS.n2727 VSS.n184 0.0007
R13648 VSS.n2734 VSS.n1069 0.0007
R13649 VSS.n2733 VSS.n1072 0.0007
R13650 VSS.n2604 VSS.n2600 0.0007
R13651 VSS.n2603 VSS.n1140 0.0007
R13652 VSS.n2608 VSS.n2607 0.0007
R13653 VSS.n2386 VSS.n1142 0.0007
R13654 VSS.n2393 VSS.n1254 0.0007
R13655 VSS.n2392 VSS.n1257 0.0007
R13656 VSS.n2277 VSS.n2273 0.0007
R13657 VSS.n2276 VSS.n1309 0.0007
R13658 VSS.n2281 VSS.n2280 0.0007
R13659 VSS.n1707 VSS.n1311 0.0007
R13660 VSS.n1714 VSS.n1365 0.0007
R13661 VSS.n1713 VSS.n1368 0.0007
R13662 VSS.n1505 VSS.n1501 0.0007
R13663 VSS.n1504 VSS.n1498 0.0007
R13664 VSS.n1509 VSS.n1508 0.0007
R13665 VSS.n3614 VSS.n187 0.0007
R13666 VSS.n3619 VSS.n3618 0.0007
R13667 VSS.n2736 VSS.n189 0.0007
R13668 VSS.n2743 VSS.n1064 0.0007
R13669 VSS.n2742 VSS.n1067 0.0007
R13670 VSS.n2593 VSS.n2589 0.0007
R13671 VSS.n2592 VSS.n1145 0.0007
R13672 VSS.n2597 VSS.n2596 0.0007
R13673 VSS.n2395 VSS.n1147 0.0007
R13674 VSS.n2402 VSS.n1249 0.0007
R13675 VSS.n2401 VSS.n1252 0.0007
R13676 VSS.n2259 VSS.n1322 0.0007
R13677 VSS.n2256 VSS.n2255 0.0007
R13678 VSS.n1360 VSS.n1327 0.0007
R13679 VSS.n1720 VSS.n1361 0.0007
R13680 VSS.n1719 VSS.n1363 0.0007
R13681 VSS.n1723 VSS.n1355 0.0007
R13682 VSS.n1727 VSS.n1726 0.0007
R13683 VSS.n1731 VSS.n1349 0.0007
R13684 VSS.n1730 VSS.n1352 0.0007
R13685 VSS.n3634 VSS.n177 0.0007
R13686 VSS.n3639 VSS.n3638 0.0007
R13687 VSS.n2718 VSS.n179 0.0007
R13688 VSS.n2725 VSS.n1074 0.0007
R13689 VSS.n2724 VSS.n1077 0.0007
R13690 VSS.n2615 VSS.n1132 0.0007
R13691 VSS.n2612 VSS.n2611 0.0007
R13692 VSS.n2376 VSS.n1137 0.0007
R13693 VSS.n2380 VSS.n2379 0.0007
R13694 VSS.n2384 VSS.n1259 0.0007
R13695 VSS.n2383 VSS.n1262 0.0007
R13696 VSS.n2288 VSS.n2284 0.0007
R13697 VSS.n2287 VSS.n1304 0.0007
R13698 VSS.n2292 VSS.n2291 0.0007
R13699 VSS.n1698 VSS.n1306 0.0007
R13700 VSS.n1705 VSS.n1370 0.0007
R13701 VSS.n1704 VSS.n1373 0.0007
R13702 VSS.n1516 VSS.n1512 0.0007
R13703 VSS.n1515 VSS.n1494 0.0007
R13704 VSS.n1520 VSS.n1519 0.0007
R13705 VSS.n3703 VSS.n3699 0.0007
R13706 VSS.n3702 VSS.n172 0.0007
R13707 VSS.n3707 VSS.n3706 0.0007
R13708 VSS.n2709 VSS.n174 0.0007
R13709 VSS.n2716 VSS.n1079 0.0007
R13710 VSS.n2715 VSS.n1082 0.0007
R13711 VSS.n2646 VSS.n2642 0.0007
R13712 VSS.n2645 VSS.n1114 0.0007
R13713 VSS.n2650 VSS.n2649 0.0007
R13714 VSS.n2365 VSS.n1116 0.0007
R13715 VSS.n2372 VSS.n1264 0.0007
R13716 VSS.n2371 VSS.n1267 0.0007
R13717 VSS.n2299 VSS.n2295 0.0007
R13718 VSS.n2298 VSS.n1299 0.0007
R13719 VSS.n2303 VSS.n2302 0.0007
R13720 VSS.n1689 VSS.n1301 0.0007
R13721 VSS.n1696 VSS.n1375 0.0007
R13722 VSS.n1695 VSS.n1378 0.0007
R13723 VSS.n1527 VSS.n1523 0.0007
R13724 VSS.n1526 VSS.n1490 0.0007
R13725 VSS.n1531 VSS.n1530 0.0007
R13726 VSS.n2775 VSS.n2768 0.0007
R13727 VSS.n2774 VSS.n2770 0.0007
R13728 VSS.n2778 VSS.n2764 0.0007
R13729 VSS.n2782 VSS.n2781 0.0007
R13730 VSS.n2786 VSS.n1049 0.0007
R13731 VSS.n2785 VSS.n1052 0.0007
R13732 VSS.n2560 VSS.n2556 0.0007
R13733 VSS.n2559 VSS.n1160 0.0007
R13734 VSS.n2564 VSS.n2563 0.0007
R13735 VSS.n2554 VSS.n1162 0.0007
R13736 VSS.n2551 VSS.n2550 0.0007
R13737 VSS.n1226 VSS.n1167 0.0007
R13738 VSS.n2434 VSS.n1227 0.0007
R13739 VSS.n2433 VSS.n1229 0.0007
R13740 VSS.n2437 VSS.n1221 0.0007
R13741 VSS.n2441 VSS.n2440 0.0007
R13742 VSS.n2445 VSS.n1215 0.0007
R13743 VSS.n2444 VSS.n1218 0.0007
R13744 VSS.n1761 VSS.n1757 0.0007
R13745 VSS.n1760 VSS.n1754 0.0007
R13746 VSS.n1765 VSS.n1764 0.0007
R13747 VSS.n3595 VSS.n3591 0.0007
R13748 VSS.n3594 VSS.n197 0.0007
R13749 VSS.n3599 VSS.n3598 0.0007
R13750 VSS.n2754 VSS.n199 0.0007
R13751 VSS.n2761 VSS.n1054 0.0007
R13752 VSS.n2760 VSS.n1057 0.0007
R13753 VSS.n2571 VSS.n2567 0.0007
R13754 VSS.n2570 VSS.n1155 0.0007
R13755 VSS.n2575 VSS.n2574 0.0007
R13756 VSS.n2417 VSS.n1157 0.0007
R13757 VSS.n2416 VSS.n1242 0.0007
R13758 VSS.n2420 VSS.n1237 0.0007
R13759 VSS.n2424 VSS.n2423 0.0007
R13760 VSS.n2428 VSS.n1231 0.0007
R13761 VSS.n2427 VSS.n1234 0.0007
R13762 VSS.n1778 VSS.n1774 0.0007
R13763 VSS.n1777 VSS.n1340 0.0007
R13764 VSS.n1782 VSS.n1781 0.0007
R13765 VSS.n1772 VSS.n1342 0.0007
R13766 VSS.n1769 VSS.n1768 0.0007
R13767 VSS.n1750 VSS.n1749 0.0007
R13768 VSS.n3041 VSS.n3037 0.0007
R13769 VSS.n3039 VSS.n542 0.0007
R13770 VSS.n3045 VSS.n3044 0.0007
R13771 VSS.n3068 VSS.n527 0.0007
R13772 VSS.n3067 VSS.n529 0.0007
R13773 VSS.n3071 VSS.n523 0.0007
R13774 VSS.n3076 VSS.n3072 0.0007
R13775 VSS.n3075 VSS.n519 0.0007
R13776 VSS.n3080 VSS.n3079 0.0007
R13777 VSS.n3103 VSS.n503 0.0007
R13778 VSS.n3102 VSS.n505 0.0007
R13779 VSS.n3106 VSS.n499 0.0007
R13780 VSS.n3110 VSS.n3109 0.0007
R13781 VSS.n3114 VSS.n493 0.0007
R13782 VSS.n3113 VSS.n496 0.0007
R13783 VSS.n2904 VSS.n2897 0.0007
R13784 VSS.n2903 VSS.n2899 0.0007
R13785 VSS.n2907 VSS.n2894 0.0007
R13786 VSS.n2912 VSS.n2908 0.0007
R13787 VSS.n2911 VSS.n2876 0.0007
R13788 VSS.n2916 VSS.n2915 0.0007
R13789 VSS.n1006 VSS.n1004 0.0007
R13790 VSS.n1011 VSS.n998 0.0007
R13791 VSS.n1016 VSS.n1012 0.0007
R13792 VSS.n1015 VSS.n950 0.0007
R13793 VSS.n1020 VSS.n1019 0.0007
R13794 VSS.n995 VSS.n952 0.0007
R13795 VSS.n992 VSS.n991 0.0007
R13796 VSS.n987 VSS.n971 0.0007
R13797 VSS.n986 VSS.n972 0.0007
R13798 VSS.n983 VSS.n982 0.0007
R13799 VSS.n978 VSS.n977 0.0007
R13800 VSS.n2843 VSS.n899 0.0007
R13801 VSS.n2842 VSS.n901 0.0007
R13802 VSS.n2846 VSS.n895 0.0007
R13803 VSS.n2850 VSS.n2849 0.0007
R13804 VSS.n2854 VSS.n889 0.0007
R13805 VSS.n2853 VSS.n892 0.0007
R13806 VSS.n2492 VSS.n2488 0.0007
R13807 VSS.n2491 VSS.n2485 0.0007
R13808 VSS.n2496 VSS.n2495 0.0007
R13809 VSS.n3721 VSS.n162 0.0007
R13810 VSS.n3727 VSS.n3726 0.0007
R13811 VSS.n2691 VSS.n164 0.0007
R13812 VSS.n2698 VSS.n1089 0.0007
R13813 VSS.n2697 VSS.n1092 0.0007
R13814 VSS.n2668 VSS.n2664 0.0007
R13815 VSS.n2667 VSS.n1104 0.0007
R13816 VSS.n2672 VSS.n2671 0.0007
R13817 VSS.n2347 VSS.n1106 0.0007
R13818 VSS.n2354 VSS.n1274 0.0007
R13819 VSS.n2353 VSS.n1277 0.0007
R13820 VSS.n2321 VSS.n2317 0.0007
R13821 VSS.n2320 VSS.n1289 0.0007
R13822 VSS.n2325 VSS.n2324 0.0007
R13823 VSS.n1671 VSS.n1291 0.0007
R13824 VSS.n1678 VSS.n1385 0.0007
R13825 VSS.n1677 VSS.n1388 0.0007
R13826 VSS.n1549 VSS.n1545 0.0007
R13827 VSS.n1548 VSS.n1482 0.0007
R13828 VSS.n1553 VSS.n1552 0.0007
R13829 VSS.n3732 VSS.n157 0.0007
R13830 VSS.n3737 VSS.n3736 0.0007
R13831 VSS.n2682 VSS.n159 0.0007
R13832 VSS.n2689 VSS.n1094 0.0007
R13833 VSS.n2688 VSS.n2681 0.0007
R13834 VSS.n2679 VSS.n1096 0.0007
R13835 VSS.n2676 VSS.n2675 0.0007
R13836 VSS.n2337 VSS.n1101 0.0007
R13837 VSS.n2341 VSS.n2340 0.0007
R13838 VSS.n2345 VSS.n1279 0.0007
R13839 VSS.n2344 VSS.n2334 0.0007
R13840 VSS.n2332 VSS.n1281 0.0007
R13841 VSS.n2329 VSS.n2328 0.0007
R13842 VSS.n1661 VSS.n1286 0.0007
R13843 VSS.n1665 VSS.n1664 0.0007
R13844 VSS.n1669 VSS.n1390 0.0007
R13845 VSS.n1668 VSS.n1393 0.0007
R13846 VSS.n1560 VSS.n1556 0.0007
R13847 VSS.n1559 VSS.n1478 0.0007
R13848 VSS.n1564 VSS.n1563 0.0007
R13849 VSS.n3870 VSS.n108 0.0007
R13850 VSS.n3869 VSS.n3863 0.0007
R13851 VSS.n3861 VSS.n110 0.0007
R13852 VSS.n3858 VSS.n3857 0.0007
R13853 VSS.n3854 VSS.n111 0.0007
R13854 VSS.n3833 VSS.n118 0.0007
R13855 VSS.n3830 VSS.n3829 0.0007
R13856 VSS.n3825 VSS.n119 0.0007
R13857 VSS.n3824 VSS.n123 0.0007
R13858 VSS.n3821 VSS.n3820 0.0007
R13859 VSS.n1615 VSS.n124 0.0007
R13860 VSS.n1619 VSS.n1618 0.0007
R13861 VSS.n1622 VSS.n1418 0.0007
R13862 VSS.n1621 VSS.n1612 0.0007
R13863 VSS.n1610 VSS.n1420 0.0007
R13864 VSS.n1607 VSS.n1606 0.0007
R13865 VSS.n1447 VSS.n1421 0.0007
R13866 VSS.n1451 VSS.n1450 0.0007
R13867 VSS.n1454 VSS.n1441 0.0007
R13868 VSS.n1453 VSS.n1444 0.0007
R13869 VSS.n3877 VSS.n3875 0.0007
R13870 VSS.n3881 VSS.n103 0.0007
R13871 VSS.n3885 VSS.n3884 0.0007
R13872 VSS.n3889 VSS.n97 0.0007
R13873 VSS.n3888 VSS.n100 0.0007
R13874 VSS.n3914 VSS.n76 0.0007
R13875 VSS.n3911 VSS.n3910 0.0007
R13876 VSS.n3808 VSS.n81 0.0007
R13877 VSS.n3813 VSS.n3809 0.0007
R13878 VSS.n3812 VSS.n130 0.0007
R13879 VSS.n3817 VSS.n3816 0.0007
R13880 VSS.n1624 VSS.n132 0.0007
R13881 VSS.n1631 VSS.n1413 0.0007
R13882 VSS.n1630 VSS.n1416 0.0007
R13883 VSS.n1599 VSS.n1595 0.0007
R13884 VSS.n1598 VSS.n1427 0.0007
R13885 VSS.n1603 VSS.n1602 0.0007
R13886 VSS.n1456 VSS.n1429 0.0007
R13887 VSS.n1463 VSS.n1436 0.0007
R13888 VSS.n1462 VSS.n1439 0.0007
R13889 VSS.n3752 VSS.n3741 0.0007
R13890 VSS.n3751 VSS.n3744 0.0007
R13891 VSS.n3895 VSS.n93 0.0007
R13892 VSS.n3894 VSS.n95 0.0007
R13893 VSS.n3898 VSS.n89 0.0007
R13894 VSS.n3903 VSS.n3899 0.0007
R13895 VSS.n3902 VSS.n84 0.0007
R13896 VSS.n3907 VSS.n3906 0.0007
R13897 VSS.n3800 VSS.n86 0.0007
R13898 VSS.n3799 VSS.n135 0.0007
R13899 VSS.n3804 VSS.n3803 0.0007
R13900 VSS.n1633 VSS.n137 0.0007
R13901 VSS.n1640 VSS.n1408 0.0007
R13902 VSS.n1639 VSS.n1411 0.0007
R13903 VSS.n1588 VSS.n1584 0.0007
R13904 VSS.n1587 VSS.n1432 0.0007
R13905 VSS.n1592 VSS.n1591 0.0007
R13906 VSS.n1582 VSS.n1434 0.0007
R13907 VSS.n1579 VSS.n1578 0.0007
R13908 VSS.n1470 VSS.n1469 0.0007
R13909 VSS.n3759 VSS.n3757 0.0007
R13910 VSS.n3763 VSS.n153 0.0007
R13911 VSS.n3771 VSS.n3764 0.0007
R13912 VSS.n3770 VSS.n3766 0.0007
R13913 VSS.n3774 VSS.n149 0.0007
R13914 VSS.n3782 VSS.n3775 0.0007
R13915 VSS.n3781 VSS.n3777 0.0007
R13916 VSS.n3785 VSS.n145 0.0007
R13917 VSS.n3790 VSS.n3786 0.0007
R13918 VSS.n3789 VSS.n140 0.0007
R13919 VSS.n3794 VSS.n3793 0.0007
R13920 VSS.n1646 VSS.n142 0.0007
R13921 VSS.n1645 VSS.n1406 0.0007
R13922 VSS.n1649 VSS.n1401 0.0007
R13923 VSS.n1653 VSS.n1652 0.0007
R13924 VSS.n1657 VSS.n1395 0.0007
R13925 VSS.n1656 VSS.n1398 0.0007
R13926 VSS.n1571 VSS.n1567 0.0007
R13927 VSS.n1570 VSS.n1474 0.0007
R13928 VSS.n1575 VSS.n1574 0.0007
R13929 VSS.n3438 VSS.n374 0.0007
R13930 VSS.n3435 VSS.n3434 0.0007
R13931 VSS.n1044 VSS.n379 0.0007
R13932 VSS.n2792 VSS.n1045 0.0007
R13933 VSS.n2791 VSS.n1047 0.0007
R13934 VSS.n2795 VSS.n937 0.0007
R13935 VSS.n2799 VSS.n2798 0.0007
R13936 VSS.n2803 VSS.n931 0.0007
R13937 VSS.n2802 VSS.n934 0.0007
R13938 VSS.n2543 VSS.n2539 0.0007
R13939 VSS.n2542 VSS.n1170 0.0007
R13940 VSS.n2547 VSS.n2546 0.0007
R13941 VSS.n2537 VSS.n1172 0.0007
R13942 VSS.n2534 VSS.n2533 0.0007
R13943 VSS.n1210 VSS.n1177 0.0007
R13944 VSS.n2451 VSS.n1211 0.0007
R13945 VSS.n2450 VSS.n1213 0.0007
R13946 VSS.n2454 VSS.n1205 0.0007
R13947 VSS.n2458 VSS.n2457 0.0007
R13948 VSS.n2462 VSS.n1199 0.0007
R13949 VSS.n2461 VSS.n1202 0.0007
R13950 VSS.n3427 VSS.n223 0.0007
R13951 VSS.n3426 VSS.n382 0.0007
R13952 VSS.n3431 VSS.n3430 0.0007
R13953 VSS.n1036 VSS.n384 0.0007
R13954 VSS.n1035 VSS.n941 0.0007
R13955 VSS.n1040 VSS.n1039 0.0007
R13956 VSS.n2809 VSS.n927 0.0007
R13957 VSS.n2808 VSS.n929 0.0007
R13958 VSS.n2812 VSS.n923 0.0007
R13959 VSS.n2816 VSS.n2815 0.0007
R13960 VSS.n2820 VSS.n917 0.0007
R13961 VSS.n2819 VSS.n920 0.0007
R13962 VSS.n2526 VSS.n2522 0.0007
R13963 VSS.n2525 VSS.n1180 0.0007
R13964 VSS.n2530 VSS.n2529 0.0007
R13965 VSS.n2520 VSS.n1182 0.0007
R13966 VSS.n2517 VSS.n2516 0.0007
R13967 VSS.n2466 VSS.n1187 0.0007
R13968 VSS.n2470 VSS.n2469 0.0007
R13969 VSS.n2474 VSS.n1194 0.0007
R13970 VSS.n2473 VSS.n1197 0.0007
R13971 VSS.n3417 VSS.n3413 0.0007
R13972 VSS.n3416 VSS.n387 0.0007
R13973 VSS.n3421 VSS.n3420 0.0007
R13974 VSS.n1026 VSS.n389 0.0007
R13975 VSS.n1025 VSS.n945 0.0007
R13976 VSS.n1030 VSS.n1029 0.0007
R13977 VSS.n958 VSS.n947 0.0007
R13978 VSS.n965 VSS.n954 0.0007
R13979 VSS.n964 VSS.n957 0.0007
R13980 VSS.n2826 VSS.n913 0.0007
R13981 VSS.n2825 VSS.n915 0.0007
R13982 VSS.n2829 VSS.n909 0.0007
R13983 VSS.n2833 VSS.n2832 0.0007
R13984 VSS.n2837 VSS.n903 0.0007
R13985 VSS.n2836 VSS.n906 0.0007
R13986 VSS.n2509 VSS.n2505 0.0007
R13987 VSS.n2508 VSS.n1190 0.0007
R13988 VSS.n2513 VSS.n2512 0.0007
R13989 VSS.n2503 VSS.n1192 0.0007
R13990 VSS.n2500 VSS.n2499 0.0007
R13991 VSS.n2481 VSS.n2480 0.0007
R13992 VSS.n3866 VSS.n3865 0.00065
R13993 VSS.n3862 VSS.n107 0.00065
R13994 VSS.n3873 VSS.n3872 0.00065
R13995 VSS.n3874 VSS.n104 0.00065
R13996 VSS.n3880 VSS.n3879 0.00065
R13997 VSS.n3750 VSS.n3749 0.00065
R13998 VSS.n3747 VSS.n3746 0.00065
R13999 VSS.n3743 VSS.n3740 0.00065
R14000 VSS.n3755 VSS.n3754 0.00065
R14001 VSS.n3756 VSS.n154 0.00065
R14002 VSS.n3762 VSS.n3761 0.00065
R14003 VSS.n3738 VSS.n156 0.00065
R14004 VSS.n3730 VSS.n158 0.00065
R14005 VSS.n3735 VSS.n3734 0.00065
R14006 VSS.n3728 VSS.n161 0.00065
R14007 VSS.n3722 VSS.n163 0.00065
R14008 VSS.n3725 VSS.n3724 0.00065
R14009 VSS.n3718 VSS.n166 0.00065
R14010 VSS.n3710 VSS.n168 0.00065
R14011 VSS.n3715 VSS.n3714 0.00065
R14012 VSS.n3708 VSS.n171 0.00065
R14013 VSS.n3700 VSS.n173 0.00065
R14014 VSS.n3705 VSS.n3704 0.00065
R14015 VSS.n3640 VSS.n176 0.00065
R14016 VSS.n3632 VSS.n178 0.00065
R14017 VSS.n3637 VSS.n3636 0.00065
R14018 VSS.n3630 VSS.n181 0.00065
R14019 VSS.n3622 VSS.n183 0.00065
R14020 VSS.n3627 VSS.n3626 0.00065
R14021 VSS.n3620 VSS.n186 0.00065
R14022 VSS.n3612 VSS.n188 0.00065
R14023 VSS.n3617 VSS.n3616 0.00065
R14024 VSS.n3610 VSS.n191 0.00065
R14025 VSS.n3602 VSS.n193 0.00065
R14026 VSS.n3607 VSS.n3606 0.00065
R14027 VSS.n3600 VSS.n196 0.00065
R14028 VSS.n3592 VSS.n198 0.00065
R14029 VSS.n3597 VSS.n3596 0.00065
R14030 VSS.n2772 VSS.n2771 0.00065
R14031 VSS.n2769 VSS.n2765 0.00065
R14032 VSS.n2777 VSS.n2776 0.00065
R14033 VSS.n3437 VSS.n375 0.00065
R14034 VSS.n377 VSS.n376 0.00065
R14035 VSS.n1043 VSS.n380 0.00065
R14036 VSS.n3432 VSS.n381 0.00065
R14037 VSS.n3424 VSS.n383 0.00065
R14038 VSS.n3429 VSS.n3428 0.00065
R14039 VSS.n3422 VSS.n386 0.00065
R14040 VSS.n3414 VSS.n388 0.00065
R14041 VSS.n3419 VSS.n3418 0.00065
R14042 VSS.n1003 VSS.n1002 0.00065
R14043 VSS.n1007 VSS.n999 0.00065
R14044 VSS.n1010 VSS.n1009 0.00065
R14045 VSS.n2992 VSS.n831 0.00065
R14046 VSS.n833 VSS.n832 0.00065
R14047 VSS.n2985 VSS.n2984 0.00065
R14048 VSS.n2987 VSS.n2986 0.00065
R14049 VSS.n3052 VSS.n3051 0.00065
R14050 VSS.n540 VSS.n536 0.00065
R14051 VSS.n3046 VSS.n541 0.00065
R14052 VSS.n3040 VSS.n543 0.00065
R14053 VSS.n3043 VSS.n3042 0.00065
R14054 VSS.n678 VSS.n545 0.00065
R14055 VSS.n670 VSS.n547 0.00065
R14056 VSS.n675 VSS.n674 0.00065
R14057 VSS.n3348 VSS.n424 0.00065
R14058 VSS.n426 VSS.n425 0.00065
R14059 VSS.n637 VSS.n429 0.00065
R14060 VSS.n3343 VSS.n430 0.00065
R14061 VSS.n3335 VSS.n432 0.00065
R14062 VSS.n3340 VSS.n3339 0.00065
R14063 VSS.n113 VSS.n112 0.00065
R14064 VSS.n3855 VSS.n114 0.00065
R14065 VSS.n3887 VSS.n3886 0.00065
R14066 VSS.n3883 VSS.n3882 0.00065
R14067 VSS.n99 VSS.n96 0.00065
R14068 VSS.n3892 VSS.n3891 0.00065
R14069 VSS.n94 VSS.n90 0.00065
R14070 VSS.n3897 VSS.n3896 0.00065
R14071 VSS.n3768 VSS.n3767 0.00065
R14072 VSS.n3765 VSS.n150 0.00065
R14073 VSS.n3773 VSS.n3772 0.00065
R14074 VSS.n2687 VSS.n2686 0.00065
R14075 VSS.n2684 VSS.n2683 0.00065
R14076 VSS.n2680 VSS.n1093 0.00065
R14077 VSS.n2696 VSS.n2695 0.00065
R14078 VSS.n2693 VSS.n2692 0.00065
R14079 VSS.n1091 VSS.n1088 0.00065
R14080 VSS.n2705 VSS.n2704 0.00065
R14081 VSS.n2702 VSS.n2701 0.00065
R14082 VSS.n1086 VSS.n1083 0.00065
R14083 VSS.n2714 VSS.n2713 0.00065
R14084 VSS.n2711 VSS.n2710 0.00065
R14085 VSS.n1081 VSS.n1078 0.00065
R14086 VSS.n2723 VSS.n2722 0.00065
R14087 VSS.n2720 VSS.n2719 0.00065
R14088 VSS.n1076 VSS.n1073 0.00065
R14089 VSS.n2732 VSS.n2731 0.00065
R14090 VSS.n2729 VSS.n2728 0.00065
R14091 VSS.n1071 VSS.n1068 0.00065
R14092 VSS.n2741 VSS.n2740 0.00065
R14093 VSS.n2738 VSS.n2737 0.00065
R14094 VSS.n1066 VSS.n1063 0.00065
R14095 VSS.n2750 VSS.n2749 0.00065
R14096 VSS.n2747 VSS.n2746 0.00065
R14097 VSS.n1061 VSS.n1058 0.00065
R14098 VSS.n2759 VSS.n2758 0.00065
R14099 VSS.n2756 VSS.n2755 0.00065
R14100 VSS.n1056 VSS.n1053 0.00065
R14101 VSS.n2784 VSS.n2783 0.00065
R14102 VSS.n2780 VSS.n2779 0.00065
R14103 VSS.n1051 VSS.n1048 0.00065
R14104 VSS.n2789 VSS.n2788 0.00065
R14105 VSS.n1046 VSS.n938 0.00065
R14106 VSS.n2794 VSS.n2793 0.00065
R14107 VSS.n1041 VSS.n940 0.00065
R14108 VSS.n1033 VSS.n942 0.00065
R14109 VSS.n1038 VSS.n1037 0.00065
R14110 VSS.n1031 VSS.n944 0.00065
R14111 VSS.n1023 VSS.n946 0.00065
R14112 VSS.n1028 VSS.n1027 0.00065
R14113 VSS.n1021 VSS.n949 0.00065
R14114 VSS.n1013 VSS.n951 0.00065
R14115 VSS.n1018 VSS.n1017 0.00065
R14116 VSS.n2981 VSS.n837 0.00065
R14117 VSS.n839 VSS.n838 0.00065
R14118 VSS.n2976 VSS.n2975 0.00065
R14119 VSS.n3056 VSS.n534 0.00065
R14120 VSS.n3058 VSS.n533 0.00065
R14121 VSS.n3060 VSS.n530 0.00065
R14122 VSS.n3065 VSS.n3064 0.00065
R14123 VSS.n528 VSS.n524 0.00065
R14124 VSS.n3070 VSS.n3069 0.00065
R14125 VSS.n653 VSS.n549 0.00065
R14126 VSS.n551 VSS.n550 0.00065
R14127 VSS.n575 VSS.n554 0.00065
R14128 VSS.n648 VSS.n555 0.00065
R14129 VSS.n640 VSS.n557 0.00065
R14130 VSS.n645 VSS.n644 0.00065
R14131 VSS.n3201 VSS.n434 0.00065
R14132 VSS.n436 VSS.n435 0.00065
R14133 VSS.n3197 VSS.n3196 0.00065
R14134 VSS.n121 VSS.n120 0.00065
R14135 VSS.n3827 VSS.n3826 0.00065
R14136 VSS.n3913 VSS.n77 0.00065
R14137 VSS.n79 VSS.n78 0.00065
R14138 VSS.n3807 VSS.n82 0.00065
R14139 VSS.n3908 VSS.n83 0.00065
R14140 VSS.n3900 VSS.n85 0.00065
R14141 VSS.n3905 VSS.n3904 0.00065
R14142 VSS.n3779 VSS.n3778 0.00065
R14143 VSS.n3776 VSS.n146 0.00065
R14144 VSS.n3784 VSS.n3783 0.00065
R14145 VSS.n2678 VSS.n1097 0.00065
R14146 VSS.n1099 VSS.n1098 0.00065
R14147 VSS.n2336 VSS.n1102 0.00065
R14148 VSS.n2673 VSS.n1103 0.00065
R14149 VSS.n2665 VSS.n1105 0.00065
R14150 VSS.n2670 VSS.n2669 0.00065
R14151 VSS.n2662 VSS.n1108 0.00065
R14152 VSS.n2654 VSS.n1110 0.00065
R14153 VSS.n2659 VSS.n2658 0.00065
R14154 VSS.n2651 VSS.n1113 0.00065
R14155 VSS.n2643 VSS.n1115 0.00065
R14156 VSS.n2648 VSS.n2647 0.00065
R14157 VSS.n2614 VSS.n1133 0.00065
R14158 VSS.n1135 VSS.n1134 0.00065
R14159 VSS.n2375 VSS.n1138 0.00065
R14160 VSS.n2609 VSS.n1139 0.00065
R14161 VSS.n2601 VSS.n1141 0.00065
R14162 VSS.n2606 VSS.n2605 0.00065
R14163 VSS.n2598 VSS.n1144 0.00065
R14164 VSS.n2590 VSS.n1146 0.00065
R14165 VSS.n2595 VSS.n2594 0.00065
R14166 VSS.n2587 VSS.n1149 0.00065
R14167 VSS.n2579 VSS.n1151 0.00065
R14168 VSS.n2584 VSS.n2583 0.00065
R14169 VSS.n2576 VSS.n1154 0.00065
R14170 VSS.n2568 VSS.n1156 0.00065
R14171 VSS.n2573 VSS.n2572 0.00065
R14172 VSS.n2565 VSS.n1159 0.00065
R14173 VSS.n2557 VSS.n1161 0.00065
R14174 VSS.n2562 VSS.n2561 0.00065
R14175 VSS.n2801 VSS.n2800 0.00065
R14176 VSS.n2797 VSS.n2796 0.00065
R14177 VSS.n933 VSS.n930 0.00065
R14178 VSS.n2806 VSS.n2805 0.00065
R14179 VSS.n928 VSS.n924 0.00065
R14180 VSS.n2811 VSS.n2810 0.00065
R14181 VSS.n963 VSS.n962 0.00065
R14182 VSS.n960 VSS.n959 0.00065
R14183 VSS.n956 VSS.n953 0.00065
R14184 VSS.n994 VSS.n967 0.00065
R14185 VSS.n969 VSS.n968 0.00065
R14186 VSS.n989 VSS.n988 0.00065
R14187 VSS.n2972 VSS.n843 0.00065
R14188 VSS.n845 VSS.n844 0.00065
R14189 VSS.n2965 VSS.n2964 0.00065
R14190 VSS.n2967 VSS.n2966 0.00065
R14191 VSS.n3087 VSS.n3086 0.00065
R14192 VSS.n517 VSS.n513 0.00065
R14193 VSS.n3081 VSS.n518 0.00065
R14194 VSS.n3073 VSS.n520 0.00065
R14195 VSS.n3078 VSS.n3077 0.00065
R14196 VSS.n581 VSS.n580 0.00065
R14197 VSS.n578 VSS.n572 0.00065
R14198 VSS.n586 VSS.n585 0.00065
R14199 VSS.n633 VSS.n559 0.00065
R14200 VSS.n561 VSS.n560 0.00065
R14201 VSS.n628 VSS.n627 0.00065
R14202 VSS.n3193 VSS.n440 0.00065
R14203 VSS.n442 VSS.n441 0.00065
R14204 VSS.n3189 VSS.n3188 0.00065
R14205 VSS.n126 VSS.n125 0.00065
R14206 VSS.n1614 VSS.n128 0.00065
R14207 VSS.n3818 VSS.n129 0.00065
R14208 VSS.n3810 VSS.n131 0.00065
R14209 VSS.n3815 VSS.n3814 0.00065
R14210 VSS.n3805 VSS.n134 0.00065
R14211 VSS.n3797 VSS.n136 0.00065
R14212 VSS.n3802 VSS.n3801 0.00065
R14213 VSS.n3795 VSS.n139 0.00065
R14214 VSS.n3787 VSS.n141 0.00065
R14215 VSS.n3792 VSS.n3791 0.00065
R14216 VSS.n2343 VSS.n2342 0.00065
R14217 VSS.n2339 VSS.n2338 0.00065
R14218 VSS.n2333 VSS.n1278 0.00065
R14219 VSS.n2352 VSS.n2351 0.00065
R14220 VSS.n2349 VSS.n2348 0.00065
R14221 VSS.n1276 VSS.n1273 0.00065
R14222 VSS.n2361 VSS.n2360 0.00065
R14223 VSS.n2358 VSS.n2357 0.00065
R14224 VSS.n1271 VSS.n1268 0.00065
R14225 VSS.n2370 VSS.n2369 0.00065
R14226 VSS.n2367 VSS.n2366 0.00065
R14227 VSS.n1266 VSS.n1263 0.00065
R14228 VSS.n2382 VSS.n2381 0.00065
R14229 VSS.n2378 VSS.n2377 0.00065
R14230 VSS.n1261 VSS.n1258 0.00065
R14231 VSS.n2391 VSS.n2390 0.00065
R14232 VSS.n2388 VSS.n2387 0.00065
R14233 VSS.n1256 VSS.n1253 0.00065
R14234 VSS.n2400 VSS.n2399 0.00065
R14235 VSS.n2397 VSS.n2396 0.00065
R14236 VSS.n1251 VSS.n1248 0.00065
R14237 VSS.n2409 VSS.n2408 0.00065
R14238 VSS.n2406 VSS.n2405 0.00065
R14239 VSS.n1246 VSS.n1243 0.00065
R14240 VSS.n2414 VSS.n2413 0.00065
R14241 VSS.n1241 VSS.n1238 0.00065
R14242 VSS.n2419 VSS.n2418 0.00065
R14243 VSS.n2553 VSS.n1163 0.00065
R14244 VSS.n1165 VSS.n1164 0.00065
R14245 VSS.n1225 VSS.n1168 0.00065
R14246 VSS.n2548 VSS.n1169 0.00065
R14247 VSS.n2540 VSS.n1171 0.00065
R14248 VSS.n2545 VSS.n2544 0.00065
R14249 VSS.n2818 VSS.n2817 0.00065
R14250 VSS.n2814 VSS.n2813 0.00065
R14251 VSS.n919 VSS.n916 0.00065
R14252 VSS.n2823 VSS.n2822 0.00065
R14253 VSS.n914 VSS.n910 0.00065
R14254 VSS.n2828 VSS.n2827 0.00065
R14255 VSS.n985 VSS.n973 0.00065
R14256 VSS.n975 VSS.n974 0.00065
R14257 VSS.n980 VSS.n979 0.00065
R14258 VSS.n2961 VSS.n849 0.00065
R14259 VSS.n851 VSS.n850 0.00065
R14260 VSS.n2956 VSS.n2955 0.00065
R14261 VSS.n3091 VSS.n511 0.00065
R14262 VSS.n3093 VSS.n509 0.00065
R14263 VSS.n3095 VSS.n506 0.00065
R14264 VSS.n3100 VSS.n3099 0.00065
R14265 VSS.n504 VSS.n500 0.00065
R14266 VSS.n3105 VSS.n3104 0.00065
R14267 VSS.n593 VSS.n592 0.00065
R14268 VSS.n589 VSS.n588 0.00065
R14269 VSS.n568 VSS.n565 0.00065
R14270 VSS.n624 VSS.n597 0.00065
R14271 VSS.n599 VSS.n598 0.00065
R14272 VSS.n619 VSS.n618 0.00065
R14273 VSS.n3185 VSS.n446 0.00065
R14274 VSS.n448 VSS.n447 0.00065
R14275 VSS.n3181 VSS.n3180 0.00065
R14276 VSS.n1617 VSS.n1616 0.00065
R14277 VSS.n1611 VSS.n1417 0.00065
R14278 VSS.n1629 VSS.n1628 0.00065
R14279 VSS.n1626 VSS.n1625 0.00065
R14280 VSS.n1415 VSS.n1412 0.00065
R14281 VSS.n1638 VSS.n1637 0.00065
R14282 VSS.n1635 VSS.n1634 0.00065
R14283 VSS.n1410 VSS.n1407 0.00065
R14284 VSS.n1643 VSS.n1642 0.00065
R14285 VSS.n1405 VSS.n1402 0.00065
R14286 VSS.n1648 VSS.n1647 0.00065
R14287 VSS.n2331 VSS.n1282 0.00065
R14288 VSS.n1284 VSS.n1283 0.00065
R14289 VSS.n1660 VSS.n1287 0.00065
R14290 VSS.n2326 VSS.n1288 0.00065
R14291 VSS.n2318 VSS.n1290 0.00065
R14292 VSS.n2323 VSS.n2322 0.00065
R14293 VSS.n2315 VSS.n1293 0.00065
R14294 VSS.n2307 VSS.n1295 0.00065
R14295 VSS.n2312 VSS.n2311 0.00065
R14296 VSS.n2304 VSS.n1298 0.00065
R14297 VSS.n2296 VSS.n1300 0.00065
R14298 VSS.n2301 VSS.n2300 0.00065
R14299 VSS.n2293 VSS.n1303 0.00065
R14300 VSS.n2285 VSS.n1305 0.00065
R14301 VSS.n2290 VSS.n2289 0.00065
R14302 VSS.n2282 VSS.n1308 0.00065
R14303 VSS.n2274 VSS.n1310 0.00065
R14304 VSS.n2279 VSS.n2278 0.00065
R14305 VSS.n2258 VSS.n1323 0.00065
R14306 VSS.n1325 VSS.n1324 0.00065
R14307 VSS.n1359 VSS.n1328 0.00065
R14308 VSS.n2253 VSS.n1329 0.00065
R14309 VSS.n2245 VSS.n1331 0.00065
R14310 VSS.n2250 VSS.n2249 0.00065
R14311 VSS.n2426 VSS.n2425 0.00065
R14312 VSS.n2422 VSS.n2421 0.00065
R14313 VSS.n1233 VSS.n1230 0.00065
R14314 VSS.n2431 VSS.n2430 0.00065
R14315 VSS.n1228 VSS.n1222 0.00065
R14316 VSS.n2436 VSS.n2435 0.00065
R14317 VSS.n2536 VSS.n1173 0.00065
R14318 VSS.n1175 VSS.n1174 0.00065
R14319 VSS.n1209 VSS.n1178 0.00065
R14320 VSS.n2531 VSS.n1179 0.00065
R14321 VSS.n2523 VSS.n1181 0.00065
R14322 VSS.n2528 VSS.n2527 0.00065
R14323 VSS.n2835 VSS.n2834 0.00065
R14324 VSS.n2831 VSS.n2830 0.00065
R14325 VSS.n905 VSS.n902 0.00065
R14326 VSS.n2840 VSS.n2839 0.00065
R14327 VSS.n900 VSS.n896 0.00065
R14328 VSS.n2845 VSS.n2844 0.00065
R14329 VSS.n2952 VSS.n855 0.00065
R14330 VSS.n857 VSS.n856 0.00065
R14331 VSS.n883 VSS.n860 0.00065
R14332 VSS.n2947 VSS.n861 0.00065
R14333 VSS.n2944 VSS.n2943 0.00065
R14334 VSS.n2940 VSS.n863 0.00065
R14335 VSS.n3112 VSS.n3111 0.00065
R14336 VSS.n3108 VSS.n3107 0.00065
R14337 VSS.n495 VSS.n492 0.00065
R14338 VSS.n3117 VSS.n3116 0.00065
R14339 VSS.n490 VSS.n486 0.00065
R14340 VSS.n3122 VSS.n3121 0.00065
R14341 VSS.n615 VSS.n603 0.00065
R14342 VSS.n605 VSS.n604 0.00065
R14343 VSS.n610 VSS.n609 0.00065
R14344 VSS.n3177 VSS.n452 0.00065
R14345 VSS.n454 VSS.n453 0.00065
R14346 VSS.n3173 VSS.n3172 0.00065
R14347 VSS.n1423 VSS.n1422 0.00065
R14348 VSS.n1446 VSS.n1425 0.00065
R14349 VSS.n1604 VSS.n1426 0.00065
R14350 VSS.n1596 VSS.n1428 0.00065
R14351 VSS.n1601 VSS.n1600 0.00065
R14352 VSS.n1593 VSS.n1431 0.00065
R14353 VSS.n1585 VSS.n1433 0.00065
R14354 VSS.n1590 VSS.n1589 0.00065
R14355 VSS.n1655 VSS.n1654 0.00065
R14356 VSS.n1651 VSS.n1650 0.00065
R14357 VSS.n1397 VSS.n1394 0.00065
R14358 VSS.n1667 VSS.n1666 0.00065
R14359 VSS.n1663 VSS.n1662 0.00065
R14360 VSS.n1392 VSS.n1389 0.00065
R14361 VSS.n1676 VSS.n1675 0.00065
R14362 VSS.n1673 VSS.n1672 0.00065
R14363 VSS.n1387 VSS.n1384 0.00065
R14364 VSS.n1685 VSS.n1684 0.00065
R14365 VSS.n1682 VSS.n1681 0.00065
R14366 VSS.n1382 VSS.n1379 0.00065
R14367 VSS.n1694 VSS.n1693 0.00065
R14368 VSS.n1691 VSS.n1690 0.00065
R14369 VSS.n1377 VSS.n1374 0.00065
R14370 VSS.n1703 VSS.n1702 0.00065
R14371 VSS.n1700 VSS.n1699 0.00065
R14372 VSS.n1372 VSS.n1369 0.00065
R14373 VSS.n1712 VSS.n1711 0.00065
R14374 VSS.n1709 VSS.n1708 0.00065
R14375 VSS.n1367 VSS.n1364 0.00065
R14376 VSS.n1717 VSS.n1716 0.00065
R14377 VSS.n1362 VSS.n1356 0.00065
R14378 VSS.n1722 VSS.n1721 0.00065
R14379 VSS.n1788 VSS.n1333 0.00065
R14380 VSS.n1335 VSS.n1334 0.00065
R14381 VSS.n1734 VSS.n1338 0.00065
R14382 VSS.n1783 VSS.n1339 0.00065
R14383 VSS.n1775 VSS.n1341 0.00065
R14384 VSS.n1780 VSS.n1779 0.00065
R14385 VSS.n2443 VSS.n2442 0.00065
R14386 VSS.n2439 VSS.n2438 0.00065
R14387 VSS.n1217 VSS.n1214 0.00065
R14388 VSS.n2448 VSS.n2447 0.00065
R14389 VSS.n1212 VSS.n1206 0.00065
R14390 VSS.n2453 VSS.n2452 0.00065
R14391 VSS.n2519 VSS.n1183 0.00065
R14392 VSS.n1185 VSS.n1184 0.00065
R14393 VSS.n2465 VSS.n1188 0.00065
R14394 VSS.n2514 VSS.n1189 0.00065
R14395 VSS.n2506 VSS.n1191 0.00065
R14396 VSS.n2511 VSS.n2510 0.00065
R14397 VSS.n2852 VSS.n2851 0.00065
R14398 VSS.n2848 VSS.n2847 0.00065
R14399 VSS.n891 VSS.n888 0.00065
R14400 VSS.n2857 VSS.n2856 0.00065
R14401 VSS.n886 VSS.n880 0.00065
R14402 VSS.n2862 VSS.n2861 0.00065
R14403 VSS.n2936 VSS.n865 0.00065
R14404 VSS.n869 VSS.n866 0.00065
R14405 VSS.n2931 VSS.n870 0.00065
R14406 VSS.n2901 VSS.n2900 0.00065
R14407 VSS.n2898 VSS.n2895 0.00065
R14408 VSS.n2906 VSS.n2905 0.00065
R14409 VSS.n3129 VSS.n3128 0.00065
R14410 VSS.n3125 VSS.n3124 0.00065
R14411 VSS.n481 VSS.n478 0.00065
R14412 VSS.n3134 VSS.n3133 0.00065
R14413 VSS.n476 VSS.n472 0.00065
R14414 VSS.n3139 VSS.n3138 0.00065
R14415 VSS.n3169 VSS.n458 0.00065
R14416 VSS.n460 VSS.n459 0.00065
R14417 VSS.n3165 VSS.n3164 0.00065
R14418 VSS.n1449 VSS.n1448 0.00065
R14419 VSS.n1443 VSS.n1440 0.00065
R14420 VSS.n1461 VSS.n1460 0.00065
R14421 VSS.n1458 VSS.n1457 0.00065
R14422 VSS.n1438 VSS.n1435 0.00065
R14423 VSS.n1581 VSS.n1465 0.00065
R14424 VSS.n1467 VSS.n1466 0.00065
R14425 VSS.n1472 VSS.n1471 0.00065
R14426 VSS.n1576 VSS.n1473 0.00065
R14427 VSS.n1568 VSS.n1475 0.00065
R14428 VSS.n1573 VSS.n1572 0.00065
R14429 VSS.n1565 VSS.n1477 0.00065
R14430 VSS.n1557 VSS.n1479 0.00065
R14431 VSS.n1562 VSS.n1561 0.00065
R14432 VSS.n1554 VSS.n1481 0.00065
R14433 VSS.n1546 VSS.n1483 0.00065
R14434 VSS.n1551 VSS.n1550 0.00065
R14435 VSS.n1543 VSS.n1485 0.00065
R14436 VSS.n1535 VSS.n1487 0.00065
R14437 VSS.n1540 VSS.n1539 0.00065
R14438 VSS.n1532 VSS.n1489 0.00065
R14439 VSS.n1524 VSS.n1491 0.00065
R14440 VSS.n1529 VSS.n1528 0.00065
R14441 VSS.n1521 VSS.n1493 0.00065
R14442 VSS.n1513 VSS.n1495 0.00065
R14443 VSS.n1518 VSS.n1517 0.00065
R14444 VSS.n1510 VSS.n1497 0.00065
R14445 VSS.n1502 VSS.n1499 0.00065
R14446 VSS.n1507 VSS.n1506 0.00065
R14447 VSS.n1729 VSS.n1728 0.00065
R14448 VSS.n1725 VSS.n1724 0.00065
R14449 VSS.n1351 VSS.n1348 0.00065
R14450 VSS.n1741 VSS.n1740 0.00065
R14451 VSS.n1737 VSS.n1736 0.00065
R14452 VSS.n1346 VSS.n1343 0.00065
R14453 VSS.n1771 VSS.n1745 0.00065
R14454 VSS.n1747 VSS.n1746 0.00065
R14455 VSS.n1752 VSS.n1751 0.00065
R14456 VSS.n1766 VSS.n1753 0.00065
R14457 VSS.n1758 VSS.n1755 0.00065
R14458 VSS.n1763 VSS.n1762 0.00065
R14459 VSS.n2460 VSS.n2459 0.00065
R14460 VSS.n2456 VSS.n2455 0.00065
R14461 VSS.n1201 VSS.n1198 0.00065
R14462 VSS.n2472 VSS.n2471 0.00065
R14463 VSS.n2468 VSS.n2467 0.00065
R14464 VSS.n1196 VSS.n1193 0.00065
R14465 VSS.n2502 VSS.n2476 0.00065
R14466 VSS.n2478 VSS.n2477 0.00065
R14467 VSS.n2483 VSS.n2482 0.00065
R14468 VSS.n2497 VSS.n2484 0.00065
R14469 VSS.n2489 VSS.n2486 0.00065
R14470 VSS.n2494 VSS.n2493 0.00065
R14471 VSS.n2869 VSS.n2868 0.00065
R14472 VSS.n2865 VSS.n2864 0.00065
R14473 VSS.n875 VSS.n872 0.00065
R14474 VSS.n2928 VSS.n2873 0.00065
R14475 VSS.n2920 VSS.n2874 0.00065
R14476 VSS.n2923 VSS.n2921 0.00065
R14477 VSS.n2917 VSS.n2875 0.00065
R14478 VSS.n2909 VSS.n2877 0.00065
R14479 VSS.n2914 VSS.n2913 0.00065
R14480 VSS.n2892 VSS.n2879 0.00065
R14481 VSS.n2884 VSS.n2881 0.00065
R14482 VSS.n2889 VSS.n2888 0.00065
R14483 VSS.n3146 VSS.n3145 0.00065
R14484 VSS.n3142 VSS.n3141 0.00065
R14485 VSS.n467 VSS.n464 0.00065
R14486 VSS.n3161 VSS.n3150 0.00065
R14487 VSS.n3152 VSS.n3151 0.00065
R14488 VSS.n3157 VSS.n3156 0.00065
R14489 VSS.n664 VSS.n663 0.0006
R14490 VSS.n668 VSS.n657 0.0006
R14491 VSS.n3016 VSS.n3008 0.0006
R14492 VSS.n3014 VSS.n3013 0.0006
R14493 VSS.n3002 VSS.n3001 0.0006
R14494 VSS.n2995 VSS.n2994 0.0006
R14495 VSS.n3352 VSS.n420 0.0006
R14496 VSS.n3351 VSS.n3350 0.0006
R14497 VSS.n3219 VSS.n3218 0.0006
R14498 VSS.n3333 VSS.n3204 0.0006
R14499 VSS.n2116 VSS.n2115 0.0006
R14500 VSS.n2243 VSS.n1791 0.0006
R14501 VSS.n2203 VSS.n2202 0.0006
R14502 VSS.n2272 VSS.n1314 0.0006
R14503 VSS.n2266 VSS.n1320 0.0006
R14504 VSS.n2264 VSS.n2263 0.0006
R14505 VSS.n2621 VSS.n2620 0.0006
R14506 VSS.n2617 VSS.n2616 0.0006
R14507 VSS.n3676 VSS.n3671 0.0006
R14508 VSS.n3670 VSS.n3669 0.0006
R14509 VSS.n3668 VSS.n3664 0.0006
R14510 VSS.n3684 VSS.n3658 0.0006
R14511 VSS.n3690 VSS.n3685 0.0006
R14512 VSS.n3657 VSS.n3656 0.0006
R14513 VSS.n3655 VSS.n3651 0.0006
R14514 VSS.n3698 VSS.n3642 0.0006
R14515 VSS.n2638 VSS.n2637 0.0006
R14516 VSS.n2641 VSS.n1119 0.0006
R14517 VSS.n3472 VSS.n276 0.0006
R14518 VSS.n3471 VSS.n3470 0.0006
R14519 VSS.n3469 VSS.n280 0.0006
R14520 VSS.n3467 VSS.n282 0.0006
R14521 VSS.n3511 VSS.n3510 0.0006
R14522 VSS.n3524 VSS.n246 0.0006
R14523 VSS.n3526 VSS.n3525 0.0006
R14524 VSS.n3590 VSS.n202 0.0006
R14525 VSS.n3032 VSS.n682 0.0006
R14526 VSS.n3036 VSS.n680 0.0006
R14527 VSS.n3853 VSS.n116 0.0006
R14528 VSS.n3851 VSS.n3834 0.0006
R14529 VSS.n3917 VSS.n74 0.0006
R14530 VSS.n3916 VSS.n3915 0.0006
R14531 VSS.n341 VSS.n333 0.0006
R14532 VSS.n345 VSS.n331 0.0006
R14533 VSS.n3443 VSS.n3442 0.0006
R14534 VSS.n3439 VSS.n347 0.0006
R14535 VSS.n3573 VSS.n3572 0.0006
R14536 VSS.n3569 VSS.n216 0.0006
R14537 VSS.n3568 VSS.n220 0.0006
R14538 VSS.n3565 VSS.n3564 0.0006
R14539 VSS.n820 VSS.n819 0.0006
R14540 VSS.n3401 VSS.n394 0.0006
R14541 VSS.n3408 VSS.n3402 0.0006
R14542 VSS.n3412 VSS.n392 0.0006
R14543 programmable_folded_cascode_0.EN1.n23 programmable_folded_cascode_0.EN1.n22 57.1848
R14544 programmable_folded_cascode_0.EN1.n24 programmable_folded_cascode_0.EN1.n23 49.2613
R14545 programmable_folded_cascode_0.EN1.n25 programmable_folded_cascode_0.EN1.n24 34.6161
R14546 programmable_folded_cascode_0.EN1 programmable_folded_cascode_0.EN1.t10 30.2794
R14547 programmable_folded_cascode_0.EN1 programmable_folded_cascode_0.EN1.t22 30.2794
R14548 programmable_folded_cascode_0.EN1 programmable_folded_cascode_0.EN1.t5 30.2794
R14549 programmable_folded_cascode_0.EN1 programmable_folded_cascode_0.EN1.t17 30.2794
R14550 programmable_folded_cascode_0.EN1 programmable_folded_cascode_0.EN1.t9 30.2794
R14551 programmable_folded_cascode_0.EN1 programmable_folded_cascode_0.EN1.t13 30.2794
R14552 programmable_folded_cascode_0.EN1 programmable_folded_cascode_0.EN1.t15 30.2794
R14553 programmable_folded_cascode_0.EN1 programmable_folded_cascode_0.EN1.t4 25.0275
R14554 programmable_folded_cascode_0.EN1.n0 programmable_folded_cascode_0.EN1.t19 24.9469
R14555 programmable_folded_cascode_0.EN1.n3 programmable_folded_cascode_0.EN1.t7 24.9469
R14556 programmable_folded_cascode_0.EN1.n14 programmable_folded_cascode_0.EN1.t3 24.9469
R14557 programmable_folded_cascode_0.EN1.n15 programmable_folded_cascode_0.EN1.t21 24.9469
R14558 programmable_folded_cascode_0.EN1.n10 programmable_folded_cascode_0.EN1.t16 24.9469
R14559 programmable_folded_cascode_0.EN1.n11 programmable_folded_cascode_0.EN1.t14 24.9469
R14560 programmable_folded_cascode_0.EN1.n6 programmable_folded_cascode_0.EN1.t8 24.9469
R14561 programmable_folded_cascode_0.EN1.n7 programmable_folded_cascode_0.EN1.t6 24.9469
R14562 programmable_folded_cascode_0.EN1.n4 programmable_folded_cascode_0.EN1.t20 24.9469
R14563 programmable_folded_cascode_0.EN1.n18 programmable_folded_cascode_0.EN1.t18 24.9469
R14564 programmable_folded_cascode_0.EN1.n19 programmable_folded_cascode_0.EN1.t11 24.9469
R14565 programmable_folded_cascode_0.EN1.n22 programmable_folded_cascode_0.EN1.t12 24.9469
R14566 programmable_folded_cascode_0.EN1 programmable_folded_cascode_0.EN1.t0 17.2081
R14567 programmable_folded_cascode_0.EN1.n2 programmable_folded_cascode_0.EN1.t2 17.1605
R14568 programmable_folded_cascode_0.EN1.n1 programmable_folded_cascode_0.EN1.t1 16.7833
R14569 programmable_folded_cascode_0.EN1 programmable_folded_cascode_0.EN1.n0 15.6278
R14570 programmable_folded_cascode_0.EN1.n24 programmable_folded_cascode_0.EN1.n3 11.8604
R14571 programmable_folded_cascode_0.EN1.n5 programmable_folded_cascode_0.EN1 5.55326
R14572 programmable_folded_cascode_0.EN1.n14 programmable_folded_cascode_0.EN1 4.93747
R14573 programmable_folded_cascode_0.EN1.n15 programmable_folded_cascode_0.EN1 4.93747
R14574 programmable_folded_cascode_0.EN1.n10 programmable_folded_cascode_0.EN1 4.93747
R14575 programmable_folded_cascode_0.EN1.n11 programmable_folded_cascode_0.EN1 4.93747
R14576 programmable_folded_cascode_0.EN1.n6 programmable_folded_cascode_0.EN1 4.93747
R14577 programmable_folded_cascode_0.EN1.n7 programmable_folded_cascode_0.EN1 4.93747
R14578 programmable_folded_cascode_0.EN1.n4 programmable_folded_cascode_0.EN1 4.93747
R14579 programmable_folded_cascode_0.EN1.n21 programmable_folded_cascode_0.EN1.n20 4.5005
R14580 programmable_folded_cascode_0.EN1.n9 programmable_folded_cascode_0.EN1.n8 4.5005
R14581 programmable_folded_cascode_0.EN1.n13 programmable_folded_cascode_0.EN1.n12 4.5005
R14582 programmable_folded_cascode_0.EN1.n17 programmable_folded_cascode_0.EN1.n16 4.5005
R14583 programmable_folded_cascode_0.EN1.n23 programmable_folded_cascode_0.EN1.n21 3.87642
R14584 programmable_folded_cascode_0.EN1.n21 programmable_folded_cascode_0.EN1.n17 3.58629
R14585 programmable_folded_cascode_0.EN1.n9 programmable_folded_cascode_0.EN1.n5 3.19787
R14586 programmable_folded_cascode_0.EN1.n13 programmable_folded_cascode_0.EN1.n9 3.13866
R14587 programmable_folded_cascode_0.EN1.n17 programmable_folded_cascode_0.EN1.n13 3.10195
R14588 programmable_folded_cascode_0.EN1.n20 programmable_folded_cascode_0.EN1 2.62708
R14589 programmable_folded_cascode_0.EN1.n8 programmable_folded_cascode_0.EN1 2.58011
R14590 programmable_folded_cascode_0.EN1.n12 programmable_folded_cascode_0.EN1 2.5766
R14591 programmable_folded_cascode_0.EN1.n16 programmable_folded_cascode_0.EN1 2.57427
R14592 programmable_folded_cascode_0.EN1.n5 programmable_folded_cascode_0.EN1 1.46537
R14593 programmable_folded_cascode_0.EN1.n20 programmable_folded_cascode_0.EN1 1.04024
R14594 programmable_folded_cascode_0.EN1.n16 programmable_folded_cascode_0.EN1 1.03842
R14595 programmable_folded_cascode_0.EN1.n12 programmable_folded_cascode_0.EN1 1.03608
R14596 programmable_folded_cascode_0.EN1.n8 programmable_folded_cascode_0.EN1 1.03258
R14597 programmable_folded_cascode_0.EN1.n2 programmable_folded_cascode_0.EN1.n1 0.386214
R14598 programmable_folded_cascode_0.EN1 programmable_folded_cascode_0.EN1.n2 0.164429
R14599 programmable_folded_cascode_0.EN1.n1 programmable_folded_cascode_0.EN1 0.140321
R14600 programmable_folded_cascode_0.EN1.n25 programmable_folded_cascode_0.EN1 0.106571
R14601 programmable_folded_cascode_0.EN1 programmable_folded_cascode_0.EN1.n25 0.0840714
R14602 programmable_folded_cascode_0.EN1.n0 programmable_folded_cascode_0.EN1 0.0721524
R14603 programmable_folded_cascode_0.EN1.n3 programmable_folded_cascode_0.EN1 0.00642105
R14604 programmable_folded_cascode_0.EN1.n18 programmable_folded_cascode_0.EN1 0.00642105
R14605 programmable_folded_cascode_0.EN1.n19 programmable_folded_cascode_0.EN1 0.00642105
R14606 programmable_folded_cascode_0.EN1.n22 programmable_folded_cascode_0.EN1 0.00642105
R14607 programmable_folded_cascode_0.EN1.n3 programmable_folded_cascode_0.EN1 0.00168421
R14608 programmable_folded_cascode_0.EN1 programmable_folded_cascode_0.EN1.n4 0.00168421
R14609 programmable_folded_cascode_0.EN1 programmable_folded_cascode_0.EN1.n18 0.00168421
R14610 programmable_folded_cascode_0.EN1 programmable_folded_cascode_0.EN1.n19 0.00168421
R14611 programmable_folded_cascode_0.EN1.n22 programmable_folded_cascode_0.EN1 0.00168421
R14612 programmable_folded_cascode_0.EN1 programmable_folded_cascode_0.EN1.n14 0.00166883
R14613 programmable_folded_cascode_0.EN1 programmable_folded_cascode_0.EN1.n15 0.00166883
R14614 programmable_folded_cascode_0.EN1 programmable_folded_cascode_0.EN1.n10 0.00166883
R14615 programmable_folded_cascode_0.EN1 programmable_folded_cascode_0.EN1.n11 0.00166883
R14616 programmable_folded_cascode_0.EN1 programmable_folded_cascode_0.EN1.n6 0.00166883
R14617 programmable_folded_cascode_0.EN1 programmable_folded_cascode_0.EN1.n7 0.00166883
R14618 INN_FOLDED.t4 INN_FOLDED.n3 234.008
R14619 INN_FOLDED.n4 INN_FOLDED.t5 225.917
R14620 INN_FOLDED.n4 INN_FOLDED.t4 225.639
R14621 INN_FOLDED.n16 INN_FOLDED.n15 21.9315
R14622 INN_FOLDED INN_FOLDED.t3 12.5271
R14623 INN_FOLDED INN_FOLDED.t2 12.5271
R14624 INN_FOLDED.n0 INN_FOLDED.t1 12.2345
R14625 INN_FOLDED.n1 INN_FOLDED.t0 12.2279
R14626 INN_FOLDED.n5 INN_FOLDED.n4 8.0005
R14627 INN_FOLDED.n16 INN_FOLDED.n5 7.52316
R14628 INN_FOLDED.n5 INN_FOLDED.n3 7.32516
R14629 INN_FOLDED.n3 INN_FOLDED.n2 5.38813
R14630 INN_FOLDED.n2 INN_FOLDED.n1 4.71086
R14631 INN_FOLDED INN_FOLDED.n0 4.68917
R14632 INN_FOLDED.n15 INN_FOLDED.n14 4.50104
R14633 INN_FOLDED.n12 INN_FOLDED.n9 4.50075
R14634 INN_FOLDED.n10 INN_FOLDED.n8 4.5005
R14635 INN_FOLDED.n12 INN_FOLDED.n11 4.5005
R14636 INN_FOLDED.n7 INN_FOLDED.n6 4.5005
R14637 INN_FOLDED.n14 INN_FOLDED.n13 4.5005
R14638 INN_FOLDED.n9 INN_FOLDED 0.0868855
R14639 INN_FOLDED INN_FOLDED.n16 0.078556
R14640 INN_FOLDED.n13 INN_FOLDED.n8 0.0551961
R14641 INN_FOLDED.n1 INN_FOLDED 0.0221867
R14642 INN_FOLDED.n14 INN_FOLDED.n7 0.0211024
R14643 INN_FOLDED.n11 INN_FOLDED.n10 0.0203795
R14644 INN_FOLDED.n0 INN_FOLDED 0.0156807
R14645 INN_FOLDED.n2 INN_FOLDED 0.0113434
R14646 INN_FOLDED.n10 INN_FOLDED.n9 0.00104217
R14647 INN_FOLDED.n11 INN_FOLDED.n7 0.00104217
R14648 INN_FOLDED.n15 INN_FOLDED.n6 0.000748619
R14649 INN_FOLDED.n8 INN_FOLDED.n6 0.000748619
R14650 INN_FOLDED.n13 INN_FOLDED.n12 0.000748619
R14651 programmable_common_source_0.EN0.n7 programmable_common_source_0.EN0.n5 70.5258
R14652 programmable_common_source_0.EN0 programmable_common_source_0.EN0.t13 30.7152
R14653 programmable_common_source_0.EN0 programmable_common_source_0.EN0.t8 30.4906
R14654 programmable_common_source_0.EN0 programmable_common_source_0.EN0.t12 25.0251
R14655 programmable_common_source_0.EN0 programmable_common_source_0.EN0.t7 25.0251
R14656 programmable_common_source_0.EN0.n1 programmable_common_source_0.EN0.t10 25.0227
R14657 programmable_common_source_0.EN0.n6 programmable_common_source_0.EN0.t5 24.9469
R14658 programmable_common_source_0.EN0.n3 programmable_common_source_0.EN0.t11 24.9469
R14659 programmable_common_source_0.EN0.n2 programmable_common_source_0.EN0.t6 24.9469
R14660 programmable_common_source_0.EN0.n8 programmable_common_source_0.EN0.t9 24.9469
R14661 programmable_common_source_0.EN0.n11 programmable_common_source_0.EN0.t3 17.5462
R14662 programmable_common_source_0.EN0.n12 programmable_common_source_0.EN0.t0 16.7838
R14663 programmable_common_source_0.EN0.n11 programmable_common_source_0.EN0.t4 16.7833
R14664 programmable_common_source_0.EN0 programmable_common_source_0.EN0.t2 12.5567
R14665 programmable_common_source_0.EN0.n0 programmable_common_source_0.EN0.t1 12.0263
R14666 programmable_common_source_0.EN0.n7 programmable_common_source_0.EN0 10.455
R14667 programmable_common_source_0.EN0.n5 programmable_common_source_0.EN0.n4 7.85368
R14668 programmable_common_source_0.EN0 programmable_common_source_0.EN0.n6 6.06552
R14669 programmable_common_source_0.EN0 programmable_common_source_0.EN0.n10 5.58854
R14670 programmable_common_source_0.EN0.n9 programmable_common_source_0.EN0.n8 5.3648
R14671 programmable_common_source_0.EN0 programmable_common_source_0.EN0.n1 5.12246
R14672 programmable_common_source_0.EN0.n4 programmable_common_source_0.EN0 4.90313
R14673 programmable_common_source_0.EN0.n10 programmable_common_source_0.EN0.n9 4.5005
R14674 programmable_common_source_0.EN0.n10 programmable_common_source_0.EN0.n0 1.24764
R14675 programmable_common_source_0.EN0 programmable_common_source_0.EN0.n12 0.947107
R14676 programmable_common_source_0.EN0.n12 programmable_common_source_0.EN0 0.424786
R14677 programmable_common_source_0.EN0.n0 programmable_common_source_0.EN0 0.2411
R14678 programmable_common_source_0.EN0 programmable_common_source_0.EN0.n7 0.159607
R14679 programmable_common_source_0.EN0 programmable_common_source_0.EN0.n11 0.140321
R14680 programmable_common_source_0.EN0.n6 programmable_common_source_0.EN0 0.0751053
R14681 programmable_common_source_0.EN0.n8 programmable_common_source_0.EN0 0.0751053
R14682 programmable_common_source_0.EN0.n5 programmable_common_source_0.EN0 0.0390714
R14683 programmable_common_source_0.EN0.n1 programmable_common_source_0.EN0 0.00878947
R14684 programmable_common_source_0.EN0.n9 programmable_common_source_0.EN0 0.00853571
R14685 programmable_common_source_0.EN0.n3 programmable_common_source_0.EN0 0.00760526
R14686 programmable_common_source_0.EN0.n2 programmable_common_source_0.EN0 0.00760526
R14687 programmable_common_source_0.EN0 programmable_common_source_0.EN0.n2 0.00405263
R14688 programmable_common_source_0.EN0.n7 programmable_common_source_0.EN0 0.00371429
R14689 programmable_common_source_0.EN0.n4 programmable_common_source_0.EN0.n3 0.00286842
R14690 programmable_5tOTA_0.programmable_pfet$4_0.g.t16 programmable_5tOTA_0.programmable_pfet$4_0.g.t18 750.149
R14691 programmable_5tOTA_0.programmable_pfet$4_0.g.t30 programmable_5tOTA_0.programmable_pfet$4_0.g.t31 750.149
R14692 programmable_5tOTA_0.programmable_pfet$4_0.g.n25 programmable_5tOTA_0.programmable_pfet$4_0.g.t16 381.329
R14693 programmable_5tOTA_0.programmable_pfet$4_0.g.n4 programmable_5tOTA_0.programmable_pfet$4_0.g.t30 381.329
R14694 programmable_5tOTA_0.programmable_pfet$4_0.g.n10 programmable_5tOTA_0.programmable_pfet$4_0.g.n8 31.4277
R14695 programmable_5tOTA_0.programmable_pfet$4_0.g.n15 programmable_5tOTA_0.programmable_pfet$4_0.g.n13 22.4134
R14696 programmable_5tOTA_0.programmable_pfet$4_0.g.n16 programmable_5tOTA_0.programmable_pfet$4_0.g.n15 21.9346
R14697 programmable_5tOTA_0.programmable_pfet$4_0.g.n24 programmable_5tOTA_0.programmable_pfet$4_0.g.n23 15.8405
R14698 programmable_5tOTA_0.programmable_pfet$4_0.g.n1 programmable_5tOTA_0.programmable_pfet$4_0.g.t21 12.487
R14699 programmable_5tOTA_0.programmable_pfet$4_0.g.n0 programmable_5tOTA_0.programmable_pfet$4_0.g.t20 12.487
R14700 programmable_5tOTA_0.programmable_pfet$4_0.g.n2 programmable_5tOTA_0.programmable_pfet$4_0.g.t26 12.4859
R14701 programmable_5tOTA_0.programmable_pfet$4_0.g.n27 programmable_5tOTA_0.programmable_pfet$4_0.g.t25 12.4859
R14702 programmable_5tOTA_0.programmable_pfet$4_0.g.n6 programmable_5tOTA_0.programmable_pfet$4_0.g.t19 12.2773
R14703 programmable_5tOTA_0.programmable_pfet$4_0.g.n5 programmable_5tOTA_0.programmable_pfet$4_0.g.t11 12.2773
R14704 programmable_5tOTA_0.programmable_pfet$4_0.g programmable_5tOTA_0.programmable_pfet$4_0.g.t28 12.2496
R14705 programmable_5tOTA_0.programmable_pfet$4_0.g programmable_5tOTA_0.programmable_pfet$4_0.g.t27 12.2496
R14706 programmable_5tOTA_0.programmable_pfet$4_0.g programmable_5tOTA_0.programmable_pfet$4_0.g.t29 12.2496
R14707 programmable_5tOTA_0.programmable_pfet$4_0.g programmable_5tOTA_0.programmable_pfet$4_0.g.t6 12.2496
R14708 programmable_5tOTA_0.programmable_pfet$4_0.g.n7 programmable_5tOTA_0.programmable_pfet$4_0.g.n5 8.66142
R14709 programmable_5tOTA_0.programmable_pfet$4_0.g.n11 programmable_5tOTA_0.programmable_pfet$4_0.g.n10 7.49892
R14710 programmable_5tOTA_0.programmable_pfet$4_0.g.n7 programmable_5tOTA_0.programmable_pfet$4_0.g.n6 7.49892
R14711 programmable_5tOTA_0.programmable_pfet$4_0.g.n19 programmable_5tOTA_0.programmable_pfet$4_0.g.n16 6.62063
R14712 programmable_5tOTA_0.programmable_pfet$4_0.g.n23 programmable_5tOTA_0.programmable_pfet$4_0.g.n11 5.94751
R14713 programmable_5tOTA_0.programmable_pfet$4_0.g.n23 programmable_5tOTA_0.programmable_pfet$4_0.g.n22 5.54321
R14714 programmable_5tOTA_0.programmable_pfet$4_0.g programmable_5tOTA_0.programmable_pfet$4_0.g.n2 4.76124
R14715 programmable_5tOTA_0.programmable_pfet$4_0.g programmable_5tOTA_0.programmable_pfet$4_0.g.n27 4.76124
R14716 programmable_5tOTA_0.programmable_pfet$4_0.g.n3 programmable_5tOTA_0.programmable_pfet$4_0.g.n1 4.72153
R14717 programmable_5tOTA_0.programmable_pfet$4_0.g.n26 programmable_5tOTA_0.programmable_pfet$4_0.g.n0 4.72153
R14718 programmable_5tOTA_0.programmable_pfet$4_0.g.n26 programmable_5tOTA_0.programmable_pfet$4_0.g.n25 4.5005
R14719 programmable_5tOTA_0.programmable_pfet$4_0.g.n4 programmable_5tOTA_0.programmable_pfet$4_0.g.n3 4.5005
R14720 programmable_5tOTA_0.programmable_pfet$4_0.g.n22 programmable_5tOTA_0.programmable_pfet$4_0.g.n21 4.5005
R14721 programmable_5tOTA_0.programmable_pfet$4_0.g.n19 programmable_5tOTA_0.programmable_pfet$4_0.g.n18 4.5005
R14722 programmable_5tOTA_0.programmable_pfet$4_0.g.n17 programmable_5tOTA_0.programmable_pfet$4_0.g.t9 3.4252
R14723 programmable_5tOTA_0.programmable_pfet$4_0.g.n20 programmable_5tOTA_0.programmable_pfet$4_0.g.t23 3.4252
R14724 programmable_5tOTA_0.programmable_pfet$4_0.g.n18 programmable_5tOTA_0.programmable_pfet$4_0.g.n17 1.78274
R14725 programmable_5tOTA_0.programmable_pfet$4_0.g.n21 programmable_5tOTA_0.programmable_pfet$4_0.g.n20 1.78274
R14726 programmable_5tOTA_0.programmable_pfet$4_0.g.n25 programmable_5tOTA_0.programmable_pfet$4_0.g.n24 1.66668
R14727 programmable_5tOTA_0.programmable_pfet$4_0.g.n18 programmable_5tOTA_0.programmable_pfet$4_0.g.t7 1.64297
R14728 programmable_5tOTA_0.programmable_pfet$4_0.g.n21 programmable_5tOTA_0.programmable_pfet$4_0.g.t22 1.64297
R14729 programmable_5tOTA_0.programmable_pfet$4_0.g.n24 programmable_5tOTA_0.programmable_pfet$4_0.g.n4 1.12668
R14730 programmable_5tOTA_0.programmable_pfet$4_0.g.n11 programmable_5tOTA_0.programmable_pfet$4_0.g.n7 1.11131
R14731 programmable_5tOTA_0.programmable_pfet$4_0.g.n22 programmable_5tOTA_0.programmable_pfet$4_0.g.n19 0.821429
R14732 programmable_5tOTA_0.programmable_pfet$4_0.g.n17 programmable_5tOTA_0.programmable_pfet$4_0.g.t8 0.495466
R14733 programmable_5tOTA_0.programmable_pfet$4_0.g.n20 programmable_5tOTA_0.programmable_pfet$4_0.g.t24 0.495466
R14734 programmable_5tOTA_0.programmable_pfet$4_0.g.n16 programmable_5tOTA_0.programmable_pfet$4_0.g.n12 0.479281
R14735 programmable_5tOTA_0.programmable_pfet$4_0.g.n15 programmable_5tOTA_0.programmable_pfet$4_0.g.n14 0.274413
R14736 programmable_5tOTA_0.programmable_pfet$4_0.g.n14 programmable_5tOTA_0.programmable_pfet$4_0.g.t5 0.144184
R14737 programmable_5tOTA_0.programmable_pfet$4_0.g.n14 programmable_5tOTA_0.programmable_pfet$4_0.g.t3 0.144184
R14738 programmable_5tOTA_0.programmable_pfet$4_0.g.n13 programmable_5tOTA_0.programmable_pfet$4_0.g.t4 0.144184
R14739 programmable_5tOTA_0.programmable_pfet$4_0.g.n13 programmable_5tOTA_0.programmable_pfet$4_0.g.t2 0.144184
R14740 programmable_5tOTA_0.programmable_pfet$4_0.g.n12 programmable_5tOTA_0.programmable_pfet$4_0.g.t1 0.144184
R14741 programmable_5tOTA_0.programmable_pfet$4_0.g.n12 programmable_5tOTA_0.programmable_pfet$4_0.g.t0 0.144184
R14742 programmable_5tOTA_0.programmable_pfet$4_0.g.n6 programmable_5tOTA_0.programmable_pfet$4_0.g.t17 0.108357
R14743 programmable_5tOTA_0.programmable_pfet$4_0.g.n5 programmable_5tOTA_0.programmable_pfet$4_0.g.t10 0.108357
R14744 programmable_5tOTA_0.programmable_pfet$4_0.g.n10 programmable_5tOTA_0.programmable_pfet$4_0.g.n9 0.0495566
R14745 programmable_5tOTA_0.programmable_pfet$4_0.g.n2 programmable_5tOTA_0.programmable_pfet$4_0.g 0.0417048
R14746 programmable_5tOTA_0.programmable_pfet$4_0.g.n27 programmable_5tOTA_0.programmable_pfet$4_0.g 0.0417048
R14747 programmable_5tOTA_0.programmable_pfet$4_0.g.n1 programmable_5tOTA_0.programmable_pfet$4_0.g 0.0406205
R14748 programmable_5tOTA_0.programmable_pfet$4_0.g.n0 programmable_5tOTA_0.programmable_pfet$4_0.g 0.0406205
R14749 programmable_5tOTA_0.programmable_pfet$4_0.g.n9 programmable_5tOTA_0.programmable_pfet$4_0.g.t13 0.0369
R14750 programmable_5tOTA_0.programmable_pfet$4_0.g.n9 programmable_5tOTA_0.programmable_pfet$4_0.g.t15 0.0369
R14751 programmable_5tOTA_0.programmable_pfet$4_0.g.n8 programmable_5tOTA_0.programmable_pfet$4_0.g.t12 0.0369
R14752 programmable_5tOTA_0.programmable_pfet$4_0.g.n8 programmable_5tOTA_0.programmable_pfet$4_0.g.t14 0.0369
R14753 programmable_5tOTA_0.programmable_pfet$4_0.g.n3 programmable_5tOTA_0.programmable_pfet$4_0.g 0.0190294
R14754 programmable_5tOTA_0.programmable_pfet$4_0.g programmable_5tOTA_0.programmable_pfet$4_0.g.n26 0.0190294
R14755 programmable_5tOTA_0.programmable_pfet$4_1.transmission_gate$27_1.out.t4 programmable_5tOTA_0.programmable_pfet$4_1.transmission_gate$27_1.out.t3 750.149
R14756 programmable_5tOTA_0.programmable_pfet$4_1.transmission_gate$27_1.out.n0 programmable_5tOTA_0.programmable_pfet$4_1.transmission_gate$27_1.out.t4 394.526
R14757 programmable_5tOTA_0.programmable_pfet$4_1.transmission_gate$27_1.out.n0 programmable_5tOTA_0.programmable_pfet$4_1.transmission_gate$27_1.out.t1 17.8479
R14758 programmable_5tOTA_0.programmable_pfet$4_1.transmission_gate$27_1.out.n1 programmable_5tOTA_0.programmable_pfet$4_1.transmission_gate$27_1.out.n0 15.0696
R14759 programmable_5tOTA_0.programmable_pfet$4_1.transmission_gate$27_1.out.n1 programmable_5tOTA_0.programmable_pfet$4_1.transmission_gate$27_1.out.t0 12.5243
R14760 programmable_5tOTA_0.programmable_pfet$4_1.transmission_gate$27_1.out programmable_5tOTA_0.programmable_pfet$4_1.transmission_gate$27_1.out.t2 12.2669
R14761 programmable_5tOTA_0.programmable_pfet$4_1.transmission_gate$27_1.out programmable_5tOTA_0.programmable_pfet$4_1.transmission_gate$27_1.out.n1 0.0329
R14762 programmable_common_source_0.programmable_pfet$5_0.transmission_gate$30_1.out.t8 programmable_common_source_0.programmable_pfet$5_0.transmission_gate$30_1.out.t4 77.2345
R14763 programmable_common_source_0.programmable_pfet$5_0.transmission_gate$30_1.out.t7 programmable_common_source_0.programmable_pfet$5_0.transmission_gate$30_1.out.t8 77.2345
R14764 programmable_common_source_0.programmable_pfet$5_0.transmission_gate$30_1.out.t12 programmable_common_source_0.programmable_pfet$5_0.transmission_gate$30_1.out.t7 77.2345
R14765 programmable_common_source_0.programmable_pfet$5_0.transmission_gate$30_1.out.t9 programmable_common_source_0.programmable_pfet$5_0.transmission_gate$30_1.out.t12 77.2345
R14766 programmable_common_source_0.programmable_pfet$5_0.transmission_gate$30_1.out.t5 programmable_common_source_0.programmable_pfet$5_0.transmission_gate$30_1.out.t9 77.2345
R14767 programmable_common_source_0.programmable_pfet$5_0.transmission_gate$30_1.out.t10 programmable_common_source_0.programmable_pfet$5_0.transmission_gate$30_1.out.t5 77.2345
R14768 programmable_common_source_0.programmable_pfet$5_0.transmission_gate$30_1.out.t6 programmable_common_source_0.programmable_pfet$5_0.transmission_gate$30_1.out.t10 77.2345
R14769 programmable_common_source_0.programmable_pfet$5_0.transmission_gate$30_1.out.t3 programmable_common_source_0.programmable_pfet$5_0.transmission_gate$30_1.out.t6 77.2345
R14770 programmable_common_source_0.programmable_pfet$5_0.transmission_gate$30_1.out.t11 programmable_common_source_0.programmable_pfet$5_0.transmission_gate$30_1.out.t3 77.2345
R14771 programmable_common_source_0.programmable_pfet$5_0.transmission_gate$30_1.out.n0 programmable_common_source_0.programmable_pfet$5_0.transmission_gate$30_1.out.t11 45.1575
R14772 programmable_common_source_0.programmable_pfet$5_0.transmission_gate$30_1.out.n0 programmable_common_source_0.programmable_pfet$5_0.transmission_gate$30_1.out.t2 22.5951
R14773 programmable_common_source_0.programmable_pfet$5_0.transmission_gate$30_1.out.n1 programmable_common_source_0.programmable_pfet$5_0.transmission_gate$30_1.out.t1 12.5243
R14774 programmable_common_source_0.programmable_pfet$5_0.transmission_gate$30_1.out programmable_common_source_0.programmable_pfet$5_0.transmission_gate$30_1.out.t0 12.2669
R14775 programmable_common_source_0.programmable_pfet$5_0.transmission_gate$30_1.out.n1 programmable_common_source_0.programmable_pfet$5_0.transmission_gate$30_1.out.n0 10.3223
R14776 programmable_common_source_0.programmable_pfet$5_0.transmission_gate$30_1.out programmable_common_source_0.programmable_pfet$5_0.transmission_gate$30_1.out.n1 0.0329
R14777 OUT_CS.n29 OUT_CS.n28 24.8119
R14778 OUT_CS.n29 OUT_CS.n18 6.81089
R14779 OUT_CS.n31 OUT_CS.n30 6.80971
R14780 OUT_CS.n34 OUT_CS.n0 6.80853
R14781 OUT_CS.n54 OUT_CS.n53 5.88358
R14782 OUT_CS.n57 OUT_CS.n44 5.819
R14783 OUT_CS.n32 OUT_CS.n18 5.71266
R14784 OUT_CS.n32 OUT_CS.n31 4.73853
R14785 OUT_CS.n35 OUT_CS.n34 4.73734
R14786 OUT_CS.n55 OUT_CS.n54 4.55971
R14787 OUT_CS.n62 OUT_CS.n61 4.55971
R14788 OUT_CS.n28 OUT_CS.n27 4.50104
R14789 OUT_CS.n25 OUT_CS.n22 4.50076
R14790 OUT_CS.n59 OUT_CS.n58 4.5005
R14791 OUT_CS.n57 OUT_CS.n56 4.5005
R14792 OUT_CS.n23 OUT_CS.n21 4.5005
R14793 OUT_CS.n25 OUT_CS.n24 4.5005
R14794 OUT_CS.n20 OUT_CS.n19 4.5005
R14795 OUT_CS.n27 OUT_CS.n26 4.5005
R14796 OUT_CS.n36 OUT_CS.t22 3.09954
R14797 OUT_CS.n45 OUT_CS.t9 3.09954
R14798 OUT_CS.n3 OUT_CS.n1 2.77997
R14799 OUT_CS.n37 OUT_CS.n36 2.50629
R14800 OUT_CS.n38 OUT_CS.n37 2.50629
R14801 OUT_CS.n39 OUT_CS.n38 2.50629
R14802 OUT_CS.n40 OUT_CS.n39 2.50629
R14803 OUT_CS.n41 OUT_CS.n40 2.50629
R14804 OUT_CS.n42 OUT_CS.n41 2.50629
R14805 OUT_CS.n43 OUT_CS.n42 2.50629
R14806 OUT_CS.n46 OUT_CS.n45 2.50629
R14807 OUT_CS.n47 OUT_CS.n46 2.50629
R14808 OUT_CS.n48 OUT_CS.n47 2.50629
R14809 OUT_CS.n49 OUT_CS.n48 2.50629
R14810 OUT_CS.n50 OUT_CS.n49 2.50629
R14811 OUT_CS.n51 OUT_CS.n50 2.50629
R14812 OUT_CS.n52 OUT_CS.n51 2.50629
R14813 OUT_CS.n5 OUT_CS.n3 2.50629
R14814 OUT_CS.n7 OUT_CS.n5 2.50629
R14815 OUT_CS.n9 OUT_CS.n7 2.50629
R14816 OUT_CS.n11 OUT_CS.n9 2.50629
R14817 OUT_CS.n13 OUT_CS.n11 2.50629
R14818 OUT_CS.n15 OUT_CS.n13 2.50629
R14819 OUT_CS.n17 OUT_CS.n15 2.50629
R14820 OUT_CS.n53 OUT_CS.n44 2.48734
R14821 OUT_CS.n61 OUT_CS.n59 2.48734
R14822 OUT_CS.n56 OUT_CS.n55 2.48616
R14823 OUT_CS.n58 OUT_CS.n35 1.9565
R14824 OUT_CS.n58 OUT_CS.n57 1.832
R14825 OUT_CS.n30 OUT_CS.n0 1.487
R14826 OUT_CS.n54 OUT_CS 1.3265
R14827 OUT_CS.n22 OUT_CS 1.09423
R14828 OUT_CS OUT_CS.n62 1.0385
R14829 OUT_CS OUT_CS.n32 0.9755
R14830 OUT_CS.n30 OUT_CS.n29 0.968
R14831 OUT_CS OUT_CS.n0 0.914
R14832 OUT_CS.n36 OUT_CS.t18 0.593749
R14833 OUT_CS.n37 OUT_CS.t19 0.593749
R14834 OUT_CS.n38 OUT_CS.t14 0.593749
R14835 OUT_CS.n39 OUT_CS.t17 0.593749
R14836 OUT_CS.n40 OUT_CS.t21 0.593749
R14837 OUT_CS.n41 OUT_CS.t16 0.593749
R14838 OUT_CS.n42 OUT_CS.t20 0.593749
R14839 OUT_CS.n43 OUT_CS.t23 0.593749
R14840 OUT_CS.n53 OUT_CS.t15 0.593749
R14841 OUT_CS.n45 OUT_CS.t11 0.593749
R14842 OUT_CS.n46 OUT_CS.t13 0.593749
R14843 OUT_CS.n47 OUT_CS.t7 0.593749
R14844 OUT_CS.n48 OUT_CS.t4 0.593749
R14845 OUT_CS.n49 OUT_CS.t10 0.593749
R14846 OUT_CS.n50 OUT_CS.t5 0.593749
R14847 OUT_CS.n51 OUT_CS.t12 0.593749
R14848 OUT_CS.n52 OUT_CS.t8 0.593749
R14849 OUT_CS.n55 OUT_CS.t6 0.593749
R14850 OUT_CS.n35 OUT_CS 0.503
R14851 OUT_CS.n62 OUT_CS 0.503
R14852 OUT_CS.n61 OUT_CS.n60 0.274184
R14853 OUT_CS.n17 OUT_CS.n16 0.274184
R14854 OUT_CS.n15 OUT_CS.n14 0.274184
R14855 OUT_CS.n13 OUT_CS.n12 0.274184
R14856 OUT_CS.n11 OUT_CS.n10 0.274184
R14857 OUT_CS.n9 OUT_CS.n8 0.274184
R14858 OUT_CS.n7 OUT_CS.n6 0.274184
R14859 OUT_CS.n5 OUT_CS.n4 0.274184
R14860 OUT_CS.n3 OUT_CS.n2 0.274184
R14861 OUT_CS.n18 OUT_CS.t0 0.204015
R14862 OUT_CS.n31 OUT_CS.t3 0.204015
R14863 OUT_CS.n1 OUT_CS.t36 0.198326
R14864 OUT_CS.n1 OUT_CS.t27 0.198326
R14865 OUT_CS.n2 OUT_CS.t42 0.198326
R14866 OUT_CS.n2 OUT_CS.t43 0.198326
R14867 OUT_CS.n4 OUT_CS.t41 0.198326
R14868 OUT_CS.n4 OUT_CS.t32 0.198326
R14869 OUT_CS.n6 OUT_CS.t30 0.198326
R14870 OUT_CS.n6 OUT_CS.t39 0.198326
R14871 OUT_CS.n8 OUT_CS.t24 0.198326
R14872 OUT_CS.n8 OUT_CS.t33 0.198326
R14873 OUT_CS.n10 OUT_CS.t37 0.198326
R14874 OUT_CS.n10 OUT_CS.t28 0.198326
R14875 OUT_CS.n12 OUT_CS.t25 0.198326
R14876 OUT_CS.n12 OUT_CS.t34 0.198326
R14877 OUT_CS.n14 OUT_CS.t38 0.198326
R14878 OUT_CS.n14 OUT_CS.t29 0.198326
R14879 OUT_CS.n16 OUT_CS.t31 0.198326
R14880 OUT_CS.n16 OUT_CS.t40 0.198326
R14881 OUT_CS.n60 OUT_CS.t26 0.198326
R14882 OUT_CS.n60 OUT_CS.t35 0.198326
R14883 OUT_CS.n34 OUT_CS.n33 0.111026
R14884 OUT_CS.n33 OUT_CS.t1 0.0609428
R14885 OUT_CS.n33 OUT_CS.t2 0.0609428
R14886 OUT_CS.n26 OUT_CS.n21 0.0578913
R14887 OUT_CS.n27 OUT_CS.n20 0.0211024
R14888 OUT_CS.n56 OUT_CS.n52 0.0206316
R14889 OUT_CS.n24 OUT_CS.n23 0.0203795
R14890 OUT_CS.n44 OUT_CS.n43 0.0194474
R14891 OUT_CS.n59 OUT_CS.n17 0.0194474
R14892 OUT_CS.n23 OUT_CS.n22 0.00104217
R14893 OUT_CS.n24 OUT_CS.n20 0.00104217
R14894 OUT_CS.n28 OUT_CS.n19 0.00076087
R14895 OUT_CS.n21 OUT_CS.n19 0.00076087
R14896 OUT_CS.n26 OUT_CS.n25 0.00076087
R14897 transmission_gate$2$1_2.out.n15 transmission_gate$2$1_2.out.n14 92.6081
R14898 transmission_gate$2$1_2.out transmission_gate$2$1_2.out.t17 30.4906
R14899 transmission_gate$2$1_2.out.n8 transmission_gate$2$1_2.out.t14 30.073
R14900 transmission_gate$2$1_2.out.n6 transmission_gate$2$1_2.out.t6 30.073
R14901 transmission_gate$2$1_2.out transmission_gate$2$1_2.out.t10 25.0251
R14902 transmission_gate$2$1_2.out transmission_gate$2$1_2.out.t13 25.0251
R14903 transmission_gate$2$1_2.out.n2 transmission_gate$2$1_2.out.t7 25.0227
R14904 transmission_gate$2$1_2.out.n16 transmission_gate$2$1_2.out.t12 24.9469
R14905 transmission_gate$2$1_2.out.n18 transmission_gate$2$1_2.out.t5 24.9469
R14906 transmission_gate$2$1_2.out.n12 transmission_gate$2$1_2.out.t9 24.9469
R14907 transmission_gate$2$1_2.out.n11 transmission_gate$2$1_2.out.t11 24.9469
R14908 transmission_gate$2$1_2.out.n7 transmission_gate$2$1_2.out.t8 24.9469
R14909 transmission_gate$2$1_2.out.n5 transmission_gate$2$1_2.out.t16 24.9469
R14910 transmission_gate$2$1_2.out.n3 transmission_gate$2$1_2.out.t15 24.9469
R14911 transmission_gate$2$1_2.out.n0 transmission_gate$2$1_2.out.t2 17.5462
R14912 transmission_gate$2$1_2.out.n1 transmission_gate$2$1_2.out.t4 16.7838
R14913 transmission_gate$2$1_2.out.n0 transmission_gate$2$1_2.out.t1 16.7833
R14914 transmission_gate$2$1_2.out.n4 transmission_gate$2$1_2.out.n3 16.2005
R14915 transmission_gate$2$1_2.out transmission_gate$2$1_2.out.t3 12.5567
R14916 transmission_gate$2$1_2.out.n21 transmission_gate$2$1_2.out.t0 12.0263
R14917 transmission_gate$2$1_2.out.n13 transmission_gate$2$1_2.out.n12 11.6011
R14918 transmission_gate$2$1_2.out.n13 transmission_gate$2$1_2.out.n11 10.8206
R14919 transmission_gate$2$1_2.out.n17 transmission_gate$2$1_2.out 10.455
R14920 transmission_gate$2$1_2.out.n9 transmission_gate$2$1_2.out.n8 7.17828
R14921 transmission_gate$2$1_2.out.n9 transmission_gate$2$1_2.out.n6 6.38721
R14922 transmission_gate$2$1_2.out transmission_gate$2$1_2.out.n16 6.06552
R14923 transmission_gate$2$1_2.out.n20 transmission_gate$2$1_2.out 5.58854
R14924 transmission_gate$2$1_2.out.n19 transmission_gate$2$1_2.out.n18 5.3648
R14925 transmission_gate$2$1_2.out transmission_gate$2$1_2.out.n7 5.03221
R14926 transmission_gate$2$1_2.out transmission_gate$2$1_2.out.n5 5.03221
R14927 transmission_gate$2$1_2.out.n14 transmission_gate$2$1_2.out.n13 4.96234
R14928 transmission_gate$2$1_2.out.n15 transmission_gate$2$1_2.out.n2 4.79782
R14929 transmission_gate$2$1_2.out.n10 transmission_gate$2$1_2.out.n9 4.5005
R14930 transmission_gate$2$1_2.out.n20 transmission_gate$2$1_2.out.n19 4.5005
R14931 transmission_gate$2$1_2.out.n10 transmission_gate$2$1_2.out.n4 3.60879
R14932 transmission_gate$2$1_2.out.n4 transmission_gate$2$1_2.out 3.46195
R14933 transmission_gate$2$1_2.out.n14 transmission_gate$2$1_2.out.n10 1.90589
R14934 transmission_gate$2$1_2.out.n21 transmission_gate$2$1_2.out.n20 1.24764
R14935 transmission_gate$2$1_2.out transmission_gate$2$1_2.out.n1 0.947107
R14936 transmission_gate$2$1_2.out.n8 transmission_gate$2$1_2.out 0.508772
R14937 transmission_gate$2$1_2.out.n6 transmission_gate$2$1_2.out 0.508772
R14938 transmission_gate$2$1_2.out.n1 transmission_gate$2$1_2.out 0.424786
R14939 transmission_gate$2$1_2.out transmission_gate$2$1_2.out.n15 0.325143
R14940 transmission_gate$2$1_2.out transmission_gate$2$1_2.out.n21 0.2411
R14941 transmission_gate$2$1_2.out transmission_gate$2$1_2.out.n0 0.140321
R14942 transmission_gate$2$1_2.out transmission_gate$2$1_2.out.n17 0.125857
R14943 transmission_gate$2$1_2.out.n16 transmission_gate$2$1_2.out 0.0751053
R14944 transmission_gate$2$1_2.out.n18 transmission_gate$2$1_2.out 0.0751053
R14945 transmission_gate$2$1_2.out.n19 transmission_gate$2$1_2.out 0.0422857
R14946 transmission_gate$2$1_2.out.n2 transmission_gate$2$1_2.out 0.00878947
R14947 transmission_gate$2$1_2.out.n12 transmission_gate$2$1_2.out 0.00760526
R14948 transmission_gate$2$1_2.out.n7 transmission_gate$2$1_2.out 0.00760526
R14949 transmission_gate$2$1_2.out.n5 transmission_gate$2$1_2.out 0.00760526
R14950 transmission_gate$2$1_2.out.n3 transmission_gate$2$1_2.out 0.00760526
R14951 transmission_gate$2$1_2.out.n11 transmission_gate$2$1_2.out 0.00405263
R14952 transmission_gate$2$1_2.out.n17 transmission_gate$2$1_2.out 0.00371429
R14953 transmission_gate$2$1_2.out.n12 transmission_gate$2$1_2.out 0.00168421
R14954 transmission_gate$2$1_2.out.n3 transmission_gate$2$1_2.out 0.00168421
R14955 programmable_5tOTA_0.ena_bar<1>.n16 programmable_5tOTA_0.ena_bar<1>.n15 93.1864
R14956 programmable_5tOTA_0.ena_bar<1>.n11 programmable_5tOTA_0.ena_bar<1>.t4 25.4419
R14957 programmable_5tOTA_0.ena_bar<1>.n4 programmable_5tOTA_0.ena_bar<1>.t3 25.4419
R14958 programmable_5tOTA_0.ena_bar<1>.n13 programmable_5tOTA_0.ena_bar<1>.t9 25.4413
R14959 programmable_5tOTA_0.ena_bar<1> programmable_5tOTA_0.ena_bar<1>.t6 25.0275
R14960 programmable_5tOTA_0.ena_bar<1>.n0 programmable_5tOTA_0.ena_bar<1>.t5 24.9469
R14961 programmable_5tOTA_0.ena_bar<1>.n10 programmable_5tOTA_0.ena_bar<1>.t8 24.9469
R14962 programmable_5tOTA_0.ena_bar<1>.n12 programmable_5tOTA_0.ena_bar<1>.t11 24.9469
R14963 programmable_5tOTA_0.ena_bar<1>.n3 programmable_5tOTA_0.ena_bar<1>.t7 24.9469
R14964 programmable_5tOTA_0.ena_bar<1>.n6 programmable_5tOTA_0.ena_bar<1>.t12 24.9469
R14965 programmable_5tOTA_0.ena_bar<1>.n7 programmable_5tOTA_0.ena_bar<1>.t10 24.9469
R14966 programmable_5tOTA_0.ena_bar<1> programmable_5tOTA_0.ena_bar<1>.t0 17.2081
R14967 programmable_5tOTA_0.ena_bar<1>.n2 programmable_5tOTA_0.ena_bar<1>.t1 17.1605
R14968 programmable_5tOTA_0.ena_bar<1>.n1 programmable_5tOTA_0.ena_bar<1>.t2 16.7833
R14969 programmable_5tOTA_0.ena_bar<1> programmable_5tOTA_0.ena_bar<1>.n0 15.6278
R14970 programmable_5tOTA_0.ena_bar<1>.n11 programmable_5tOTA_0.ena_bar<1> 4.973
R14971 programmable_5tOTA_0.ena_bar<1>.n13 programmable_5tOTA_0.ena_bar<1> 4.973
R14972 programmable_5tOTA_0.ena_bar<1>.n4 programmable_5tOTA_0.ena_bar<1> 4.973
R14973 programmable_5tOTA_0.ena_bar<1> programmable_5tOTA_0.ena_bar<1>.n10 4.93747
R14974 programmable_5tOTA_0.ena_bar<1> programmable_5tOTA_0.ena_bar<1>.n12 4.93747
R14975 programmable_5tOTA_0.ena_bar<1> programmable_5tOTA_0.ena_bar<1>.n3 4.93747
R14976 programmable_5tOTA_0.ena_bar<1>.n15 programmable_5tOTA_0.ena_bar<1>.n14 4.83918
R14977 programmable_5tOTA_0.ena_bar<1>.n5 programmable_5tOTA_0.ena_bar<1>.n4 4.71958
R14978 programmable_5tOTA_0.ena_bar<1>.n9 programmable_5tOTA_0.ena_bar<1>.n8 4.5005
R14979 programmable_5tOTA_0.ena_bar<1>.n15 programmable_5tOTA_0.ena_bar<1>.n9 4.0505
R14980 programmable_5tOTA_0.ena_bar<1>.n5 programmable_5tOTA_0.ena_bar<1> 3.04629
R14981 programmable_5tOTA_0.ena_bar<1>.n9 programmable_5tOTA_0.ena_bar<1>.n5 2.45537
R14982 programmable_5tOTA_0.ena_bar<1>.n14 programmable_5tOTA_0.ena_bar<1>.n13 1.66493
R14983 programmable_5tOTA_0.ena_bar<1>.n8 programmable_5tOTA_0.ena_bar<1> 1.64505
R14984 programmable_5tOTA_0.ena_bar<1>.n2 programmable_5tOTA_0.ena_bar<1>.n1 0.386214
R14985 programmable_5tOTA_0.ena_bar<1> programmable_5tOTA_0.ena_bar<1>.n2 0.249607
R14986 programmable_5tOTA_0.ena_bar<1>.n14 programmable_5tOTA_0.ena_bar<1>.n11 0.216026
R14987 programmable_5tOTA_0.ena_bar<1>.n8 programmable_5tOTA_0.ena_bar<1> 0.212058
R14988 programmable_5tOTA_0.ena_bar<1>.n1 programmable_5tOTA_0.ena_bar<1> 0.140321
R14989 programmable_5tOTA_0.ena_bar<1>.n0 programmable_5tOTA_0.ena_bar<1> 0.0721524
R14990 programmable_5tOTA_0.ena_bar<1> programmable_5tOTA_0.ena_bar<1>.n16 0.0390714
R14991 programmable_5tOTA_0.ena_bar<1>.n16 programmable_5tOTA_0.ena_bar<1> 0.0197857
R14992 programmable_5tOTA_0.ena_bar<1>.n6 programmable_5tOTA_0.ena_bar<1> 0.00634416
R14993 programmable_5tOTA_0.ena_bar<1>.n7 programmable_5tOTA_0.ena_bar<1> 0.00634416
R14994 programmable_5tOTA_0.ena_bar<1>.n10 programmable_5tOTA_0.ena_bar<1> 0.00168421
R14995 programmable_5tOTA_0.ena_bar<1>.n12 programmable_5tOTA_0.ena_bar<1> 0.00168421
R14996 programmable_5tOTA_0.ena_bar<1>.n3 programmable_5tOTA_0.ena_bar<1> 0.00168421
R14997 programmable_5tOTA_0.ena_bar<1> programmable_5tOTA_0.ena_bar<1>.n6 0.00166883
R14998 programmable_5tOTA_0.ena_bar<1> programmable_5tOTA_0.ena_bar<1>.n7 0.00166883
R14999 programmable_folded_cascode_0.programmable_pfet_0.transmission_gate$16_1.out.t9 programmable_folded_cascode_0.programmable_pfet_0.transmission_gate$16_1.out.t5 264.151
R15000 programmable_folded_cascode_0.programmable_pfet_0.transmission_gate$16_1.out.t19 programmable_folded_cascode_0.programmable_pfet_0.transmission_gate$16_1.out.t10 264.151
R15001 programmable_folded_cascode_0.programmable_pfet_0.transmission_gate$16_1.out.t5 programmable_folded_cascode_0.programmable_pfet_0.transmission_gate$16_1.out.t22 264.115
R15002 programmable_folded_cascode_0.programmable_pfet_0.transmission_gate$16_1.out.t11 programmable_folded_cascode_0.programmable_pfet_0.transmission_gate$16_1.out.t9 264.115
R15003 programmable_folded_cascode_0.programmable_pfet_0.transmission_gate$16_1.out.t7 programmable_folded_cascode_0.programmable_pfet_0.transmission_gate$16_1.out.t11 264.115
R15004 programmable_folded_cascode_0.programmable_pfet_0.transmission_gate$16_1.out.t15 programmable_folded_cascode_0.programmable_pfet_0.transmission_gate$16_1.out.t7 264.115
R15005 programmable_folded_cascode_0.programmable_pfet_0.transmission_gate$16_1.out.t17 programmable_folded_cascode_0.programmable_pfet_0.transmission_gate$16_1.out.t15 264.115
R15006 programmable_folded_cascode_0.programmable_pfet_0.transmission_gate$16_1.out.t12 programmable_folded_cascode_0.programmable_pfet_0.transmission_gate$16_1.out.t17 264.115
R15007 programmable_folded_cascode_0.programmable_pfet_0.transmission_gate$16_1.out.t8 programmable_folded_cascode_0.programmable_pfet_0.transmission_gate$16_1.out.t12 264.115
R15008 programmable_folded_cascode_0.programmable_pfet_0.transmission_gate$16_1.out.t14 programmable_folded_cascode_0.programmable_pfet_0.transmission_gate$16_1.out.t8 264.115
R15009 programmable_folded_cascode_0.programmable_pfet_0.transmission_gate$16_1.out.t10 programmable_folded_cascode_0.programmable_pfet_0.transmission_gate$16_1.out.t13 264.115
R15010 programmable_folded_cascode_0.programmable_pfet_0.transmission_gate$16_1.out.t20 programmable_folded_cascode_0.programmable_pfet_0.transmission_gate$16_1.out.t19 264.115
R15011 programmable_folded_cascode_0.programmable_pfet_0.transmission_gate$16_1.out.t16 programmable_folded_cascode_0.programmable_pfet_0.transmission_gate$16_1.out.t20 264.115
R15012 programmable_folded_cascode_0.programmable_pfet_0.transmission_gate$16_1.out.t4 programmable_folded_cascode_0.programmable_pfet_0.transmission_gate$16_1.out.t16 264.115
R15013 programmable_folded_cascode_0.programmable_pfet_0.transmission_gate$16_1.out.t6 programmable_folded_cascode_0.programmable_pfet_0.transmission_gate$16_1.out.t4 264.115
R15014 programmable_folded_cascode_0.programmable_pfet_0.transmission_gate$16_1.out.t21 programmable_folded_cascode_0.programmable_pfet_0.transmission_gate$16_1.out.t6 264.115
R15015 programmable_folded_cascode_0.programmable_pfet_0.transmission_gate$16_1.out.t18 programmable_folded_cascode_0.programmable_pfet_0.transmission_gate$16_1.out.t21 264.115
R15016 programmable_folded_cascode_0.programmable_pfet_0.transmission_gate$16_1.out.t3 programmable_folded_cascode_0.programmable_pfet_0.transmission_gate$16_1.out.t18 264.115
R15017 programmable_folded_cascode_0.programmable_pfet_0.transmission_gate$16_1.out.n0 programmable_folded_cascode_0.programmable_pfet_0.transmission_gate$16_1.out.t3 143.1
R15018 programmable_folded_cascode_0.programmable_pfet_0.transmission_gate$16_1.out.n1 programmable_folded_cascode_0.programmable_pfet_0.transmission_gate$16_1.out.t14 138.597
R15019 programmable_folded_cascode_0.programmable_pfet_0.transmission_gate$16_1.out.n0 programmable_folded_cascode_0.programmable_pfet_0.transmission_gate$16_1.out.t2 17.7026
R15020 programmable_folded_cascode_0.programmable_pfet_0.transmission_gate$16_1.out.n2 programmable_folded_cascode_0.programmable_pfet_0.transmission_gate$16_1.out.t1 12.5327
R15021 programmable_folded_cascode_0.programmable_pfet_0.transmission_gate$16_1.out programmable_folded_cascode_0.programmable_pfet_0.transmission_gate$16_1.out.t0 12.2669
R15022 programmable_folded_cascode_0.programmable_pfet_0.transmission_gate$16_1.out.n2 programmable_folded_cascode_0.programmable_pfet_0.transmission_gate$16_1.out.n1 10.2686
R15023 programmable_folded_cascode_0.programmable_pfet_0.transmission_gate$16_1.out.n1 programmable_folded_cascode_0.programmable_pfet_0.transmission_gate$16_1.out.n0 4.84686
R15024 programmable_folded_cascode_0.programmable_pfet_0.transmission_gate$16_1.out programmable_folded_cascode_0.programmable_pfet_0.transmission_gate$16_1.out.n2 0.0245
R15025 a_49197_2844.n43 a_49197_2844.t8 16.5211
R15026 a_49197_2844.n64 a_49197_2844.n0 16.4359
R15027 a_49197_2844.n44 a_49197_2844.n43 16.3379
R15028 a_49197_2844.n45 a_49197_2844.n44 16.3379
R15029 a_49197_2844.n46 a_49197_2844.n45 16.3379
R15030 a_49197_2844.n19 a_49197_2844.n9 9.26837
R15031 a_49197_2844.n21 a_49197_2844.n19 9.22068
R15032 a_49197_2844.n1 a_49197_2844.t51 8.7356
R15033 a_49197_2844.n30 a_49197_2844.n28 8.65111
R15034 a_49197_2844.n3 a_49197_2844.n2 8.5811
R15035 a_49197_2844.n32 a_49197_2844.n30 8.5811
R15036 a_49197_2844.n2 a_49197_2844.n1 8.57988
R15037 a_49197_2844.n4 a_49197_2844.n3 8.57988
R15038 a_49197_2844.n5 a_49197_2844.n4 8.57988
R15039 a_49197_2844.n6 a_49197_2844.n5 8.57988
R15040 a_49197_2844.n7 a_49197_2844.n6 8.57988
R15041 a_49197_2844.n8 a_49197_2844.n7 8.57988
R15042 a_49197_2844.n9 a_49197_2844.n8 8.57988
R15043 a_49197_2844.n23 a_49197_2844.n21 8.57988
R15044 a_49197_2844.n25 a_49197_2844.n23 8.57988
R15045 a_49197_2844.n27 a_49197_2844.n25 8.57988
R15046 a_49197_2844.n34 a_49197_2844.n32 8.57988
R15047 a_49197_2844.n36 a_49197_2844.n34 8.57988
R15048 a_49197_2844.n38 a_49197_2844.n36 8.57988
R15049 a_49197_2844.n10 a_49197_2844.t21 8.42485
R15050 a_49197_2844.n11 a_49197_2844.n10 8.27035
R15051 a_49197_2844.n12 a_49197_2844.n11 8.26914
R15052 a_49197_2844.n13 a_49197_2844.n12 8.26914
R15053 a_49197_2844.n14 a_49197_2844.n13 8.26914
R15054 a_49197_2844.n15 a_49197_2844.n14 8.26914
R15055 a_49197_2844.n16 a_49197_2844.n15 8.26914
R15056 a_49197_2844.n17 a_49197_2844.n16 8.26914
R15057 a_49197_2844.n18 a_49197_2844.n17 8.26914
R15058 a_49197_2844.n60 a_49197_2844.n59 8.21666
R15059 a_49197_2844.n64 a_49197_2844.n63 7.84718
R15060 a_49197_2844.n19 a_49197_2844.n18 7.81455
R15061 a_49197_2844.n63 a_49197_2844.n61 7.66561
R15062 a_49197_2844.n52 a_49197_2844.t47 7.53086
R15063 a_49197_2844.n47 a_49197_2844.t42 7.53086
R15064 a_49197_2844.n40 a_49197_2844.t62 7.53086
R15065 a_49197_2844.n53 a_49197_2844.n52 7.34766
R15066 a_49197_2844.n48 a_49197_2844.n47 7.34766
R15067 a_49197_2844.n41 a_49197_2844.n40 7.34766
R15068 a_49197_2844.n42 a_49197_2844.n41 7.34766
R15069 a_49197_2844.n54 a_49197_2844.n53 7.30237
R15070 a_49197_2844.n49 a_49197_2844.n48 7.30237
R15071 a_49197_2844.n55 a_49197_2844.n54 7.25708
R15072 a_49197_2844.n50 a_49197_2844.n49 7.25708
R15073 a_49197_2844.n63 a_49197_2844.n62 7.09966
R15074 a_49197_2844.n57 a_49197_2844.n56 7.05721
R15075 a_49197_2844.n62 a_49197_2844.t4 7.03646
R15076 a_49197_2844.n51 a_49197_2844.n46 6.68774
R15077 a_49197_2844.n58 a_49197_2844.n42 6.35411
R15078 a_49197_2844.n56 a_49197_2844.n55 6.11115
R15079 a_49197_2844.n51 a_49197_2844.n50 6.11115
R15080 a_49197_2844.n59 a_49197_2844.n39 5.96666
R15081 a_49197_2844.n60 a_49197_2844.t49 5.94624
R15082 a_49197_2844.n39 a_49197_2844.n27 5.24751
R15083 a_49197_2844.n59 a_49197_2844.n58 4.5005
R15084 a_49197_2844.n39 a_49197_2844.n38 3.33287
R15085 a_49197_2844.n61 a_49197_2844.n60 1.1716
R15086 a_49197_2844.n58 a_49197_2844.n57 0.994053
R15087 a_49197_2844.n56 a_49197_2844.n51 0.926553
R15088 a_49197_2844.n61 a_49197_2844.t48 0.186113
R15089 a_49197_2844.n62 a_49197_2844.t5 0.186113
R15090 a_49197_2844.n57 a_49197_2844.t66 0.183695
R15091 a_49197_2844.n55 a_49197_2844.t46 0.183695
R15092 a_49197_2844.n54 a_49197_2844.t44 0.183695
R15093 a_49197_2844.n53 a_49197_2844.t50 0.183695
R15094 a_49197_2844.n52 a_49197_2844.t45 0.183695
R15095 a_49197_2844.n50 a_49197_2844.t11 0.183695
R15096 a_49197_2844.n49 a_49197_2844.t7 0.183695
R15097 a_49197_2844.n48 a_49197_2844.t43 0.183695
R15098 a_49197_2844.n47 a_49197_2844.t10 0.183695
R15099 a_49197_2844.n46 a_49197_2844.t6 0.183695
R15100 a_49197_2844.n45 a_49197_2844.t13 0.183695
R15101 a_49197_2844.n44 a_49197_2844.t9 0.183695
R15102 a_49197_2844.n43 a_49197_2844.t12 0.183695
R15103 a_49197_2844.n42 a_49197_2844.t64 0.183695
R15104 a_49197_2844.n41 a_49197_2844.t63 0.183695
R15105 a_49197_2844.n40 a_49197_2844.t65 0.183695
R15106 a_49197_2844.n9 a_49197_2844.t54 0.156216
R15107 a_49197_2844.n8 a_49197_2844.t67 0.156216
R15108 a_49197_2844.n7 a_49197_2844.t53 0.156216
R15109 a_49197_2844.n6 a_49197_2844.t56 0.156216
R15110 a_49197_2844.n5 a_49197_2844.t55 0.156216
R15111 a_49197_2844.n4 a_49197_2844.t14 0.156216
R15112 a_49197_2844.n3 a_49197_2844.t52 0.156216
R15113 a_49197_2844.n2 a_49197_2844.t58 0.156216
R15114 a_49197_2844.n1 a_49197_2844.t57 0.156216
R15115 a_49197_2844.n18 a_49197_2844.t19 0.156216
R15116 a_49197_2844.n17 a_49197_2844.t15 0.156216
R15117 a_49197_2844.n16 a_49197_2844.t18 0.156216
R15118 a_49197_2844.n15 a_49197_2844.t60 0.156216
R15119 a_49197_2844.n14 a_49197_2844.t20 0.156216
R15120 a_49197_2844.n13 a_49197_2844.t59 0.156216
R15121 a_49197_2844.n12 a_49197_2844.t17 0.156216
R15122 a_49197_2844.n11 a_49197_2844.t16 0.156216
R15123 a_49197_2844.n10 a_49197_2844.t61 0.156216
R15124 a_49197_2844.n65 a_49197_2844.n64 0.102113
R15125 a_49197_2844.n21 a_49197_2844.n20 0.0717329
R15126 a_49197_2844.n23 a_49197_2844.n22 0.0717329
R15127 a_49197_2844.n25 a_49197_2844.n24 0.0717329
R15128 a_49197_2844.n27 a_49197_2844.n26 0.0717329
R15129 a_49197_2844.n30 a_49197_2844.n29 0.0717329
R15130 a_49197_2844.n32 a_49197_2844.n31 0.0717329
R15131 a_49197_2844.n34 a_49197_2844.n33 0.0717329
R15132 a_49197_2844.n36 a_49197_2844.n35 0.0717329
R15133 a_49197_2844.n38 a_49197_2844.n37 0.0717329
R15134 a_49197_2844.n0 a_49197_2844.t3 0.0551
R15135 a_49197_2844.n0 a_49197_2844.t1 0.0551
R15136 a_49197_2844.t0 a_49197_2844.n65 0.0551
R15137 a_49197_2844.n65 a_49197_2844.t2 0.0551
R15138 a_49197_2844.n37 a_49197_2844.t40 0.0527989
R15139 a_49197_2844.n37 a_49197_2844.t29 0.0527989
R15140 a_49197_2844.n26 a_49197_2844.t38 0.0527989
R15141 a_49197_2844.n26 a_49197_2844.t27 0.0527989
R15142 a_49197_2844.n24 a_49197_2844.t23 0.0527989
R15143 a_49197_2844.n24 a_49197_2844.t32 0.0527989
R15144 a_49197_2844.n22 a_49197_2844.t26 0.0527989
R15145 a_49197_2844.n22 a_49197_2844.t36 0.0527989
R15146 a_49197_2844.n20 a_49197_2844.t41 0.0527989
R15147 a_49197_2844.n20 a_49197_2844.t30 0.0527989
R15148 a_49197_2844.n35 a_49197_2844.t28 0.0527989
R15149 a_49197_2844.n35 a_49197_2844.t37 0.0527989
R15150 a_49197_2844.n33 a_49197_2844.t24 0.0527989
R15151 a_49197_2844.n33 a_49197_2844.t33 0.0527989
R15152 a_49197_2844.n31 a_49197_2844.t25 0.0527989
R15153 a_49197_2844.n31 a_49197_2844.t35 0.0527989
R15154 a_49197_2844.n29 a_49197_2844.t34 0.0527989
R15155 a_49197_2844.n29 a_49197_2844.t39 0.0527989
R15156 a_49197_2844.n28 a_49197_2844.t31 0.0527989
R15157 a_49197_2844.n28 a_49197_2844.t22 0.0527989
R15158 transmission_gate$2$1_7.out.n26 transmission_gate$2$1_7.out.n25 52.5498
R15159 transmission_gate$2$1_7.out.n27 transmission_gate$2$1_7.out.n26 51.85
R15160 transmission_gate$2$1_7.out.n29 transmission_gate$2$1_7.out.n27 37.3645
R15161 transmission_gate$2$1_7.out.n3 transmission_gate$2$1_7.out.t8 30.6264
R15162 transmission_gate$2$1_7.out.n19 transmission_gate$2$1_7.out.t21 30.6217
R15163 transmission_gate$2$1_7.out.n21 transmission_gate$2$1_7.out.t16 30.6169
R15164 transmission_gate$2$1_7.out.n25 transmission_gate$2$1_7.out.t9 30.5921
R15165 transmission_gate$2$1_7.out transmission_gate$2$1_7.out.t18 30.4906
R15166 transmission_gate$2$1_7.out transmission_gate$2$1_7.out.t13 25.0251
R15167 transmission_gate$2$1_7.out transmission_gate$2$1_7.out.t14 25.0251
R15168 transmission_gate$2$1_7.out.n1 transmission_gate$2$1_7.out.t20 25.0227
R15169 transmission_gate$2$1_7.out.n28 transmission_gate$2$1_7.out.t15 24.9469
R15170 transmission_gate$2$1_7.out.n2 transmission_gate$2$1_7.out.t24 24.9469
R15171 transmission_gate$2$1_7.out.n20 transmission_gate$2$1_7.out.t7 24.9469
R15172 transmission_gate$2$1_7.out.n18 transmission_gate$2$1_7.out.t23 24.9469
R15173 transmission_gate$2$1_7.out.n10 transmission_gate$2$1_7.out.t17 24.9469
R15174 transmission_gate$2$1_7.out.n11 transmission_gate$2$1_7.out.t6 24.9469
R15175 transmission_gate$2$1_7.out.n24 transmission_gate$2$1_7.out.t5 24.9469
R15176 transmission_gate$2$1_7.out.n14 transmission_gate$2$1_7.out.t22 24.9469
R15177 transmission_gate$2$1_7.out.n15 transmission_gate$2$1_7.out.t10 24.9469
R15178 transmission_gate$2$1_7.out.n4 transmission_gate$2$1_7.out.t12 24.9469
R15179 transmission_gate$2$1_7.out.n6 transmission_gate$2$1_7.out.t25 24.9469
R15180 transmission_gate$2$1_7.out.n7 transmission_gate$2$1_7.out.t11 24.9469
R15181 transmission_gate$2$1_7.out.n30 transmission_gate$2$1_7.out.t19 24.9469
R15182 transmission_gate$2$1_7.out.n33 transmission_gate$2$1_7.out.t4 17.5462
R15183 transmission_gate$2$1_7.out.n5 transmission_gate$2$1_7.out 16.8627
R15184 transmission_gate$2$1_7.out.n34 transmission_gate$2$1_7.out.t0 16.7838
R15185 transmission_gate$2$1_7.out.n33 transmission_gate$2$1_7.out.t3 16.7833
R15186 transmission_gate$2$1_7.out transmission_gate$2$1_7.out.t1 12.5567
R15187 transmission_gate$2$1_7.out.n12 transmission_gate$2$1_7.out 12.3139
R15188 transmission_gate$2$1_7.out.n16 transmission_gate$2$1_7.out 12.3104
R15189 transmission_gate$2$1_7.out.n8 transmission_gate$2$1_7.out 12.3082
R15190 transmission_gate$2$1_7.out.n8 transmission_gate$2$1_7.out 12.1739
R15191 transmission_gate$2$1_7.out.n16 transmission_gate$2$1_7.out 12.1717
R15192 transmission_gate$2$1_7.out.n12 transmission_gate$2$1_7.out 12.1682
R15193 transmission_gate$2$1_7.out.n0 transmission_gate$2$1_7.out.t2 12.0263
R15194 transmission_gate$2$1_7.out.n29 transmission_gate$2$1_7.out 10.455
R15195 transmission_gate$2$1_7.out.n22 transmission_gate$2$1_7.out.n21 7.16142
R15196 transmission_gate$2$1_7.out.n22 transmission_gate$2$1_7.out.n19 7.15432
R15197 transmission_gate$2$1_7.out transmission_gate$2$1_7.out.n28 6.06552
R15198 transmission_gate$2$1_7.out transmission_gate$2$1_7.out.n32 5.58854
R15199 transmission_gate$2$1_7.out transmission_gate$2$1_7.out.n30 5.21213
R15200 transmission_gate$2$1_7.out transmission_gate$2$1_7.out.n1 5.12246
R15201 transmission_gate$2$1_7.out transmission_gate$2$1_7.out.n2 4.9055
R15202 transmission_gate$2$1_7.out transmission_gate$2$1_7.out.n20 4.9055
R15203 transmission_gate$2$1_7.out transmission_gate$2$1_7.out.n18 4.9055
R15204 transmission_gate$2$1_7.out transmission_gate$2$1_7.out.n24 4.9055
R15205 transmission_gate$2$1_7.out.n27 transmission_gate$2$1_7.out.n3 4.58932
R15206 transmission_gate$2$1_7.out.n9 transmission_gate$2$1_7.out.n8 4.5005
R15207 transmission_gate$2$1_7.out.n17 transmission_gate$2$1_7.out.n16 4.5005
R15208 transmission_gate$2$1_7.out.n13 transmission_gate$2$1_7.out.n12 4.5005
R15209 transmission_gate$2$1_7.out.n23 transmission_gate$2$1_7.out.n22 4.5005
R15210 transmission_gate$2$1_7.out.n32 transmission_gate$2$1_7.out.n31 4.5005
R15211 transmission_gate$2$1_7.out.n26 transmission_gate$2$1_7.out.n23 4.00787
R15212 transmission_gate$2$1_7.out.n23 transmission_gate$2$1_7.out.n17 3.77458
R15213 transmission_gate$2$1_7.out.n9 transmission_gate$2$1_7.out.n5 3.2405
R15214 transmission_gate$2$1_7.out.n13 transmission_gate$2$1_7.out.n9 3.14221
R15215 transmission_gate$2$1_7.out.n17 transmission_gate$2$1_7.out.n13 3.09603
R15216 transmission_gate$2$1_7.out.n5 transmission_gate$2$1_7.out 2.453
R15217 transmission_gate$2$1_7.out.n32 transmission_gate$2$1_7.out.n0 1.24764
R15218 transmission_gate$2$1_7.out transmission_gate$2$1_7.out.n34 0.947107
R15219 transmission_gate$2$1_7.out.n34 transmission_gate$2$1_7.out 0.424786
R15220 transmission_gate$2$1_7.out.n0 transmission_gate$2$1_7.out 0.2411
R15221 transmission_gate$2$1_7.out.n31 transmission_gate$2$1_7.out.n29 0.167643
R15222 transmission_gate$2$1_7.out.n31 transmission_gate$2$1_7.out 0.153179
R15223 transmission_gate$2$1_7.out transmission_gate$2$1_7.out.n33 0.140321
R15224 transmission_gate$2$1_7.out.n25 transmission_gate$2$1_7.out 0.123658
R15225 transmission_gate$2$1_7.out.n21 transmission_gate$2$1_7.out 0.0987895
R15226 transmission_gate$2$1_7.out.n19 transmission_gate$2$1_7.out 0.0940526
R15227 transmission_gate$2$1_7.out.n3 transmission_gate$2$1_7.out 0.0893158
R15228 transmission_gate$2$1_7.out.n28 transmission_gate$2$1_7.out 0.0751053
R15229 transmission_gate$2$1_7.out.n30 transmission_gate$2$1_7.out 0.0751053
R15230 transmission_gate$2$1_7.out.n1 transmission_gate$2$1_7.out 0.00878947
R15231 transmission_gate$2$1_7.out.n2 transmission_gate$2$1_7.out 0.00760526
R15232 transmission_gate$2$1_7.out.n20 transmission_gate$2$1_7.out 0.00760526
R15233 transmission_gate$2$1_7.out.n18 transmission_gate$2$1_7.out 0.00760526
R15234 transmission_gate$2$1_7.out.n10 transmission_gate$2$1_7.out 0.00760526
R15235 transmission_gate$2$1_7.out.n11 transmission_gate$2$1_7.out 0.00760526
R15236 transmission_gate$2$1_7.out.n24 transmission_gate$2$1_7.out 0.00760526
R15237 transmission_gate$2$1_7.out.n14 transmission_gate$2$1_7.out 0.00760526
R15238 transmission_gate$2$1_7.out.n15 transmission_gate$2$1_7.out 0.00760526
R15239 transmission_gate$2$1_7.out.n4 transmission_gate$2$1_7.out 0.00760526
R15240 transmission_gate$2$1_7.out.n6 transmission_gate$2$1_7.out 0.00760526
R15241 transmission_gate$2$1_7.out.n7 transmission_gate$2$1_7.out 0.00760526
R15242 transmission_gate$2$1_7.out transmission_gate$2$1_7.out.n10 0.00405263
R15243 transmission_gate$2$1_7.out transmission_gate$2$1_7.out.n11 0.00405263
R15244 transmission_gate$2$1_7.out transmission_gate$2$1_7.out.n14 0.00405263
R15245 transmission_gate$2$1_7.out transmission_gate$2$1_7.out.n15 0.00405263
R15246 transmission_gate$2$1_7.out transmission_gate$2$1_7.out.n4 0.00405263
R15247 transmission_gate$2$1_7.out transmission_gate$2$1_7.out.n6 0.00405263
R15248 transmission_gate$2$1_7.out transmission_gate$2$1_7.out.n7 0.00405263
R15249 transmission_gate$2$1_7.out.n29 transmission_gate$2$1_7.out 0.00371429
R15250 programmable_folded_cascode_0.programmable_pfet_0.transmission_gate$16_0.out.t6 programmable_folded_cascode_0.programmable_pfet_0.transmission_gate$16_0.out.t12 264.151
R15251 programmable_folded_cascode_0.programmable_pfet_0.transmission_gate$16_0.out.t11 programmable_folded_cascode_0.programmable_pfet_0.transmission_gate$16_0.out.t5 264.115
R15252 programmable_folded_cascode_0.programmable_pfet_0.transmission_gate$16_0.out.t12 programmable_folded_cascode_0.programmable_pfet_0.transmission_gate$16_0.out.t11 264.115
R15253 programmable_folded_cascode_0.programmable_pfet_0.transmission_gate$16_0.out.t3 programmable_folded_cascode_0.programmable_pfet_0.transmission_gate$16_0.out.t6 264.115
R15254 programmable_folded_cascode_0.programmable_pfet_0.transmission_gate$16_0.out.t9 programmable_folded_cascode_0.programmable_pfet_0.transmission_gate$16_0.out.t3 264.115
R15255 programmable_folded_cascode_0.programmable_pfet_0.transmission_gate$16_0.out.t10 programmable_folded_cascode_0.programmable_pfet_0.transmission_gate$16_0.out.t9 264.115
R15256 programmable_folded_cascode_0.programmable_pfet_0.transmission_gate$16_0.out.t7 programmable_folded_cascode_0.programmable_pfet_0.transmission_gate$16_0.out.t10 264.115
R15257 programmable_folded_cascode_0.programmable_pfet_0.transmission_gate$16_0.out.t4 programmable_folded_cascode_0.programmable_pfet_0.transmission_gate$16_0.out.t7 264.115
R15258 programmable_folded_cascode_0.programmable_pfet_0.transmission_gate$16_0.out.t8 programmable_folded_cascode_0.programmable_pfet_0.transmission_gate$16_0.out.t4 264.115
R15259 programmable_folded_cascode_0.programmable_pfet_0.transmission_gate$16_0.out.n0 programmable_folded_cascode_0.programmable_pfet_0.transmission_gate$16_0.out.t8 138.597
R15260 programmable_folded_cascode_0.programmable_pfet_0.transmission_gate$16_0.out.n0 programmable_folded_cascode_0.programmable_pfet_0.transmission_gate$16_0.out.t2 22.607
R15261 programmable_folded_cascode_0.programmable_pfet_0.transmission_gate$16_0.out.n1 programmable_folded_cascode_0.programmable_pfet_0.transmission_gate$16_0.out.t1 12.5243
R15262 programmable_folded_cascode_0.programmable_pfet_0.transmission_gate$16_0.out programmable_folded_cascode_0.programmable_pfet_0.transmission_gate$16_0.out.t0 12.2669
R15263 programmable_folded_cascode_0.programmable_pfet_0.transmission_gate$16_0.out.n1 programmable_folded_cascode_0.programmable_pfet_0.transmission_gate$16_0.out.n0 10.3256
R15264 programmable_folded_cascode_0.programmable_pfet_0.transmission_gate$16_0.out programmable_folded_cascode_0.programmable_pfet_0.transmission_gate$16_0.out.n1 0.0329
R15265 programmable_folded_cascode_0.programmable_pfet_0.g.t38 programmable_folded_cascode_0.programmable_pfet_0.g.t33 264.151
R15266 programmable_folded_cascode_0.programmable_pfet_0.g.t26 programmable_folded_cascode_0.programmable_pfet_0.g.t37 264.151
R15267 programmable_folded_cascode_0.programmable_pfet_0.g.t33 programmable_folded_cascode_0.programmable_pfet_0.g.t34 264.115
R15268 programmable_folded_cascode_0.programmable_pfet_0.g.t19 programmable_folded_cascode_0.programmable_pfet_0.g.t38 264.115
R15269 programmable_folded_cascode_0.programmable_pfet_0.g.t37 programmable_folded_cascode_0.programmable_pfet_0.g.t31 264.115
R15270 programmable_folded_cascode_0.programmable_pfet_0.g.t27 programmable_folded_cascode_0.programmable_pfet_0.g.t26 264.115
R15271 programmable_folded_cascode_0.programmable_pfet_0.g.t22 programmable_folded_cascode_0.programmable_pfet_0.g.t27 264.115
R15272 programmable_folded_cascode_0.programmable_pfet_0.g.t30 programmable_folded_cascode_0.programmable_pfet_0.g.t22 264.115
R15273 programmable_folded_cascode_0.programmable_pfet_0.g.t32 programmable_folded_cascode_0.programmable_pfet_0.g.t30 264.115
R15274 programmable_folded_cascode_0.programmable_pfet_0.g.t28 programmable_folded_cascode_0.programmable_pfet_0.g.t32 264.115
R15275 programmable_folded_cascode_0.programmable_pfet_0.g.t24 programmable_folded_cascode_0.programmable_pfet_0.g.t28 264.115
R15276 programmable_folded_cascode_0.programmable_pfet_0.g.t29 programmable_folded_cascode_0.programmable_pfet_0.g.t24 264.115
R15277 programmable_folded_cascode_0.programmable_pfet_0.g.t2 programmable_folded_cascode_0.programmable_pfet_0.g.t4 184.571
R15278 programmable_folded_cascode_0.programmable_pfet_0.g.t10 programmable_folded_cascode_0.programmable_pfet_0.g.t2 184.571
R15279 programmable_folded_cascode_0.programmable_pfet_0.g.t6 programmable_folded_cascode_0.programmable_pfet_0.g.t10 184.571
R15280 programmable_folded_cascode_0.programmable_pfet_0.g.t8 programmable_folded_cascode_0.programmable_pfet_0.g.t6 184.571
R15281 programmable_folded_cascode_0.programmable_pfet_0.g.n24 programmable_folded_cascode_0.programmable_pfet_0.g.t29 138.757
R15282 programmable_folded_cascode_0.programmable_pfet_0.g.n20 programmable_folded_cascode_0.programmable_pfet_0.g.t21 138.597
R15283 programmable_folded_cascode_0.programmable_pfet_0.g.n10 programmable_folded_cascode_0.programmable_pfet_0.g.t35 133.518
R15284 programmable_folded_cascode_0.programmable_pfet_0.g.t23 programmable_folded_cascode_0.programmable_pfet_0.g.n13 133.518
R15285 programmable_folded_cascode_0.programmable_pfet_0.g.t25 programmable_folded_cascode_0.programmable_pfet_0.g.n14 133.518
R15286 programmable_folded_cascode_0.programmable_pfet_0.g.n15 programmable_folded_cascode_0.programmable_pfet_0.g.t20 133.518
R15287 programmable_folded_cascode_0.programmable_pfet_0.g.t36 programmable_folded_cascode_0.programmable_pfet_0.g.n18 133.518
R15288 programmable_folded_cascode_0.programmable_pfet_0.g.t21 programmable_folded_cascode_0.programmable_pfet_0.g.n19 133.518
R15289 programmable_folded_cascode_0.programmable_pfet_0.g.n10 programmable_folded_cascode_0.programmable_pfet_0.g.t19 130.597
R15290 programmable_folded_cascode_0.programmable_pfet_0.g.n13 programmable_folded_cascode_0.programmable_pfet_0.g.t35 130.597
R15291 programmable_folded_cascode_0.programmable_pfet_0.g.n14 programmable_folded_cascode_0.programmable_pfet_0.g.t23 130.597
R15292 programmable_folded_cascode_0.programmable_pfet_0.g.n15 programmable_folded_cascode_0.programmable_pfet_0.g.t25 130.597
R15293 programmable_folded_cascode_0.programmable_pfet_0.g.n18 programmable_folded_cascode_0.programmable_pfet_0.g.t20 130.597
R15294 programmable_folded_cascode_0.programmable_pfet_0.g.n19 programmable_folded_cascode_0.programmable_pfet_0.g.t36 130.597
R15295 programmable_folded_cascode_0.programmable_pfet_0.g.n9 programmable_folded_cascode_0.programmable_pfet_0.g.t8 95.5299
R15296 programmable_folded_cascode_0.programmable_pfet_0.g.n11 programmable_folded_cascode_0.programmable_pfet_0.g.n9 32.9788
R15297 programmable_folded_cascode_0.programmable_pfet_0.g.n6 programmable_folded_cascode_0.programmable_pfet_0.g.t0 15.658
R15298 programmable_folded_cascode_0.programmable_pfet_0.g.n25 programmable_folded_cascode_0.programmable_pfet_0.g.n24 12.9333
R15299 programmable_folded_cascode_0.programmable_pfet_0.g.n22 programmable_folded_cascode_0.programmable_pfet_0.g.t13 12.487
R15300 programmable_folded_cascode_0.programmable_pfet_0.g.n1 programmable_folded_cascode_0.programmable_pfet_0.g.t12 12.487
R15301 programmable_folded_cascode_0.programmable_pfet_0.g.n21 programmable_folded_cascode_0.programmable_pfet_0.g.t16 12.4859
R15302 programmable_folded_cascode_0.programmable_pfet_0.g.n0 programmable_folded_cascode_0.programmable_pfet_0.g.t18 12.4859
R15303 programmable_folded_cascode_0.programmable_pfet_0.g programmable_folded_cascode_0.programmable_pfet_0.g.t1 12.2496
R15304 programmable_folded_cascode_0.programmable_pfet_0.g programmable_folded_cascode_0.programmable_pfet_0.g.t14 12.2496
R15305 programmable_folded_cascode_0.programmable_pfet_0.g programmable_folded_cascode_0.programmable_pfet_0.g.t17 12.2496
R15306 programmable_folded_cascode_0.programmable_pfet_0.g programmable_folded_cascode_0.programmable_pfet_0.g.t15 12.2496
R15307 programmable_folded_cascode_0.programmable_pfet_0.g.n9 programmable_folded_cascode_0.programmable_pfet_0.g.n8 12.0953
R15308 programmable_folded_cascode_0.programmable_pfet_0.g.n17 programmable_folded_cascode_0.programmable_pfet_0.g.n2 8.56945
R15309 programmable_folded_cascode_0.programmable_pfet_0.g.n17 programmable_folded_cascode_0.programmable_pfet_0.g.n16 8.56945
R15310 programmable_folded_cascode_0.programmable_pfet_0.g.n16 programmable_folded_cascode_0.programmable_pfet_0.g.n3 8.56945
R15311 programmable_folded_cascode_0.programmable_pfet_0.g.n12 programmable_folded_cascode_0.programmable_pfet_0.g.n3 8.56945
R15312 programmable_folded_cascode_0.programmable_pfet_0.g.n12 programmable_folded_cascode_0.programmable_pfet_0.g.n11 8.56945
R15313 programmable_folded_cascode_0.programmable_pfet_0.g.n20 programmable_folded_cascode_0.programmable_pfet_0.g.n2 8.56885
R15314 programmable_folded_cascode_0.programmable_pfet_0.g.n19 programmable_folded_cascode_0.programmable_pfet_0.g.n2 8.0005
R15315 programmable_folded_cascode_0.programmable_pfet_0.g.n18 programmable_folded_cascode_0.programmable_pfet_0.g.n17 8.0005
R15316 programmable_folded_cascode_0.programmable_pfet_0.g.n16 programmable_folded_cascode_0.programmable_pfet_0.g.n15 8.0005
R15317 programmable_folded_cascode_0.programmable_pfet_0.g.n14 programmable_folded_cascode_0.programmable_pfet_0.g.n3 8.0005
R15318 programmable_folded_cascode_0.programmable_pfet_0.g.n13 programmable_folded_cascode_0.programmable_pfet_0.g.n12 8.0005
R15319 programmable_folded_cascode_0.programmable_pfet_0.g.n11 programmable_folded_cascode_0.programmable_pfet_0.g.n10 8.0005
R15320 programmable_folded_cascode_0.programmable_pfet_0.g.n4 programmable_folded_cascode_0.programmable_pfet_0.g.t5 6.01087
R15321 programmable_folded_cascode_0.programmable_pfet_0.g.n8 programmable_folded_cascode_0.programmable_pfet_0.g.n7 5.77471
R15322 programmable_folded_cascode_0.programmable_pfet_0.g.n5 programmable_folded_cascode_0.programmable_pfet_0.g.n4 5.77471
R15323 programmable_folded_cascode_0.programmable_pfet_0.g.n24 programmable_folded_cascode_0.programmable_pfet_0.g.n23 5.02629
R15324 programmable_folded_cascode_0.programmable_pfet_0.g.n26 programmable_folded_cascode_0.programmable_pfet_0.g.n25 5.02629
R15325 programmable_folded_cascode_0.programmable_pfet_0.g.n6 programmable_folded_cascode_0.programmable_pfet_0.g.n5 4.97537
R15326 programmable_folded_cascode_0.programmable_pfet_0.g programmable_folded_cascode_0.programmable_pfet_0.g.n21 4.76124
R15327 programmable_folded_cascode_0.programmable_pfet_0.g programmable_folded_cascode_0.programmable_pfet_0.g.n0 4.76124
R15328 programmable_folded_cascode_0.programmable_pfet_0.g.n23 programmable_folded_cascode_0.programmable_pfet_0.g.n22 4.72021
R15329 programmable_folded_cascode_0.programmable_pfet_0.g.n26 programmable_folded_cascode_0.programmable_pfet_0.g.n1 4.72021
R15330 programmable_folded_cascode_0.programmable_pfet_0.g.n7 programmable_folded_cascode_0.programmable_pfet_0.g.n6 0.799842
R15331 programmable_folded_cascode_0.programmable_pfet_0.g.n8 programmable_folded_cascode_0.programmable_pfet_0.g.t9 0.236659
R15332 programmable_folded_cascode_0.programmable_pfet_0.g.n7 programmable_folded_cascode_0.programmable_pfet_0.g.t7 0.236659
R15333 programmable_folded_cascode_0.programmable_pfet_0.g.n5 programmable_folded_cascode_0.programmable_pfet_0.g.t11 0.236659
R15334 programmable_folded_cascode_0.programmable_pfet_0.g.n4 programmable_folded_cascode_0.programmable_pfet_0.g.t3 0.236659
R15335 programmable_folded_cascode_0.programmable_pfet_0.g.n25 programmable_folded_cascode_0.programmable_pfet_0.g.n20 0.160953
R15336 programmable_folded_cascode_0.programmable_pfet_0.g.n21 programmable_folded_cascode_0.programmable_pfet_0.g 0.0417048
R15337 programmable_folded_cascode_0.programmable_pfet_0.g.n0 programmable_folded_cascode_0.programmable_pfet_0.g 0.0417048
R15338 programmable_folded_cascode_0.programmable_pfet_0.g.n22 programmable_folded_cascode_0.programmable_pfet_0.g 0.0406205
R15339 programmable_folded_cascode_0.programmable_pfet_0.g.n1 programmable_folded_cascode_0.programmable_pfet_0.g 0.0406205
R15340 programmable_folded_cascode_0.programmable_pfet_0.g.n23 programmable_folded_cascode_0.programmable_pfet_0.g 0.0203529
R15341 programmable_folded_cascode_0.programmable_pfet_0.g programmable_folded_cascode_0.programmable_pfet_0.g.n26 0.0203529
R15342 programmable_telescopic_cascode_0.programmable_nfet$6_0.transmission_gate$26_0.out.t6 programmable_telescopic_cascode_0.programmable_nfet$6_0.transmission_gate$26_0.out.t4 204.911
R15343 programmable_telescopic_cascode_0.programmable_nfet$6_0.transmission_gate$26_0.out.t3 programmable_telescopic_cascode_0.programmable_nfet$6_0.transmission_gate$26_0.out.t5 204.911
R15344 programmable_telescopic_cascode_0.programmable_nfet$6_0.transmission_gate$26_0.out.n0 programmable_telescopic_cascode_0.programmable_nfet$6_0.transmission_gate$26_0.out.t3 114.921
R15345 programmable_telescopic_cascode_0.programmable_nfet$6_0.transmission_gate$26_0.out.n1 programmable_telescopic_cascode_0.programmable_nfet$6_0.transmission_gate$26_0.out.t6 114.921
R15346 programmable_telescopic_cascode_0.programmable_nfet$6_0.transmission_gate$26_0.out.n0 programmable_telescopic_cascode_0.programmable_nfet$6_0.transmission_gate$26_0.out.t0 17.4912
R15347 programmable_telescopic_cascode_0.programmable_nfet$6_0.transmission_gate$26_0.out.n2 programmable_telescopic_cascode_0.programmable_nfet$6_0.transmission_gate$26_0.out.t1 12.3005
R15348 programmable_telescopic_cascode_0.programmable_nfet$6_0.transmission_gate$26_0.out programmable_telescopic_cascode_0.programmable_nfet$6_0.transmission_gate$26_0.out.t2 12.2669
R15349 programmable_telescopic_cascode_0.programmable_nfet$6_0.transmission_gate$26_0.out.n2 programmable_telescopic_cascode_0.programmable_nfet$6_0.transmission_gate$26_0.out.n1 5.33661
R15350 programmable_telescopic_cascode_0.programmable_nfet$6_0.transmission_gate$26_0.out.n1 programmable_telescopic_cascode_0.programmable_nfet$6_0.transmission_gate$26_0.out.n0 0.356994
R15351 programmable_telescopic_cascode_0.programmable_nfet$6_0.transmission_gate$26_0.out programmable_telescopic_cascode_0.programmable_nfet$6_0.transmission_gate$26_0.out.n2 0.2567
R15352 programmable_telescopic_cascode_0.programmable_nfet$6_0.d.n7 programmable_telescopic_cascode_0.programmable_nfet$6_0.d.n6 9.4964
R15353 programmable_telescopic_cascode_0.programmable_nfet$6_0.d programmable_telescopic_cascode_0.programmable_nfet$6_0.d.n2 8.43214
R15354 programmable_telescopic_cascode_0.programmable_nfet$6_0.d programmable_telescopic_cascode_0.programmable_nfet$6_0.d.t4 8.23136
R15355 programmable_telescopic_cascode_0.programmable_nfet$6_0.d.n5 programmable_telescopic_cascode_0.programmable_nfet$6_0.d.n4 8.21881
R15356 programmable_telescopic_cascode_0.programmable_nfet$6_0.d.n13 programmable_telescopic_cascode_0.programmable_nfet$6_0.d.t0 7.76743
R15357 programmable_telescopic_cascode_0.programmable_nfet$6_0.d.n11 programmable_telescopic_cascode_0.programmable_nfet$6_0.d.t1 7.76743
R15358 programmable_telescopic_cascode_0.programmable_nfet$6_0.d.n8 programmable_telescopic_cascode_0.programmable_nfet$6_0.d.t15 7.76743
R15359 programmable_telescopic_cascode_0.programmable_nfet$6_0.d.n12 programmable_telescopic_cascode_0.programmable_nfet$6_0.d.t2 7.76624
R15360 programmable_telescopic_cascode_0.programmable_nfet$6_0.d.n10 programmable_telescopic_cascode_0.programmable_nfet$6_0.d.t9 7.76506
R15361 programmable_telescopic_cascode_0.programmable_nfet$6_0.d.n9 programmable_telescopic_cascode_0.programmable_nfet$6_0.d.t3 7.76506
R15362 programmable_telescopic_cascode_0.programmable_nfet$6_0.d.n4 programmable_telescopic_cascode_0.programmable_nfet$6_0.d.n3 7.52024
R15363 programmable_telescopic_cascode_0.programmable_nfet$6_0.d.n3 programmable_telescopic_cascode_0.programmable_nfet$6_0.d.t6 6.85217
R15364 programmable_telescopic_cascode_0.programmable_nfet$6_0.d.n2 programmable_telescopic_cascode_0.programmable_nfet$6_0.d.n0 6.75918
R15365 programmable_telescopic_cascode_0.programmable_nfet$6_0.d.n8 programmable_telescopic_cascode_0.programmable_nfet$6_0.d.n7 5.9674
R15366 programmable_telescopic_cascode_0.programmable_nfet$6_0.d.n6 programmable_telescopic_cascode_0.programmable_nfet$6_0.d.n5 4.23287
R15367 programmable_telescopic_cascode_0.programmable_nfet$6_0.d.n6 programmable_telescopic_cascode_0.programmable_nfet$6_0.d.t8 2.6198
R15368 programmable_telescopic_cascode_0.programmable_nfet$6_0.d.n7 programmable_telescopic_cascode_0.programmable_nfet$6_0.d.t14 2.29756
R15369 programmable_telescopic_cascode_0.programmable_nfet$6_0.d.n13 programmable_telescopic_cascode_0.programmable_nfet$6_0.d.n12 1.02907
R15370 programmable_telescopic_cascode_0.programmable_nfet$6_0.d.n12 programmable_telescopic_cascode_0.programmable_nfet$6_0.d.n11 0.498714
R15371 programmable_telescopic_cascode_0.programmable_nfet$6_0.d programmable_telescopic_cascode_0.programmable_nfet$6_0.d.n13 0.464429
R15372 programmable_telescopic_cascode_0.programmable_nfet$6_0.d.n9 programmable_telescopic_cascode_0.programmable_nfet$6_0.d.n8 0.3155
R15373 programmable_telescopic_cascode_0.programmable_nfet$6_0.d.n11 programmable_telescopic_cascode_0.programmable_nfet$6_0.d.n10 0.3155
R15374 programmable_telescopic_cascode_0.programmable_nfet$6_0.d.n5 programmable_telescopic_cascode_0.programmable_nfet$6_0.d.t7 0.204015
R15375 programmable_telescopic_cascode_0.programmable_nfet$6_0.d.n3 programmable_telescopic_cascode_0.programmable_nfet$6_0.d.t5 0.204015
R15376 programmable_telescopic_cascode_0.programmable_nfet$6_0.d.n4 programmable_telescopic_cascode_0.programmable_nfet$6_0.d 0.147286
R15377 programmable_telescopic_cascode_0.programmable_nfet$6_0.d programmable_telescopic_cascode_0.programmable_nfet$6_0.d.n9 0.131214
R15378 programmable_telescopic_cascode_0.programmable_nfet$6_0.d.n10 programmable_telescopic_cascode_0.programmable_nfet$6_0.d 0.131214
R15379 programmable_telescopic_cascode_0.programmable_nfet$6_0.d.n2 programmable_telescopic_cascode_0.programmable_nfet$6_0.d.n1 0.111026
R15380 programmable_telescopic_cascode_0.programmable_nfet$6_0.d.n0 programmable_telescopic_cascode_0.programmable_nfet$6_0.d.t13 0.0609428
R15381 programmable_telescopic_cascode_0.programmable_nfet$6_0.d.n0 programmable_telescopic_cascode_0.programmable_nfet$6_0.d.t10 0.0609428
R15382 programmable_telescopic_cascode_0.programmable_nfet$6_0.d.n1 programmable_telescopic_cascode_0.programmable_nfet$6_0.d.t11 0.0609428
R15383 programmable_telescopic_cascode_0.programmable_nfet$6_0.d.n1 programmable_telescopic_cascode_0.programmable_nfet$6_0.d.t12 0.0609428
R15384 programmable_telescopic_cascode_0.programmable_nfet$4_0.g.t19 programmable_telescopic_cascode_0.programmable_nfet$4_0.g.t23 838.953
R15385 programmable_telescopic_cascode_0.programmable_nfet$4_0.g.t13 programmable_telescopic_cascode_0.programmable_nfet$4_0.g.t19 838.953
R15386 programmable_telescopic_cascode_0.programmable_nfet$4_0.g.t17 programmable_telescopic_cascode_0.programmable_nfet$4_0.g.t13 838.953
R15387 programmable_telescopic_cascode_0.programmable_nfet$4_0.g.t11 programmable_telescopic_cascode_0.programmable_nfet$4_0.g.t17 838.953
R15388 programmable_telescopic_cascode_0.programmable_nfet$4_0.g.t15 programmable_telescopic_cascode_0.programmable_nfet$4_0.g.t11 838.953
R15389 programmable_telescopic_cascode_0.programmable_nfet$4_0.g.t22 programmable_telescopic_cascode_0.programmable_nfet$4_0.g.t12 838.953
R15390 programmable_telescopic_cascode_0.programmable_nfet$4_0.g.t16 programmable_telescopic_cascode_0.programmable_nfet$4_0.g.t22 838.953
R15391 programmable_telescopic_cascode_0.programmable_nfet$4_0.g.t21 programmable_telescopic_cascode_0.programmable_nfet$4_0.g.t16 838.953
R15392 programmable_telescopic_cascode_0.programmable_nfet$4_0.g.t14 programmable_telescopic_cascode_0.programmable_nfet$4_0.g.t21 838.953
R15393 programmable_telescopic_cascode_0.programmable_nfet$4_0.g.t18 programmable_telescopic_cascode_0.programmable_nfet$4_0.g.t14 838.953
R15394 programmable_telescopic_cascode_0.programmable_nfet$4_0.g.n7 programmable_telescopic_cascode_0.programmable_nfet$4_0.g.t20 530.659
R15395 programmable_telescopic_cascode_0.programmable_nfet$4_0.g.n5 programmable_telescopic_cascode_0.programmable_nfet$4_0.g.t9 526.154
R15396 programmable_telescopic_cascode_0.programmable_nfet$4_0.g.n9 programmable_telescopic_cascode_0.programmable_nfet$4_0.g.t15 427.385
R15397 programmable_telescopic_cascode_0.programmable_nfet$4_0.g.n4 programmable_telescopic_cascode_0.programmable_nfet$4_0.g.t18 427.385
R15398 programmable_telescopic_cascode_0.programmable_nfet$4_0.g.n8 programmable_telescopic_cascode_0.programmable_nfet$4_0.g.n7 68.5214
R15399 programmable_telescopic_cascode_0.programmable_nfet$4_0.g.n5 programmable_telescopic_cascode_0.programmable_nfet$4_0.g.t2 13.4149
R15400 programmable_telescopic_cascode_0.programmable_nfet$4_0.g.n6 programmable_telescopic_cascode_0.programmable_nfet$4_0.g.t10 13.0227
R15401 programmable_telescopic_cascode_0.programmable_nfet$4_0.g.n2 programmable_telescopic_cascode_0.programmable_nfet$4_0.g.t1 12.513
R15402 programmable_telescopic_cascode_0.programmable_nfet$4_0.g.n11 programmable_telescopic_cascode_0.programmable_nfet$4_0.g.t0 12.513
R15403 programmable_telescopic_cascode_0.programmable_nfet$4_0.g.n0 programmable_telescopic_cascode_0.programmable_nfet$4_0.g.t7 12.5087
R15404 programmable_telescopic_cascode_0.programmable_nfet$4_0.g.n1 programmable_telescopic_cascode_0.programmable_nfet$4_0.g.t8 12.5087
R15405 programmable_telescopic_cascode_0.programmable_nfet$4_0.g programmable_telescopic_cascode_0.programmable_nfet$4_0.g.t6 12.2496
R15406 programmable_telescopic_cascode_0.programmable_nfet$4_0.g programmable_telescopic_cascode_0.programmable_nfet$4_0.g.t3 12.2496
R15407 programmable_telescopic_cascode_0.programmable_nfet$4_0.g programmable_telescopic_cascode_0.programmable_nfet$4_0.g.t5 12.2496
R15408 programmable_telescopic_cascode_0.programmable_nfet$4_0.g programmable_telescopic_cascode_0.programmable_nfet$4_0.g.t4 12.2496
R15409 programmable_telescopic_cascode_0.programmable_nfet$4_0.g.n9 programmable_telescopic_cascode_0.programmable_nfet$4_0.g.n8 7.12346
R15410 programmable_telescopic_cascode_0.programmable_nfet$4_0.g.n8 programmable_telescopic_cascode_0.programmable_nfet$4_0.g.n4 6.90166
R15411 programmable_telescopic_cascode_0.programmable_nfet$4_0.g programmable_telescopic_cascode_0.programmable_nfet$4_0.g.n3 4.84037
R15412 programmable_telescopic_cascode_0.programmable_nfet$4_0.g.n10 programmable_telescopic_cascode_0.programmable_nfet$4_0.g 4.84037
R15413 programmable_telescopic_cascode_0.programmable_nfet$4_0.g.n3 programmable_telescopic_cascode_0.programmable_nfet$4_0.g.n2 4.73379
R15414 programmable_telescopic_cascode_0.programmable_nfet$4_0.g.n11 programmable_telescopic_cascode_0.programmable_nfet$4_0.g.n10 4.73379
R15415 programmable_telescopic_cascode_0.programmable_nfet$4_0.g.n3 programmable_telescopic_cascode_0.programmable_nfet$4_0.g.n1 4.72195
R15416 programmable_telescopic_cascode_0.programmable_nfet$4_0.g.n10 programmable_telescopic_cascode_0.programmable_nfet$4_0.g.n0 4.72195
R15417 programmable_telescopic_cascode_0.programmable_nfet$4_0.g.n6 programmable_telescopic_cascode_0.programmable_nfet$4_0.g.n5 4.67103
R15418 programmable_telescopic_cascode_0.programmable_nfet$4_0.g.n7 programmable_telescopic_cascode_0.programmable_nfet$4_0.g.n6 0.759579
R15419 programmable_telescopic_cascode_0.programmable_nfet$4_0.g.n4 programmable_telescopic_cascode_0.programmable_nfet$4_0.g 0.428
R15420 programmable_telescopic_cascode_0.programmable_nfet$4_0.g programmable_telescopic_cascode_0.programmable_nfet$4_0.g.n9 0.428
R15421 programmable_telescopic_cascode_0.programmable_nfet$4_0.g.n0 programmable_telescopic_cascode_0.programmable_nfet$4_0.g 0.0189337
R15422 programmable_telescopic_cascode_0.programmable_nfet$4_0.g.n1 programmable_telescopic_cascode_0.programmable_nfet$4_0.g 0.0189337
R15423 programmable_telescopic_cascode_0.programmable_nfet$4_0.g.n2 programmable_telescopic_cascode_0.programmable_nfet$4_0.g 0.0145964
R15424 programmable_telescopic_cascode_0.programmable_nfet$4_0.g programmable_telescopic_cascode_0.programmable_nfet$4_0.g.n11 0.0145964
R15425 OUT_TELESCOPIC.n69 OUT_TELESCOPIC.n68 61.2467
R15426 OUT_TELESCOPIC.n33 OUT_TELESCOPIC.n31 19.9544
R15427 OUT_TELESCOPIC.n37 OUT_TELESCOPIC.n35 19.8881
R15428 OUT_TELESCOPIC.n35 OUT_TELESCOPIC.n33 19.8881
R15429 OUT_TELESCOPIC.n39 OUT_TELESCOPIC.n37 19.8881
R15430 OUT_TELESCOPIC.n51 OUT_TELESCOPIC.n39 17.2923
R15431 OUT_TELESCOPIC.n61 OUT_TELESCOPIC.n60 16.8033
R15432 OUT_TELESCOPIC OUT_TELESCOPIC.n69 13.8293
R15433 OUT_TELESCOPIC.n53 OUT_TELESCOPIC.n52 12.8105
R15434 OUT_TELESCOPIC.n26 OUT_TELESCOPIC.t23 11.574
R15435 OUT_TELESCOPIC.n62 OUT_TELESCOPIC.t13 11.574
R15436 OUT_TELESCOPIC.n60 OUT_TELESCOPIC.n58 11.4601
R15437 OUT_TELESCOPIC.n58 OUT_TELESCOPIC.n56 11.4589
R15438 OUT_TELESCOPIC.n64 OUT_TELESCOPIC.n63 11.4589
R15439 OUT_TELESCOPIC.n63 OUT_TELESCOPIC.n62 11.4589
R15440 OUT_TELESCOPIC.n28 OUT_TELESCOPIC.n27 11.4589
R15441 OUT_TELESCOPIC.n27 OUT_TELESCOPIC.n26 11.4589
R15442 OUT_TELESCOPIC.n56 OUT_TELESCOPIC.n54 10.5155
R15443 OUT_TELESCOPIC.n40 OUT_TELESCOPIC.t8 10.5057
R15444 OUT_TELESCOPIC.n45 OUT_TELESCOPIC.t27 10.5057
R15445 OUT_TELESCOPIC.n58 OUT_TELESCOPIC.n57 10.0489
R15446 OUT_TELESCOPIC.n56 OUT_TELESCOPIC.n55 10.0489
R15447 OUT_TELESCOPIC.n60 OUT_TELESCOPIC.n59 10.0478
R15448 OUT_TELESCOPIC.n41 OUT_TELESCOPIC.n40 9.87873
R15449 OUT_TELESCOPIC.n42 OUT_TELESCOPIC.n41 9.87873
R15450 OUT_TELESCOPIC.n43 OUT_TELESCOPIC.n42 9.87873
R15451 OUT_TELESCOPIC.n46 OUT_TELESCOPIC.n45 9.87873
R15452 OUT_TELESCOPIC.n47 OUT_TELESCOPIC.n46 9.87873
R15453 OUT_TELESCOPIC.n48 OUT_TELESCOPIC.n47 9.87873
R15454 OUT_TELESCOPIC.n44 OUT_TELESCOPIC.n43 7.78764
R15455 OUT_TELESCOPIC.n49 OUT_TELESCOPIC.n48 7.78646
R15456 OUT_TELESCOPIC.n65 OUT_TELESCOPIC.n64 6.80853
R15457 OUT_TELESCOPIC.n67 OUT_TELESCOPIC.n28 6.80853
R15458 OUT_TELESCOPIC.n23 OUT_TELESCOPIC.n11 5.88027
R15459 OUT_TELESCOPIC.n66 OUT_TELESCOPIC.n61 5.70603
R15460 OUT_TELESCOPIC.n51 OUT_TELESCOPIC 5.18086
R15461 OUT_TELESCOPIC.n67 OUT_TELESCOPIC 5.16247
R15462 OUT_TELESCOPIC.n50 OUT_TELESCOPIC.n44 5.07264
R15463 OUT_TELESCOPIC.n65 OUT_TELESCOPIC.t10 4.76597
R15464 OUT_TELESCOPIC.n14 OUT_TELESCOPIC.n12 4.51471
R15465 OUT_TELESCOPIC.n11 OUT_TELESCOPIC.n10 4.50104
R15466 OUT_TELESCOPIC.n8 OUT_TELESCOPIC.n5 4.50073
R15467 OUT_TELESCOPIC.n21 OUT_TELESCOPIC.n13 4.50064
R15468 OUT_TELESCOPIC.n50 OUT_TELESCOPIC.n49 4.5005
R15469 OUT_TELESCOPIC.n66 OUT_TELESCOPIC.n65 4.5005
R15470 OUT_TELESCOPIC.n25 OUT_TELESCOPIC.n24 4.5005
R15471 OUT_TELESCOPIC.n19 OUT_TELESCOPIC.n0 4.5005
R15472 OUT_TELESCOPIC.n15 OUT_TELESCOPIC.n14 4.5005
R15473 OUT_TELESCOPIC.n16 OUT_TELESCOPIC.n1 4.5005
R15474 OUT_TELESCOPIC.n18 OUT_TELESCOPIC.n17 4.5005
R15475 OUT_TELESCOPIC.n23 OUT_TELESCOPIC.n22 4.5005
R15476 OUT_TELESCOPIC.n21 OUT_TELESCOPIC.n20 4.5005
R15477 OUT_TELESCOPIC.n6 OUT_TELESCOPIC.n4 4.5005
R15478 OUT_TELESCOPIC.n3 OUT_TELESCOPIC.n2 4.5005
R15479 OUT_TELESCOPIC.n8 OUT_TELESCOPIC.n7 4.5005
R15480 OUT_TELESCOPIC.n10 OUT_TELESCOPIC.n9 4.5005
R15481 OUT_TELESCOPIC.n61 OUT_TELESCOPIC.n53 3.87879
R15482 OUT_TELESCOPIC.n49 OUT_TELESCOPIC.t30 2.71979
R15483 OUT_TELESCOPIC.n44 OUT_TELESCOPIC.t14 2.71861
R15484 OUT_TELESCOPIC.n68 OUT_TELESCOPIC.n67 2.67563
R15485 OUT_TELESCOPIC.n69 OUT_TELESCOPIC.n25 2.38647
R15486 OUT_TELESCOPIC.n68 OUT_TELESCOPIC.t19 2.09084
R15487 OUT_TELESCOPIC.n52 OUT_TELESCOPIC.n51 1.688
R15488 OUT_TELESCOPIC.n52 OUT_TELESCOPIC.n30 0.975105
R15489 OUT_TELESCOPIC.n53 OUT_TELESCOPIC.n29 0.825131
R15490 OUT_TELESCOPIC OUT_TELESCOPIC.n66 0.264579
R15491 OUT_TELESCOPIC.n43 OUT_TELESCOPIC.t15 0.122816
R15492 OUT_TELESCOPIC.n42 OUT_TELESCOPIC.t6 0.122816
R15493 OUT_TELESCOPIC.n41 OUT_TELESCOPIC.t16 0.122816
R15494 OUT_TELESCOPIC.n40 OUT_TELESCOPIC.t7 0.122816
R15495 OUT_TELESCOPIC.n48 OUT_TELESCOPIC.t26 0.122816
R15496 OUT_TELESCOPIC.n47 OUT_TELESCOPIC.t29 0.122816
R15497 OUT_TELESCOPIC.n46 OUT_TELESCOPIC.t31 0.122816
R15498 OUT_TELESCOPIC.n45 OUT_TELESCOPIC.t28 0.122816
R15499 OUT_TELESCOPIC OUT_TELESCOPIC.n50 0.1205
R15500 OUT_TELESCOPIC.n28 OUT_TELESCOPIC.t22 0.115578
R15501 OUT_TELESCOPIC.n27 OUT_TELESCOPIC.t21 0.115578
R15502 OUT_TELESCOPIC.n26 OUT_TELESCOPIC.t20 0.115578
R15503 OUT_TELESCOPIC.n64 OUT_TELESCOPIC.t12 0.115578
R15504 OUT_TELESCOPIC.n63 OUT_TELESCOPIC.t9 0.115578
R15505 OUT_TELESCOPIC.n62 OUT_TELESCOPIC.t11 0.115578
R15506 OUT_TELESCOPIC.n33 OUT_TELESCOPIC.n32 0.0668158
R15507 OUT_TELESCOPIC.n35 OUT_TELESCOPIC.n34 0.0668158
R15508 OUT_TELESCOPIC.n37 OUT_TELESCOPIC.n36 0.0668158
R15509 OUT_TELESCOPIC.n39 OUT_TELESCOPIC.n38 0.0668158
R15510 OUT_TELESCOPIC.n5 OUT_TELESCOPIC 0.0530904
R15511 OUT_TELESCOPIC.n9 OUT_TELESCOPIC.n4 0.0501241
R15512 OUT_TELESCOPIC.n29 OUT_TELESCOPIC.t41 0.0392234
R15513 OUT_TELESCOPIC.n29 OUT_TELESCOPIC.t38 0.0392234
R15514 OUT_TELESCOPIC.n59 OUT_TELESCOPIC.t39 0.0392234
R15515 OUT_TELESCOPIC.n59 OUT_TELESCOPIC.t42 0.0392234
R15516 OUT_TELESCOPIC.n57 OUT_TELESCOPIC.t37 0.0392234
R15517 OUT_TELESCOPIC.n57 OUT_TELESCOPIC.t43 0.0392234
R15518 OUT_TELESCOPIC.n55 OUT_TELESCOPIC.t24 0.0392234
R15519 OUT_TELESCOPIC.n55 OUT_TELESCOPIC.t5 0.0392234
R15520 OUT_TELESCOPIC.n54 OUT_TELESCOPIC.t40 0.0392234
R15521 OUT_TELESCOPIC.n54 OUT_TELESCOPIC.t25 0.0392234
R15522 OUT_TELESCOPIC.n20 OUT_TELESCOPIC.n1 0.0372669
R15523 OUT_TELESCOPIC.n30 OUT_TELESCOPIC.t1 0.0369
R15524 OUT_TELESCOPIC.n30 OUT_TELESCOPIC.t32 0.0369
R15525 OUT_TELESCOPIC.n38 OUT_TELESCOPIC.t35 0.0369
R15526 OUT_TELESCOPIC.n38 OUT_TELESCOPIC.t4 0.0369
R15527 OUT_TELESCOPIC.n36 OUT_TELESCOPIC.t3 0.0369
R15528 OUT_TELESCOPIC.n36 OUT_TELESCOPIC.t34 0.0369
R15529 OUT_TELESCOPIC.n34 OUT_TELESCOPIC.t0 0.0369
R15530 OUT_TELESCOPIC.n34 OUT_TELESCOPIC.t18 0.0369
R15531 OUT_TELESCOPIC.n32 OUT_TELESCOPIC.t17 0.0369
R15532 OUT_TELESCOPIC.n32 OUT_TELESCOPIC.t36 0.0369
R15533 OUT_TELESCOPIC.n31 OUT_TELESCOPIC.t33 0.0369
R15534 OUT_TELESCOPIC.n31 OUT_TELESCOPIC.t2 0.0369
R15535 OUT_TELESCOPIC.n18 OUT_TELESCOPIC.n13 0.0280188
R15536 OUT_TELESCOPIC.n10 OUT_TELESCOPIC.n3 0.0211024
R15537 OUT_TELESCOPIC.n7 OUT_TELESCOPIC.n6 0.0203795
R15538 OUT_TELESCOPIC.n16 OUT_TELESCOPIC.n15 0.0174462
R15539 OUT_TELESCOPIC.n22 OUT_TELESCOPIC.n12 0.0167342
R15540 OUT_TELESCOPIC.n19 OUT_TELESCOPIC.n18 0.0147105
R15541 OUT_TELESCOPIC.n24 OUT_TELESCOPIC.n1 0.0147105
R15542 OUT_TELESCOPIC.n14 OUT_TELESCOPIC.n13 0.00117669
R15543 OUT_TELESCOPIC.n20 OUT_TELESCOPIC.n19 0.00117669
R15544 OUT_TELESCOPIC.n24 OUT_TELESCOPIC.n23 0.00117669
R15545 OUT_TELESCOPIC.n25 OUT_TELESCOPIC.n0 0.00106962
R15546 OUT_TELESCOPIC.n17 OUT_TELESCOPIC.n16 0.00106962
R15547 OUT_TELESCOPIC.n22 OUT_TELESCOPIC.n21 0.00106962
R15548 OUT_TELESCOPIC.n6 OUT_TELESCOPIC.n5 0.00104217
R15549 OUT_TELESCOPIC.n7 OUT_TELESCOPIC.n3 0.00104217
R15550 OUT_TELESCOPIC.n11 OUT_TELESCOPIC.n2 0.000725564
R15551 OUT_TELESCOPIC.n4 OUT_TELESCOPIC.n2 0.000725564
R15552 OUT_TELESCOPIC.n9 OUT_TELESCOPIC.n8 0.000725564
R15553 OUT_TELESCOPIC.n15 OUT_TELESCOPIC.n0 0.000642405
R15554 OUT_TELESCOPIC.n17 OUT_TELESCOPIC.n12 0.000642405
R15555 programmable_telescopic_cascode_0.programmable_nfet$5_1.d.n24 programmable_telescopic_cascode_0.programmable_nfet$5_1.d.n23 12.535
R15556 programmable_telescopic_cascode_0.programmable_nfet$5_1.d.n5 programmable_telescopic_cascode_0.programmable_nfet$5_1.d.t10 10.7455
R15557 programmable_telescopic_cascode_0.programmable_nfet$5_1.d.n10 programmable_telescopic_cascode_0.programmable_nfet$5_1.d.t16 10.7455
R15558 programmable_telescopic_cascode_0.programmable_nfet$5_1.d.n1 programmable_telescopic_cascode_0.programmable_nfet$5_1.d.t23 10.6833
R15559 programmable_telescopic_cascode_0.programmable_nfet$5_1.d.n16 programmable_telescopic_cascode_0.programmable_nfet$5_1.d.t5 10.4697
R15560 programmable_telescopic_cascode_0.programmable_nfet$5_1.d.n6 programmable_telescopic_cascode_0.programmable_nfet$5_1.d.n5 10.3582
R15561 programmable_telescopic_cascode_0.programmable_nfet$5_1.d.n7 programmable_telescopic_cascode_0.programmable_nfet$5_1.d.n6 10.3582
R15562 programmable_telescopic_cascode_0.programmable_nfet$5_1.d.n8 programmable_telescopic_cascode_0.programmable_nfet$5_1.d.n7 10.3582
R15563 programmable_telescopic_cascode_0.programmable_nfet$5_1.d.n11 programmable_telescopic_cascode_0.programmable_nfet$5_1.d.n10 10.3582
R15564 programmable_telescopic_cascode_0.programmable_nfet$5_1.d.n12 programmable_telescopic_cascode_0.programmable_nfet$5_1.d.n11 10.3582
R15565 programmable_telescopic_cascode_0.programmable_nfet$5_1.d.n13 programmable_telescopic_cascode_0.programmable_nfet$5_1.d.n12 10.3582
R15566 programmable_telescopic_cascode_0.programmable_nfet$5_1.d.n2 programmable_telescopic_cascode_0.programmable_nfet$5_1.d.n1 10.2339
R15567 programmable_telescopic_cascode_0.programmable_nfet$5_1.d.n3 programmable_telescopic_cascode_0.programmable_nfet$5_1.d.n2 10.2339
R15568 programmable_telescopic_cascode_0.programmable_nfet$5_1.d.n4 programmable_telescopic_cascode_0.programmable_nfet$5_1.d.n3 10.2339
R15569 programmable_telescopic_cascode_0.programmable_nfet$5_1.d.n17 programmable_telescopic_cascode_0.programmable_nfet$5_1.d.n16 9.78627
R15570 programmable_telescopic_cascode_0.programmable_nfet$5_1.d.n18 programmable_telescopic_cascode_0.programmable_nfet$5_1.d.n17 9.78627
R15571 programmable_telescopic_cascode_0.programmable_nfet$5_1.d.n19 programmable_telescopic_cascode_0.programmable_nfet$5_1.d.n18 9.78627
R15572 programmable_telescopic_cascode_0.programmable_nfet$5_1.d programmable_telescopic_cascode_0.programmable_nfet$5_1.d.n0 8.71132
R15573 programmable_telescopic_cascode_0.programmable_nfet$5_1.d.n25 programmable_telescopic_cascode_0.programmable_nfet$5_1.d.t27 8.00782
R15574 programmable_telescopic_cascode_0.programmable_nfet$5_1.d.n9 programmable_telescopic_cascode_0.programmable_nfet$5_1.d.n8 7.78698
R15575 programmable_telescopic_cascode_0.programmable_nfet$5_1.d.n14 programmable_telescopic_cascode_0.programmable_nfet$5_1.d.n13 7.78343
R15576 programmable_telescopic_cascode_0.programmable_nfet$5_1.d.n22 programmable_telescopic_cascode_0.programmable_nfet$5_1.d.n4 7.72601
R15577 programmable_telescopic_cascode_0.programmable_nfet$5_1.d.n20 programmable_telescopic_cascode_0.programmable_nfet$5_1.d.n19 7.50764
R15578 programmable_telescopic_cascode_0.programmable_nfet$5_1.d.n25 programmable_telescopic_cascode_0.programmable_nfet$5_1.d.n24 6.16175
R15579 programmable_telescopic_cascode_0.programmable_nfet$5_1.d.n22 programmable_telescopic_cascode_0.programmable_nfet$5_1.d.n21 4.99204
R15580 programmable_telescopic_cascode_0.programmable_nfet$5_1.d programmable_telescopic_cascode_0.programmable_nfet$5_1.d.n9 4.98627
R15581 programmable_telescopic_cascode_0.programmable_nfet$5_1.d.n21 programmable_telescopic_cascode_0.programmable_nfet$5_1.d.n20 4.5005
R15582 programmable_telescopic_cascode_0.programmable_nfet$5_1.d.n15 programmable_telescopic_cascode_0.programmable_nfet$5_1.d.n14 4.5005
R15583 programmable_telescopic_cascode_0.programmable_nfet$5_1.d.n14 programmable_telescopic_cascode_0.programmable_nfet$5_1.d.t19 2.96255
R15584 programmable_telescopic_cascode_0.programmable_nfet$5_1.d.n20 programmable_telescopic_cascode_0.programmable_nfet$5_1.d.t22 2.96255
R15585 programmable_telescopic_cascode_0.programmable_nfet$5_1.d.n9 programmable_telescopic_cascode_0.programmable_nfet$5_1.d.t11 2.959
R15586 programmable_telescopic_cascode_0.programmable_nfet$5_1.d.n24 programmable_telescopic_cascode_0.programmable_nfet$5_1.d.t2 2.54032
R15587 programmable_telescopic_cascode_0.programmable_nfet$5_1.d.n23 programmable_telescopic_cascode_0.programmable_nfet$5_1.d.n22 2.28958
R15588 programmable_telescopic_cascode_0.programmable_nfet$5_1.d.n23 programmable_telescopic_cascode_0.programmable_nfet$5_1.d.t4 0.668737
R15589 programmable_telescopic_cascode_0.programmable_nfet$5_1.d.n21 programmable_telescopic_cascode_0.programmable_nfet$5_1.d.n15 0.338577
R15590 programmable_telescopic_cascode_0.programmable_nfet$5_1.d programmable_telescopic_cascode_0.programmable_nfet$5_1.d.n25 0.19425
R15591 programmable_telescopic_cascode_0.programmable_nfet$5_1.d.n15 programmable_telescopic_cascode_0.programmable_nfet$5_1.d 0.129731
R15592 programmable_telescopic_cascode_0.programmable_nfet$5_1.d.n8 programmable_telescopic_cascode_0.programmable_nfet$5_1.d.t12 0.122816
R15593 programmable_telescopic_cascode_0.programmable_nfet$5_1.d.n7 programmable_telescopic_cascode_0.programmable_nfet$5_1.d.t8 0.122816
R15594 programmable_telescopic_cascode_0.programmable_nfet$5_1.d.n6 programmable_telescopic_cascode_0.programmable_nfet$5_1.d.t13 0.122816
R15595 programmable_telescopic_cascode_0.programmable_nfet$5_1.d.n5 programmable_telescopic_cascode_0.programmable_nfet$5_1.d.t9 0.122816
R15596 programmable_telescopic_cascode_0.programmable_nfet$5_1.d.n13 programmable_telescopic_cascode_0.programmable_nfet$5_1.d.t21 0.122816
R15597 programmable_telescopic_cascode_0.programmable_nfet$5_1.d.n12 programmable_telescopic_cascode_0.programmable_nfet$5_1.d.t18 0.122816
R15598 programmable_telescopic_cascode_0.programmable_nfet$5_1.d.n11 programmable_telescopic_cascode_0.programmable_nfet$5_1.d.t20 0.122816
R15599 programmable_telescopic_cascode_0.programmable_nfet$5_1.d.n10 programmable_telescopic_cascode_0.programmable_nfet$5_1.d.t17 0.122816
R15600 programmable_telescopic_cascode_0.programmable_nfet$5_1.d.n19 programmable_telescopic_cascode_0.programmable_nfet$5_1.d.t7 0.122816
R15601 programmable_telescopic_cascode_0.programmable_nfet$5_1.d.n18 programmable_telescopic_cascode_0.programmable_nfet$5_1.d.t24 0.122816
R15602 programmable_telescopic_cascode_0.programmable_nfet$5_1.d.n17 programmable_telescopic_cascode_0.programmable_nfet$5_1.d.t15 0.122816
R15603 programmable_telescopic_cascode_0.programmable_nfet$5_1.d.n16 programmable_telescopic_cascode_0.programmable_nfet$5_1.d.t26 0.122816
R15604 programmable_telescopic_cascode_0.programmable_nfet$5_1.d.n4 programmable_telescopic_cascode_0.programmable_nfet$5_1.d.t25 0.122816
R15605 programmable_telescopic_cascode_0.programmable_nfet$5_1.d.n3 programmable_telescopic_cascode_0.programmable_nfet$5_1.d.t6 0.122816
R15606 programmable_telescopic_cascode_0.programmable_nfet$5_1.d.n2 programmable_telescopic_cascode_0.programmable_nfet$5_1.d.t3 0.122816
R15607 programmable_telescopic_cascode_0.programmable_nfet$5_1.d.n1 programmable_telescopic_cascode_0.programmable_nfet$5_1.d.t14 0.122816
R15608 programmable_telescopic_cascode_0.programmable_nfet$5_1.d.n0 programmable_telescopic_cascode_0.programmable_nfet$5_1.d.t1 0.0551
R15609 programmable_telescopic_cascode_0.programmable_nfet$5_1.d.n0 programmable_telescopic_cascode_0.programmable_nfet$5_1.d.t0 0.0551
R15610 CLK.t11 CLK.t4 43.2425
R15611 CLK.t53 CLK.t46 43.2425
R15612 CLK.t52 CLK.t44 43.2425
R15613 CLK.t17 CLK.t12 43.2425
R15614 CLK.t27 CLK.t21 43.2425
R15615 CLK.t39 CLK.t31 43.2425
R15616 CLK.t33 CLK.t28 43.2425
R15617 CLK.t47 CLK.t40 43.2425
R15618 CLK.t6 CLK.t0 43.2425
R15619 CLK.n45 CLK.t10 30.4764
R15620 CLK.n41 CLK.t9 30.4764
R15621 CLK.n37 CLK.t50 30.4764
R15622 CLK.n33 CLK.t16 30.4764
R15623 CLK.n29 CLK.t26 30.4764
R15624 CLK.n12 CLK.t38 30.4764
R15625 CLK.n8 CLK.t51 30.4764
R15626 CLK.n4 CLK.t45 30.4764
R15627 CLK.n1 CLK.t5 30.4764
R15628 CLK CLK.t34 25.031
R15629 CLK CLK.t32 25.031
R15630 CLK CLK.t23 25.031
R15631 CLK CLK.t41 25.031
R15632 CLK CLK.t1 25.031
R15633 CLK CLK.t13 25.031
R15634 CLK CLK.t24 25.031
R15635 CLK CLK.t19 25.031
R15636 CLK CLK.t29 25.031
R15637 CLK.t4 CLK 25.0275
R15638 CLK.t46 CLK 25.0275
R15639 CLK.t44 CLK 25.0275
R15640 CLK.t12 CLK 25.0275
R15641 CLK.t21 CLK 25.0275
R15642 CLK.t31 CLK 25.0275
R15643 CLK.t28 CLK 25.0275
R15644 CLK.t40 CLK 25.0275
R15645 CLK.t0 CLK 25.0275
R15646 CLK CLK.t18 25.0275
R15647 CLK CLK.t8 25.0275
R15648 CLK CLK.t7 25.0275
R15649 CLK CLK.t22 25.0275
R15650 CLK CLK.t35 25.0275
R15651 CLK CLK.t48 25.0275
R15652 CLK CLK.t42 25.0275
R15653 CLK CLK.t2 25.0275
R15654 CLK CLK.t14 25.0275
R15655 CLK CLK.t49 25.0186
R15656 CLK CLK.t37 25.0186
R15657 CLK CLK.t36 25.0186
R15658 CLK CLK.t3 25.0186
R15659 CLK CLK.t15 25.0186
R15660 CLK CLK.t25 25.0186
R15661 CLK CLK.t20 25.0186
R15662 CLK CLK.t30 25.0186
R15663 CLK CLK.t43 25.0186
R15664 CLK.n44 CLK.t11 24.9469
R15665 CLK.n40 CLK.t53 24.9469
R15666 CLK.n36 CLK.t52 24.9469
R15667 CLK.n32 CLK.t17 24.9469
R15668 CLK.n28 CLK.t27 24.9469
R15669 CLK.n11 CLK.t39 24.9469
R15670 CLK.n7 CLK.t33 24.9469
R15671 CLK.n3 CLK.t47 24.9469
R15672 CLK.n0 CLK.t6 24.9469
R15673 CLK.n6 CLK.n2 12.851
R15674 CLK.n9 CLK.n7 10.5717
R15675 CLK.n13 CLK.n11 10.5621
R15676 CLK.n30 CLK.n28 10.5605
R15677 CLK.n46 CLK.n44 10.5588
R15678 CLK.n42 CLK.n40 10.5588
R15679 CLK.n38 CLK.n36 10.5556
R15680 CLK.n34 CLK.n32 10.554
R15681 CLK.n2 CLK.n0 10.5508
R15682 CLK.n5 CLK.n3 10.5476
R15683 CLK.n10 CLK.n6 8.35098
R15684 CLK.n14 CLK.n10 8.35098
R15685 CLK.n35 CLK.n31 8.35098
R15686 CLK.n39 CLK.n35 8.35098
R15687 CLK.n43 CLK.n39 8.35098
R15688 CLK CLK.n43 8.28917
R15689 CLK.n5 CLK 7.01426
R15690 CLK.n2 CLK 7.01104
R15691 CLK.n34 CLK 7.00783
R15692 CLK.n38 CLK 7.00622
R15693 CLK.n46 CLK 7.00301
R15694 CLK.n42 CLK 7.00301
R15695 CLK.n30 CLK 7.0014
R15696 CLK.n13 CLK 6.99979
R15697 CLK.n9 CLK 6.99015
R15698 CLK.n27 CLK.n14 5.75616
R15699 CLK CLK.n45 4.78485
R15700 CLK CLK.n41 4.78485
R15701 CLK CLK.n37 4.78485
R15702 CLK CLK.n33 4.78485
R15703 CLK CLK.n29 4.78485
R15704 CLK CLK.n12 4.78485
R15705 CLK CLK.n8 4.78485
R15706 CLK CLK.n4 4.78485
R15707 CLK CLK.n1 4.78485
R15708 CLK.n18 CLK.n15 4.56733
R15709 CLK CLK.n46 4.56231
R15710 CLK.n27 CLK.n26 4.50966
R15711 CLK.n26 CLK.n25 4.50466
R15712 CLK.n19 CLK.n18 4.50104
R15713 CLK.n6 CLK.n5 4.5005
R15714 CLK.n10 CLK.n9 4.5005
R15715 CLK.n14 CLK.n13 4.5005
R15716 CLK.n31 CLK.n30 4.5005
R15717 CLK.n35 CLK.n34 4.5005
R15718 CLK.n39 CLK.n38 4.5005
R15719 CLK.n43 CLK.n42 4.5005
R15720 CLK.n16 CLK.n15 4.5005
R15721 CLK.n21 CLK.n20 4.5005
R15722 CLK.n22 CLK.n17 4.5005
R15723 CLK.n24 CLK.n23 4.5005
R15724 CLK.n31 CLK.n27 2.59532
R15725 CLK.n25 CLK.n24 2.27153
R15726 CLK.n19 CLK 0.192608
R15727 CLK.n26 CLK.n15 0.0646317
R15728 CLK.n44 CLK 0.0555735
R15729 CLK.n40 CLK 0.0555735
R15730 CLK.n36 CLK 0.0555735
R15731 CLK.n32 CLK 0.0555735
R15732 CLK.n28 CLK 0.0555735
R15733 CLK.n11 CLK 0.0555735
R15734 CLK.n7 CLK 0.0555735
R15735 CLK.n3 CLK 0.0555735
R15736 CLK.n0 CLK 0.0555735
R15737 CLK.n22 CLK.n21 0.0303193
R15738 CLK.n25 CLK.n16 0.0295993
R15739 CLK.n20 CLK.n17 0.0203795
R15740 CLK.n45 CLK 0.0147105
R15741 CLK.n41 CLK 0.0147105
R15742 CLK.n37 CLK 0.0147105
R15743 CLK.n33 CLK 0.0147105
R15744 CLK.n29 CLK 0.0147105
R15745 CLK.n12 CLK 0.0147105
R15746 CLK.n8 CLK 0.0147105
R15747 CLK.n4 CLK 0.0147105
R15748 CLK.n1 CLK 0.0147105
R15749 CLK.n23 CLK.n16 0.00321084
R15750 CLK.n23 CLK.n22 0.00131325
R15751 CLK.n20 CLK.n19 0.00104217
R15752 CLK.n24 CLK.n17 0.00104217
R15753 CLK.n21 CLK.n18 0.000771084
R15754 transmission_gate$2$1_6.out.n26 transmission_gate$2$1_6.out.n25 51.3633
R15755 transmission_gate$2$1_6.out.n27 transmission_gate$2$1_6.out.n26 50.243
R15756 transmission_gate$2$1_6.out.n28 transmission_gate$2$1_6.out.n27 33.9628
R15757 transmission_gate$2$1_6.out transmission_gate$2$1_6.out.t8 30.5822
R15758 transmission_gate$2$1_6.out transmission_gate$2$1_6.out.t17 30.5822
R15759 transmission_gate$2$1_6.out transmission_gate$2$1_6.out.t21 30.5822
R15760 transmission_gate$2$1_6.out transmission_gate$2$1_6.out.t18 30.5822
R15761 transmission_gate$2$1_6.out transmission_gate$2$1_6.out.t20 30.4906
R15762 transmission_gate$2$1_6.out transmission_gate$2$1_6.out.t13 25.0251
R15763 transmission_gate$2$1_6.out transmission_gate$2$1_6.out.t12 25.0251
R15764 transmission_gate$2$1_6.out.n1 transmission_gate$2$1_6.out.t22 25.0227
R15765 transmission_gate$2$1_6.out.n29 transmission_gate$2$1_6.out.t15 24.9469
R15766 transmission_gate$2$1_6.out.n31 transmission_gate$2$1_6.out.t14 24.9469
R15767 transmission_gate$2$1_6.out.n2 transmission_gate$2$1_6.out.t24 24.9469
R15768 transmission_gate$2$1_6.out.n20 transmission_gate$2$1_6.out.t10 24.9469
R15769 transmission_gate$2$1_6.out.n18 transmission_gate$2$1_6.out.t5 24.9469
R15770 transmission_gate$2$1_6.out.n14 transmission_gate$2$1_6.out.t19 24.9469
R15771 transmission_gate$2$1_6.out.n15 transmission_gate$2$1_6.out.t6 24.9469
R15772 transmission_gate$2$1_6.out.n10 transmission_gate$2$1_6.out.t11 24.9469
R15773 transmission_gate$2$1_6.out.n11 transmission_gate$2$1_6.out.t23 24.9469
R15774 transmission_gate$2$1_6.out.n4 transmission_gate$2$1_6.out.t9 24.9469
R15775 transmission_gate$2$1_6.out.n6 transmission_gate$2$1_6.out.t25 24.9469
R15776 transmission_gate$2$1_6.out.n7 transmission_gate$2$1_6.out.t7 24.9469
R15777 transmission_gate$2$1_6.out.n24 transmission_gate$2$1_6.out.t16 24.9469
R15778 transmission_gate$2$1_6.out.n34 transmission_gate$2$1_6.out.t1 17.5462
R15779 transmission_gate$2$1_6.out.n35 transmission_gate$2$1_6.out.t2 16.7838
R15780 transmission_gate$2$1_6.out.n34 transmission_gate$2$1_6.out.t0 16.7833
R15781 transmission_gate$2$1_6.out.n5 transmission_gate$2$1_6.out 15.6879
R15782 transmission_gate$2$1_6.out.n8 transmission_gate$2$1_6.out 13.3109
R15783 transmission_gate$2$1_6.out.n12 transmission_gate$2$1_6.out 13.3064
R15784 transmission_gate$2$1_6.out.n16 transmission_gate$2$1_6.out 13.3041
R15785 transmission_gate$2$1_6.out transmission_gate$2$1_6.out.t3 12.5567
R15786 transmission_gate$2$1_6.out.n0 transmission_gate$2$1_6.out.t4 12.0263
R15787 transmission_gate$2$1_6.out.n16 transmission_gate$2$1_6.out 11.1822
R15788 transmission_gate$2$1_6.out.n12 transmission_gate$2$1_6.out 11.1804
R15789 transmission_gate$2$1_6.out.n8 transmission_gate$2$1_6.out 11.1753
R15790 transmission_gate$2$1_6.out.n30 transmission_gate$2$1_6.out 10.455
R15791 transmission_gate$2$1_6.out.n22 transmission_gate$2$1_6.out.n21 8.34445
R15792 transmission_gate$2$1_6.out transmission_gate$2$1_6.out.n29 6.06552
R15793 transmission_gate$2$1_6.out.n22 transmission_gate$2$1_6.out.n19 5.97129
R15794 transmission_gate$2$1_6.out transmission_gate$2$1_6.out.n33 5.58854
R15795 transmission_gate$2$1_6.out transmission_gate$2$1_6.out.n31 5.28284
R15796 transmission_gate$2$1_6.out.n27 transmission_gate$2$1_6.out.n3 5.02392
R15797 transmission_gate$2$1_6.out.n3 transmission_gate$2$1_6.out.n2 5.00261
R15798 transmission_gate$2$1_6.out.n28 transmission_gate$2$1_6.out.n1 4.99871
R15799 transmission_gate$2$1_6.out.n19 transmission_gate$2$1_6.out.n18 4.99787
R15800 transmission_gate$2$1_6.out.n21 transmission_gate$2$1_6.out.n20 4.99313
R15801 transmission_gate$2$1_6.out.n25 transmission_gate$2$1_6.out.n24 4.973
R15802 transmission_gate$2$1_6.out.n9 transmission_gate$2$1_6.out.n8 4.5005
R15803 transmission_gate$2$1_6.out.n13 transmission_gate$2$1_6.out.n12 4.5005
R15804 transmission_gate$2$1_6.out.n17 transmission_gate$2$1_6.out.n16 4.5005
R15805 transmission_gate$2$1_6.out.n23 transmission_gate$2$1_6.out.n22 4.5005
R15806 transmission_gate$2$1_6.out.n33 transmission_gate$2$1_6.out.n32 4.5005
R15807 transmission_gate$2$1_6.out.n26 transmission_gate$2$1_6.out.n23 4.00076
R15808 transmission_gate$2$1_6.out.n23 transmission_gate$2$1_6.out.n17 3.40747
R15809 transmission_gate$2$1_6.out.n9 transmission_gate$2$1_6.out.n5 3.16353
R15810 transmission_gate$2$1_6.out.n13 transmission_gate$2$1_6.out.n9 3.13747
R15811 transmission_gate$2$1_6.out.n17 transmission_gate$2$1_6.out.n13 3.10076
R15812 transmission_gate$2$1_6.out.n33 transmission_gate$2$1_6.out.n0 1.24764
R15813 transmission_gate$2$1_6.out.n5 transmission_gate$2$1_6.out 1.19892
R15814 transmission_gate$2$1_6.out transmission_gate$2$1_6.out.n35 0.947107
R15815 transmission_gate$2$1_6.out.n35 transmission_gate$2$1_6.out 0.424786
R15816 transmission_gate$2$1_6.out.n0 transmission_gate$2$1_6.out 0.2411
R15817 transmission_gate$2$1_6.out.n32 transmission_gate$2$1_6.out.n30 0.167643
R15818 transmission_gate$2$1_6.out transmission_gate$2$1_6.out.n34 0.140321
R15819 transmission_gate$2$1_6.out transmission_gate$2$1_6.out.n28 0.12425
R15820 transmission_gate$2$1_6.out.n32 transmission_gate$2$1_6.out 0.0824643
R15821 transmission_gate$2$1_6.out.n29 transmission_gate$2$1_6.out 0.0751053
R15822 transmission_gate$2$1_6.out.n31 transmission_gate$2$1_6.out 0.0751053
R15823 transmission_gate$2$1_6.out.n25 transmission_gate$2$1_6.out 0.0585263
R15824 transmission_gate$2$1_6.out.n21 transmission_gate$2$1_6.out 0.0383947
R15825 transmission_gate$2$1_6.out.n19 transmission_gate$2$1_6.out 0.0336579
R15826 transmission_gate$2$1_6.out.n3 transmission_gate$2$1_6.out 0.0289211
R15827 transmission_gate$2$1_6.out.n1 transmission_gate$2$1_6.out 0.00878947
R15828 transmission_gate$2$1_6.out.n2 transmission_gate$2$1_6.out 0.00760526
R15829 transmission_gate$2$1_6.out.n20 transmission_gate$2$1_6.out 0.00760526
R15830 transmission_gate$2$1_6.out.n18 transmission_gate$2$1_6.out 0.00760526
R15831 transmission_gate$2$1_6.out.n15 transmission_gate$2$1_6.out 0.00760526
R15832 transmission_gate$2$1_6.out.n10 transmission_gate$2$1_6.out 0.00760526
R15833 transmission_gate$2$1_6.out.n11 transmission_gate$2$1_6.out 0.00760526
R15834 transmission_gate$2$1_6.out.n4 transmission_gate$2$1_6.out 0.00760526
R15835 transmission_gate$2$1_6.out.n7 transmission_gate$2$1_6.out 0.00760526
R15836 transmission_gate$2$1_6.out.n24 transmission_gate$2$1_6.out 0.00760526
R15837 transmission_gate$2$1_6.out.n14 transmission_gate$2$1_6.out 0.00751299
R15838 transmission_gate$2$1_6.out.n6 transmission_gate$2$1_6.out 0.00751299
R15839 transmission_gate$2$1_6.out.n30 transmission_gate$2$1_6.out 0.00371429
R15840 transmission_gate$2$1_6.out transmission_gate$2$1_6.out.n15 0.00168421
R15841 transmission_gate$2$1_6.out transmission_gate$2$1_6.out.n10 0.00168421
R15842 transmission_gate$2$1_6.out transmission_gate$2$1_6.out.n11 0.00168421
R15843 transmission_gate$2$1_6.out transmission_gate$2$1_6.out.n4 0.00168421
R15844 transmission_gate$2$1_6.out transmission_gate$2$1_6.out.n7 0.00168421
R15845 transmission_gate$2$1_6.out transmission_gate$2$1_6.out.n14 0.00166883
R15846 transmission_gate$2$1_6.out transmission_gate$2$1_6.out.n6 0.00166883
R15847 programmable_folded_cascode_0.programmable_pfet$1_0.g.t32 programmable_folded_cascode_0.programmable_pfet$1_0.g.t37 452.308
R15848 programmable_folded_cascode_0.programmable_pfet$1_0.g.t29 programmable_folded_cascode_0.programmable_pfet$1_0.g.t32 452.308
R15849 programmable_folded_cascode_0.programmable_pfet$1_0.g.t31 programmable_folded_cascode_0.programmable_pfet$1_0.g.t34 452.308
R15850 programmable_folded_cascode_0.programmable_pfet$1_0.g.t35 programmable_folded_cascode_0.programmable_pfet$1_0.g.t38 452.308
R15851 programmable_folded_cascode_0.programmable_pfet$1_0.g.t30 programmable_folded_cascode_0.programmable_pfet$1_0.g.t35 452.308
R15852 programmable_folded_cascode_0.programmable_pfet$1_0.g.t36 programmable_folded_cascode_0.programmable_pfet$1_0.g.t33 452.308
R15853 programmable_folded_cascode_0.programmable_pfet$1_0.g.t34 programmable_folded_cascode_0.programmable_pfet$1_0.g.t29 452.248
R15854 programmable_folded_cascode_0.programmable_pfet$1_0.g.t33 programmable_folded_cascode_0.programmable_pfet$1_0.g.t30 452.248
R15855 programmable_folded_cascode_0.programmable_pfet$1_0.g.t4 programmable_folded_cascode_0.programmable_pfet$1_0.g.t6 308.844
R15856 programmable_folded_cascode_0.programmable_pfet$1_0.g.t10 programmable_folded_cascode_0.programmable_pfet$1_0.g.t4 308.844
R15857 programmable_folded_cascode_0.programmable_pfet$1_0.g.t0 programmable_folded_cascode_0.programmable_pfet$1_0.g.t10 308.844
R15858 programmable_folded_cascode_0.programmable_pfet$1_0.g.t12 programmable_folded_cascode_0.programmable_pfet$1_0.g.t0 308.844
R15859 programmable_folded_cascode_0.programmable_pfet$1_0.g.t16 programmable_folded_cascode_0.programmable_pfet$1_0.g.t12 308.844
R15860 programmable_folded_cascode_0.programmable_pfet$1_0.g.t8 programmable_folded_cascode_0.programmable_pfet$1_0.g.t16 308.844
R15861 programmable_folded_cascode_0.programmable_pfet$1_0.g.t18 programmable_folded_cascode_0.programmable_pfet$1_0.g.t8 308.844
R15862 programmable_folded_cascode_0.programmable_pfet$1_0.g.t2 programmable_folded_cascode_0.programmable_pfet$1_0.g.t18 308.844
R15863 programmable_folded_cascode_0.programmable_pfet$1_0.g.t14 programmable_folded_cascode_0.programmable_pfet$1_0.g.t2 308.844
R15864 programmable_folded_cascode_0.programmable_pfet$1_0.g.n3 programmable_folded_cascode_0.programmable_pfet$1_0.g.t36 236.857
R15865 programmable_folded_cascode_0.programmable_pfet$1_0.g.n18 programmable_folded_cascode_0.programmable_pfet$1_0.g.t31 231.316
R15866 programmable_folded_cascode_0.programmable_pfet$1_0.g.n7 programmable_folded_cascode_0.programmable_pfet$1_0.g.t14 169.828
R15867 programmable_folded_cascode_0.programmable_pfet$1_0.g.n18 programmable_folded_cascode_0.programmable_pfet$1_0.g.n17 26.2343
R15868 programmable_folded_cascode_0.programmable_pfet$1_0.g.n12 programmable_folded_cascode_0.programmable_pfet$1_0.g.t20 14.9616
R15869 programmable_folded_cascode_0.programmable_pfet$1_0.g.n5 programmable_folded_cascode_0.programmable_pfet$1_0.g.n4 13.5858
R15870 programmable_folded_cascode_0.programmable_pfet$1_0.g.n6 programmable_folded_cascode_0.programmable_pfet$1_0.g.t21 12.487
R15871 programmable_folded_cascode_0.programmable_pfet$1_0.g.n2 programmable_folded_cascode_0.programmable_pfet$1_0.g.t22 12.487
R15872 programmable_folded_cascode_0.programmable_pfet$1_0.g.n0 programmable_folded_cascode_0.programmable_pfet$1_0.g.t25 12.4859
R15873 programmable_folded_cascode_0.programmable_pfet$1_0.g.n1 programmable_folded_cascode_0.programmable_pfet$1_0.g.t26 12.4859
R15874 programmable_folded_cascode_0.programmable_pfet$1_0.g programmable_folded_cascode_0.programmable_pfet$1_0.g.t27 12.2496
R15875 programmable_folded_cascode_0.programmable_pfet$1_0.g programmable_folded_cascode_0.programmable_pfet$1_0.g.t24 12.2496
R15876 programmable_folded_cascode_0.programmable_pfet$1_0.g programmable_folded_cascode_0.programmable_pfet$1_0.g.t28 12.2496
R15877 programmable_folded_cascode_0.programmable_pfet$1_0.g programmable_folded_cascode_0.programmable_pfet$1_0.g.t23 12.2496
R15878 programmable_folded_cascode_0.programmable_pfet$1_0.g.n19 programmable_folded_cascode_0.programmable_pfet$1_0.g.n18 5.54165
R15879 programmable_folded_cascode_0.programmable_pfet$1_0.g.n10 programmable_folded_cascode_0.programmable_pfet$1_0.g.t7 5.24628
R15880 programmable_folded_cascode_0.programmable_pfet$1_0.g.n8 programmable_folded_cascode_0.programmable_pfet$1_0.g.n7 4.96945
R15881 programmable_folded_cascode_0.programmable_pfet$1_0.g.n9 programmable_folded_cascode_0.programmable_pfet$1_0.g.n8 4.96945
R15882 programmable_folded_cascode_0.programmable_pfet$1_0.g.n16 programmable_folded_cascode_0.programmable_pfet$1_0.g.n15 4.96945
R15883 programmable_folded_cascode_0.programmable_pfet$1_0.g.n15 programmable_folded_cascode_0.programmable_pfet$1_0.g.n14 4.96945
R15884 programmable_folded_cascode_0.programmable_pfet$1_0.g.n14 programmable_folded_cascode_0.programmable_pfet$1_0.g.n13 4.96945
R15885 programmable_folded_cascode_0.programmable_pfet$1_0.g.n11 programmable_folded_cascode_0.programmable_pfet$1_0.g.n10 4.96945
R15886 programmable_folded_cascode_0.programmable_pfet$1_0.g.n13 programmable_folded_cascode_0.programmable_pfet$1_0.g.n12 4.88892
R15887 programmable_folded_cascode_0.programmable_pfet$1_0.g.n3 programmable_folded_cascode_0.programmable_pfet$1_0.g.n2 4.72021
R15888 programmable_folded_cascode_0.programmable_pfet$1_0.g.n19 programmable_folded_cascode_0.programmable_pfet$1_0.g.n6 4.72021
R15889 programmable_folded_cascode_0.programmable_pfet$1_0.g.n5 programmable_folded_cascode_0.programmable_pfet$1_0.g.n0 4.67918
R15890 programmable_folded_cascode_0.programmable_pfet$1_0.g.n4 programmable_folded_cascode_0.programmable_pfet$1_0.g.n1 4.67653
R15891 programmable_folded_cascode_0.programmable_pfet$1_0.g.n17 programmable_folded_cascode_0.programmable_pfet$1_0.g.n16 4.10142
R15892 programmable_folded_cascode_0.programmable_pfet$1_0.g.n17 programmable_folded_cascode_0.programmable_pfet$1_0.g.n9 0.868526
R15893 programmable_folded_cascode_0.programmable_pfet$1_0.g.n7 programmable_folded_cascode_0.programmable_pfet$1_0.g.t15 0.277329
R15894 programmable_folded_cascode_0.programmable_pfet$1_0.g.n8 programmable_folded_cascode_0.programmable_pfet$1_0.g.t3 0.277329
R15895 programmable_folded_cascode_0.programmable_pfet$1_0.g.n9 programmable_folded_cascode_0.programmable_pfet$1_0.g.t19 0.277329
R15896 programmable_folded_cascode_0.programmable_pfet$1_0.g.n16 programmable_folded_cascode_0.programmable_pfet$1_0.g.t9 0.277329
R15897 programmable_folded_cascode_0.programmable_pfet$1_0.g.n15 programmable_folded_cascode_0.programmable_pfet$1_0.g.t17 0.277329
R15898 programmable_folded_cascode_0.programmable_pfet$1_0.g.n14 programmable_folded_cascode_0.programmable_pfet$1_0.g.t13 0.277329
R15899 programmable_folded_cascode_0.programmable_pfet$1_0.g.n11 programmable_folded_cascode_0.programmable_pfet$1_0.g.t11 0.277329
R15900 programmable_folded_cascode_0.programmable_pfet$1_0.g.n10 programmable_folded_cascode_0.programmable_pfet$1_0.g.t5 0.277329
R15901 programmable_folded_cascode_0.programmable_pfet$1_0.g.n13 programmable_folded_cascode_0.programmable_pfet$1_0.g.t1 0.277329
R15902 programmable_folded_cascode_0.programmable_pfet$1_0.g.n4 programmable_folded_cascode_0.programmable_pfet$1_0.g 0.0852059
R15903 programmable_folded_cascode_0.programmable_pfet$1_0.g programmable_folded_cascode_0.programmable_pfet$1_0.g.n5 0.0825588
R15904 programmable_folded_cascode_0.programmable_pfet$1_0.g.n12 programmable_folded_cascode_0.programmable_pfet$1_0.g.n11 0.0810263
R15905 programmable_folded_cascode_0.programmable_pfet$1_0.g.n0 programmable_folded_cascode_0.programmable_pfet$1_0.g 0.0417048
R15906 programmable_folded_cascode_0.programmable_pfet$1_0.g.n1 programmable_folded_cascode_0.programmable_pfet$1_0.g 0.0417048
R15907 programmable_folded_cascode_0.programmable_pfet$1_0.g.n6 programmable_folded_cascode_0.programmable_pfet$1_0.g 0.0406205
R15908 programmable_folded_cascode_0.programmable_pfet$1_0.g.n2 programmable_folded_cascode_0.programmable_pfet$1_0.g 0.0406205
R15909 programmable_folded_cascode_0.programmable_pfet$1_0.g programmable_folded_cascode_0.programmable_pfet$1_0.g.n3 0.0203529
R15910 programmable_folded_cascode_0.programmable_pfet$1_0.g programmable_folded_cascode_0.programmable_pfet$1_0.g.n19 0.0203529
R15911 programmable_folded_cascode_0.programmable_pfet$1_0.transmission_gate$17_1.out.t11 programmable_folded_cascode_0.programmable_pfet$1_0.transmission_gate$17_1.out.t7 452.308
R15912 programmable_folded_cascode_0.programmable_pfet$1_0.transmission_gate$17_1.out.t8 programmable_folded_cascode_0.programmable_pfet$1_0.transmission_gate$17_1.out.t11 452.308
R15913 programmable_folded_cascode_0.programmable_pfet$1_0.transmission_gate$17_1.out.t5 programmable_folded_cascode_0.programmable_pfet$1_0.transmission_gate$17_1.out.t12 452.308
R15914 programmable_folded_cascode_0.programmable_pfet$1_0.transmission_gate$17_1.out.t9 programmable_folded_cascode_0.programmable_pfet$1_0.transmission_gate$17_1.out.t3 452.308
R15915 programmable_folded_cascode_0.programmable_pfet$1_0.transmission_gate$17_1.out.t4 programmable_folded_cascode_0.programmable_pfet$1_0.transmission_gate$17_1.out.t9 452.308
R15916 programmable_folded_cascode_0.programmable_pfet$1_0.transmission_gate$17_1.out.t10 programmable_folded_cascode_0.programmable_pfet$1_0.transmission_gate$17_1.out.t6 452.308
R15917 programmable_folded_cascode_0.programmable_pfet$1_0.transmission_gate$17_1.out.t6 programmable_folded_cascode_0.programmable_pfet$1_0.transmission_gate$17_1.out.t4 452.245
R15918 programmable_folded_cascode_0.programmable_pfet$1_0.transmission_gate$17_1.out.t12 programmable_folded_cascode_0.programmable_pfet$1_0.transmission_gate$17_1.out.t8 452.241
R15919 programmable_folded_cascode_0.programmable_pfet$1_0.transmission_gate$17_1.out.n0 programmable_folded_cascode_0.programmable_pfet$1_0.transmission_gate$17_1.out.t5 232.097
R15920 programmable_folded_cascode_0.programmable_pfet$1_0.transmission_gate$17_1.out.n1 programmable_folded_cascode_0.programmable_pfet$1_0.transmission_gate$17_1.out.t10 231.773
R15921 programmable_folded_cascode_0.programmable_pfet$1_0.transmission_gate$17_1.out.n0 programmable_folded_cascode_0.programmable_pfet$1_0.transmission_gate$17_1.out.t2 13.0317
R15922 programmable_folded_cascode_0.programmable_pfet$1_0.transmission_gate$17_1.out.n2 programmable_folded_cascode_0.programmable_pfet$1_0.transmission_gate$17_1.out.t1 12.5327
R15923 programmable_folded_cascode_0.programmable_pfet$1_0.transmission_gate$17_1.out programmable_folded_cascode_0.programmable_pfet$1_0.transmission_gate$17_1.out.t0 12.2669
R15924 programmable_folded_cascode_0.programmable_pfet$1_0.transmission_gate$17_1.out.n2 programmable_folded_cascode_0.programmable_pfet$1_0.transmission_gate$17_1.out.n1 10.2254
R15925 programmable_folded_cascode_0.programmable_pfet$1_0.transmission_gate$17_1.out.n1 programmable_folded_cascode_0.programmable_pfet$1_0.transmission_gate$17_1.out.n0 9.51658
R15926 programmable_folded_cascode_0.programmable_pfet$1_0.transmission_gate$17_1.out programmable_folded_cascode_0.programmable_pfet$1_0.transmission_gate$17_1.out.n2 0.0245
R15927 INN_5T.t5 INN_5T.t4 180.602
R15928 INN_5T.t6 INN_5T.t5 180.602
R15929 INN_5T.n3 INN_5T.t6 99.1131
R15930 INN_5T.n14 INN_5T.n3 13.3276
R15931 INN_5T INN_5T.t1 12.5271
R15932 INN_5T INN_5T.t2 12.5271
R15933 INN_5T.n1 INN_5T.t0 12.2345
R15934 INN_5T.n0 INN_5T.t3 12.2279
R15935 INN_5T.n14 INN_5T.n13 11.1902
R15936 INN_5T.n7 INN_5T 4.79002
R15937 INN_5T.n2 INN_5T.n0 4.71086
R15938 INN_5T INN_5T.n1 4.68917
R15939 INN_5T.n13 INN_5T.n12 4.50104
R15940 INN_5T.n10 INN_5T.n7 4.50076
R15941 INN_5T.n3 INN_5T.n2 4.5005
R15942 INN_5T.n8 INN_5T.n6 4.5005
R15943 INN_5T.n10 INN_5T.n9 4.5005
R15944 INN_5T.n5 INN_5T.n4 4.5005
R15945 INN_5T.n12 INN_5T.n11 4.5005
R15946 INN_5T INN_5T.n14 0.5405
R15947 INN_5T.n11 INN_5T.n6 0.0578913
R15948 INN_5T.n0 INN_5T 0.0221867
R15949 INN_5T.n12 INN_5T.n5 0.0211024
R15950 INN_5T.n9 INN_5T.n8 0.0203795
R15951 INN_5T.n1 INN_5T 0.0156807
R15952 INN_5T.n2 INN_5T 0.0113434
R15953 INN_5T.n8 INN_5T.n7 0.00104217
R15954 INN_5T.n9 INN_5T.n5 0.00104217
R15955 INN_5T.n13 INN_5T.n4 0.00076087
R15956 INN_5T.n6 INN_5T.n4 0.00076087
R15957 INN_5T.n11 INN_5T.n10 0.00076087
R15958 programmable_telescopic_cascode_0.EN1.n8 programmable_telescopic_cascode_0.EN1.t13 30.72
R15959 programmable_telescopic_cascode_0.EN1.n5 programmable_telescopic_cascode_0.EN1.t7 30.72
R15960 programmable_telescopic_cascode_0.EN1.n3 programmable_telescopic_cascode_0.EN1.t5 30.72
R15961 programmable_telescopic_cascode_0.EN1.n14 programmable_telescopic_cascode_0.EN1.t17 30.7093
R15962 programmable_telescopic_cascode_0.EN1.n11 programmable_telescopic_cascode_0.EN1.t15 30.7093
R15963 programmable_telescopic_cascode_0.EN1 programmable_telescopic_cascode_0.EN1.t10 25.0275
R15964 programmable_telescopic_cascode_0.EN1 programmable_telescopic_cascode_0.EN1.t9 24.9481
R15965 programmable_telescopic_cascode_0.EN1.n0 programmable_telescopic_cascode_0.EN1.t8 24.9469
R15966 programmable_telescopic_cascode_0.EN1.n18 programmable_telescopic_cascode_0.EN1.t12 24.9469
R15967 programmable_telescopic_cascode_0.EN1.n19 programmable_telescopic_cascode_0.EN1.t18 24.9469
R15968 programmable_telescopic_cascode_0.EN1.n21 programmable_telescopic_cascode_0.EN1.t16 24.9469
R15969 programmable_telescopic_cascode_0.EN1.n15 programmable_telescopic_cascode_0.EN1.t3 24.9469
R15970 programmable_telescopic_cascode_0.EN1.n12 programmable_telescopic_cascode_0.EN1.t6 24.9469
R15971 programmable_telescopic_cascode_0.EN1.n9 programmable_telescopic_cascode_0.EN1.t4 24.9469
R15972 programmable_telescopic_cascode_0.EN1.n6 programmable_telescopic_cascode_0.EN1.t14 24.9469
R15973 programmable_telescopic_cascode_0.EN1.n4 programmable_telescopic_cascode_0.EN1.t11 24.9469
R15974 programmable_telescopic_cascode_0.EN1 programmable_telescopic_cascode_0.EN1.t0 17.2081
R15975 programmable_telescopic_cascode_0.EN1.n2 programmable_telescopic_cascode_0.EN1.t1 17.1605
R15976 programmable_telescopic_cascode_0.EN1.n1 programmable_telescopic_cascode_0.EN1.t2 16.7833
R15977 programmable_telescopic_cascode_0.EN1 programmable_telescopic_cascode_0.EN1.n0 15.6278
R15978 programmable_telescopic_cascode_0.EN1.n24 programmable_telescopic_cascode_0.EN1.n23 11.2989
R15979 programmable_telescopic_cascode_0.EN1.n7 programmable_telescopic_cascode_0.EN1 8.52775
R15980 programmable_telescopic_cascode_0.EN1.n17 programmable_telescopic_cascode_0.EN1 8.52775
R15981 programmable_telescopic_cascode_0.EN1.n20 programmable_telescopic_cascode_0.EN1 8.01642
R15982 programmable_telescopic_cascode_0.EN1.n23 programmable_telescopic_cascode_0.EN1.n17 4.92089
R15983 programmable_telescopic_cascode_0.EN1.n16 programmable_telescopic_cascode_0.EN1 4.87471
R15984 programmable_telescopic_cascode_0.EN1.n13 programmable_telescopic_cascode_0.EN1 4.87471
R15985 programmable_telescopic_cascode_0.EN1.n10 programmable_telescopic_cascode_0.EN1 4.87471
R15986 programmable_telescopic_cascode_0.EN1.n7 programmable_telescopic_cascode_0.EN1 4.87414
R15987 programmable_telescopic_cascode_0.EN1.n22 programmable_telescopic_cascode_0.EN1.n21 4.50168
R15988 programmable_telescopic_cascode_0.EN1.n15 programmable_telescopic_cascode_0.EN1.n14 4.5005
R15989 programmable_telescopic_cascode_0.EN1.n12 programmable_telescopic_cascode_0.EN1.n11 4.5005
R15990 programmable_telescopic_cascode_0.EN1.n9 programmable_telescopic_cascode_0.EN1.n8 4.5005
R15991 programmable_telescopic_cascode_0.EN1.n6 programmable_telescopic_cascode_0.EN1.n5 4.5005
R15992 programmable_telescopic_cascode_0.EN1.n4 programmable_telescopic_cascode_0.EN1.n3 4.5005
R15993 programmable_telescopic_cascode_0.EN1.n20 programmable_telescopic_cascode_0.EN1.n19 4.5005
R15994 programmable_telescopic_cascode_0.EN1.n13 programmable_telescopic_cascode_0.EN1.n10 3.65514
R15995 programmable_telescopic_cascode_0.EN1.n16 programmable_telescopic_cascode_0.EN1.n13 3.65514
R15996 programmable_telescopic_cascode_0.EN1.n10 programmable_telescopic_cascode_0.EN1.n7 3.64229
R15997 programmable_telescopic_cascode_0.EN1.n22 programmable_telescopic_cascode_0.EN1.n20 3.51524
R15998 programmable_telescopic_cascode_0.EN1.n23 programmable_telescopic_cascode_0.EN1.n22 3.09484
R15999 programmable_telescopic_cascode_0.EN1 programmable_telescopic_cascode_0.EN1.n16 0.561393
R16000 programmable_telescopic_cascode_0.EN1.n2 programmable_telescopic_cascode_0.EN1.n1 0.386214
R16001 programmable_telescopic_cascode_0.EN1 programmable_telescopic_cascode_0.EN1.n2 0.246393
R16002 programmable_telescopic_cascode_0.EN1.n1 programmable_telescopic_cascode_0.EN1 0.140321
R16003 programmable_telescopic_cascode_0.EN1.n24 programmable_telescopic_cascode_0.EN1 0.0744286
R16004 programmable_telescopic_cascode_0.EN1.n0 programmable_telescopic_cascode_0.EN1 0.0721524
R16005 programmable_telescopic_cascode_0.EN1 programmable_telescopic_cascode_0.EN1.n24 0.03425
R16006 programmable_telescopic_cascode_0.EN1.n14 programmable_telescopic_cascode_0.EN1 0.0253684
R16007 programmable_telescopic_cascode_0.EN1.n11 programmable_telescopic_cascode_0.EN1 0.0253684
R16008 programmable_telescopic_cascode_0.EN1.n3 programmable_telescopic_cascode_0.EN1 0.00523684
R16009 programmable_telescopic_cascode_0.EN1.n8 programmable_telescopic_cascode_0.EN1 0.00405263
R16010 programmable_telescopic_cascode_0.EN1.n5 programmable_telescopic_cascode_0.EN1 0.00405263
R16011 programmable_telescopic_cascode_0.EN1.n18 programmable_telescopic_cascode_0.EN1 0.00286842
R16012 programmable_telescopic_cascode_0.EN1.n19 programmable_telescopic_cascode_0.EN1 0.00286842
R16013 programmable_telescopic_cascode_0.EN1 programmable_telescopic_cascode_0.EN1.n18 0.00168421
R16014 programmable_telescopic_cascode_0.EN1.n19 programmable_telescopic_cascode_0.EN1 0.00168421
R16015 programmable_telescopic_cascode_0.EN1.n21 programmable_telescopic_cascode_0.EN1 0.00168421
R16016 programmable_telescopic_cascode_0.EN1 programmable_telescopic_cascode_0.EN1.n15 0.00168421
R16017 programmable_telescopic_cascode_0.EN1 programmable_telescopic_cascode_0.EN1.n12 0.00168421
R16018 programmable_telescopic_cascode_0.EN1 programmable_telescopic_cascode_0.EN1.n9 0.00168421
R16019 programmable_telescopic_cascode_0.EN1 programmable_telescopic_cascode_0.EN1.n4 0.00168421
R16020 programmable_telescopic_cascode_0.EN1.n17 programmable_telescopic_cascode_0.EN1 0.00168421
R16021 programmable_telescopic_cascode_0.EN1 programmable_telescopic_cascode_0.EN1.n6 0.00166883
R16022 programmable_telescopic_cascode_0.programmable_nfet$4_1.transmission_gate$24_0.out.t9 programmable_telescopic_cascode_0.programmable_nfet$4_1.transmission_gate$24_0.out.t12 838.953
R16023 programmable_telescopic_cascode_0.programmable_nfet$4_1.transmission_gate$24_0.out.t4 programmable_telescopic_cascode_0.programmable_nfet$4_1.transmission_gate$24_0.out.t9 838.953
R16024 programmable_telescopic_cascode_0.programmable_nfet$4_1.transmission_gate$24_0.out.t7 programmable_telescopic_cascode_0.programmable_nfet$4_1.transmission_gate$24_0.out.t4 838.953
R16025 programmable_telescopic_cascode_0.programmable_nfet$4_1.transmission_gate$24_0.out.t14 programmable_telescopic_cascode_0.programmable_nfet$4_1.transmission_gate$24_0.out.t7 838.953
R16026 programmable_telescopic_cascode_0.programmable_nfet$4_1.transmission_gate$24_0.out.t5 programmable_telescopic_cascode_0.programmable_nfet$4_1.transmission_gate$24_0.out.t14 838.953
R16027 programmable_telescopic_cascode_0.programmable_nfet$4_1.transmission_gate$24_0.out.t3 programmable_telescopic_cascode_0.programmable_nfet$4_1.transmission_gate$24_0.out.t6 838.953
R16028 programmable_telescopic_cascode_0.programmable_nfet$4_1.transmission_gate$24_0.out.t10 programmable_telescopic_cascode_0.programmable_nfet$4_1.transmission_gate$24_0.out.t3 838.953
R16029 programmable_telescopic_cascode_0.programmable_nfet$4_1.transmission_gate$24_0.out.t13 programmable_telescopic_cascode_0.programmable_nfet$4_1.transmission_gate$24_0.out.t10 838.953
R16030 programmable_telescopic_cascode_0.programmable_nfet$4_1.transmission_gate$24_0.out.t8 programmable_telescopic_cascode_0.programmable_nfet$4_1.transmission_gate$24_0.out.t13 838.953
R16031 programmable_telescopic_cascode_0.programmable_nfet$4_1.transmission_gate$24_0.out.t11 programmable_telescopic_cascode_0.programmable_nfet$4_1.transmission_gate$24_0.out.t8 838.953
R16032 programmable_telescopic_cascode_0.programmable_nfet$4_1.transmission_gate$24_0.out.n1 programmable_telescopic_cascode_0.programmable_nfet$4_1.transmission_gate$24_0.out.t5 431.887
R16033 programmable_telescopic_cascode_0.programmable_nfet$4_1.transmission_gate$24_0.out.n0 programmable_telescopic_cascode_0.programmable_nfet$4_1.transmission_gate$24_0.out.t11 431.885
R16034 programmable_telescopic_cascode_0.programmable_nfet$4_1.transmission_gate$24_0.out.n0 programmable_telescopic_cascode_0.programmable_nfet$4_1.transmission_gate$24_0.out.t0 17.7431
R16035 programmable_telescopic_cascode_0.programmable_nfet$4_1.transmission_gate$24_0.out.n2 programmable_telescopic_cascode_0.programmable_nfet$4_1.transmission_gate$24_0.out.t2 12.3005
R16036 programmable_telescopic_cascode_0.programmable_nfet$4_1.transmission_gate$24_0.out programmable_telescopic_cascode_0.programmable_nfet$4_1.transmission_gate$24_0.out.t1 12.2669
R16037 programmable_telescopic_cascode_0.programmable_nfet$4_1.transmission_gate$24_0.out.n2 programmable_telescopic_cascode_0.programmable_nfet$4_1.transmission_gate$24_0.out.n1 5.32728
R16038 programmable_telescopic_cascode_0.programmable_nfet$4_1.transmission_gate$24_0.out programmable_telescopic_cascode_0.programmable_nfet$4_1.transmission_gate$24_0.out.n2 0.2567
R16039 programmable_telescopic_cascode_0.programmable_nfet$4_1.transmission_gate$24_0.out.n1 programmable_telescopic_cascode_0.programmable_nfet$4_1.transmission_gate$24_0.out.n0 0.218395
R16040 programmable_telescopic_cascode_0.programmable_nfet$4_1.transmission_gate$24_1.out.t5 programmable_telescopic_cascode_0.programmable_nfet$4_1.transmission_gate$24_1.out.t6 838.953
R16041 programmable_telescopic_cascode_0.programmable_nfet$4_1.transmission_gate$24_1.out.t8 programmable_telescopic_cascode_0.programmable_nfet$4_1.transmission_gate$24_1.out.t5 838.953
R16042 programmable_telescopic_cascode_0.programmable_nfet$4_1.transmission_gate$24_1.out.t4 programmable_telescopic_cascode_0.programmable_nfet$4_1.transmission_gate$24_1.out.t8 838.953
R16043 programmable_telescopic_cascode_0.programmable_nfet$4_1.transmission_gate$24_1.out.t7 programmable_telescopic_cascode_0.programmable_nfet$4_1.transmission_gate$24_1.out.t4 838.953
R16044 programmable_telescopic_cascode_0.programmable_nfet$4_1.transmission_gate$24_1.out.t3 programmable_telescopic_cascode_0.programmable_nfet$4_1.transmission_gate$24_1.out.t7 838.953
R16045 programmable_telescopic_cascode_0.programmable_nfet$4_1.transmission_gate$24_1.out.n0 programmable_telescopic_cascode_0.programmable_nfet$4_1.transmission_gate$24_1.out.t3 431.889
R16046 programmable_telescopic_cascode_0.programmable_nfet$4_1.transmission_gate$24_1.out.n0 programmable_telescopic_cascode_0.programmable_nfet$4_1.transmission_gate$24_1.out.t0 17.964
R16047 programmable_telescopic_cascode_0.programmable_nfet$4_1.transmission_gate$24_1.out.n1 programmable_telescopic_cascode_0.programmable_nfet$4_1.transmission_gate$24_1.out.t1 12.3005
R16048 programmable_telescopic_cascode_0.programmable_nfet$4_1.transmission_gate$24_1.out programmable_telescopic_cascode_0.programmable_nfet$4_1.transmission_gate$24_1.out.t2 12.2669
R16049 programmable_telescopic_cascode_0.programmable_nfet$4_1.transmission_gate$24_1.out.n1 programmable_telescopic_cascode_0.programmable_nfet$4_1.transmission_gate$24_1.out.n0 5.27657
R16050 programmable_telescopic_cascode_0.programmable_nfet$4_1.transmission_gate$24_1.out programmable_telescopic_cascode_0.programmable_nfet$4_1.transmission_gate$24_1.out.n1 0.256084
R16051 OUT_5T.n13 OUT_5T.n11 31.4277
R16052 OUT_5T.n3 OUT_5T.n1 22.4134
R16053 OUT_5T.n4 OUT_5T.n3 21.9346
R16054 OUT_5T.n19 OUT_5T.n18 17.234
R16055 OUT_5T.n17 OUT_5T.t16 12.2773
R16056 OUT_5T.n15 OUT_5T.t13 12.2773
R16057 OUT_5T.n14 OUT_5T.n10 11.3918
R16058 OUT_5T.n19 OUT_5T 11.1957
R16059 OUT_5T.n18 OUT_5T.n17 7.49892
R16060 OUT_5T.n16 OUT_5T.n15 7.49892
R16061 OUT_5T.n14 OUT_5T.n13 7.49892
R16062 OUT_5T.n7 OUT_5T.n4 6.62063
R16063 OUT_5T.n7 OUT_5T.n6 4.5005
R16064 OUT_5T.n10 OUT_5T.n9 4.5005
R16065 OUT_5T.n8 OUT_5T.t19 3.4252
R16066 OUT_5T.n5 OUT_5T.t6 3.4252
R16067 OUT_5T.n9 OUT_5T.n8 1.78274
R16068 OUT_5T.n6 OUT_5T.n5 1.78274
R16069 OUT_5T.n9 OUT_5T.t17 1.64297
R16070 OUT_5T.n6 OUT_5T.t4 1.64297
R16071 OUT_5T.n18 OUT_5T.n16 1.14058
R16072 OUT_5T.n16 OUT_5T.n14 1.11027
R16073 OUT_5T.n10 OUT_5T.n7 0.814416
R16074 OUT_5T.n8 OUT_5T.t18 0.495466
R16075 OUT_5T.n5 OUT_5T.t5 0.495466
R16076 OUT_5T.n4 OUT_5T.n0 0.479281
R16077 OUT_5T.n3 OUT_5T.n2 0.274413
R16078 OUT_5T.n0 OUT_5T.t10 0.144184
R16079 OUT_5T.n0 OUT_5T.t8 0.144184
R16080 OUT_5T.n2 OUT_5T.t12 0.144184
R16081 OUT_5T.n2 OUT_5T.t9 0.144184
R16082 OUT_5T.n1 OUT_5T.t7 0.144184
R16083 OUT_5T.n1 OUT_5T.t11 0.144184
R16084 OUT_5T.n17 OUT_5T.t15 0.108357
R16085 OUT_5T.n15 OUT_5T.t14 0.108357
R16086 OUT_5T.n13 OUT_5T.n12 0.0495566
R16087 OUT_5T.n12 OUT_5T.t3 0.0369
R16088 OUT_5T.n12 OUT_5T.t0 0.0369
R16089 OUT_5T.n11 OUT_5T.t1 0.0369
R16090 OUT_5T.n11 OUT_5T.t2 0.0369
R16091 OUT_5T OUT_5T.n19 0.00168421
R16092 programmable_folded_cascode_0.programmable_nfet$1_0.g.n3 programmable_folded_cascode_0.programmable_nfet$1_0.g.t33 97.0502
R16093 programmable_folded_cascode_0.programmable_nfet$1_0.g.n30 programmable_folded_cascode_0.programmable_nfet$1_0.g.t5 91.6585
R16094 programmable_folded_cascode_0.programmable_nfet$1_0.g.n30 programmable_folded_cascode_0.programmable_nfet$1_0.g.n29 17.9652
R16095 programmable_folded_cascode_0.programmable_nfet$1_0.g.n23 programmable_folded_cascode_0.programmable_nfet$1_0.g.n18 17.9354
R16096 programmable_folded_cascode_0.programmable_nfet$1_0.g.n9 programmable_folded_cascode_0.programmable_nfet$1_0.g.n7 16.4217
R16097 programmable_folded_cascode_0.programmable_nfet$1_0.g.n11 programmable_folded_cascode_0.programmable_nfet$1_0.g.n9 16.3379
R16098 programmable_folded_cascode_0.programmable_nfet$1_0.g.n13 programmable_folded_cascode_0.programmable_nfet$1_0.g.n11 16.3379
R16099 programmable_folded_cascode_0.programmable_nfet$1_0.g.n15 programmable_folded_cascode_0.programmable_nfet$1_0.g.n13 16.3379
R16100 programmable_folded_cascode_0.programmable_nfet$1_0.g.n5 programmable_folded_cascode_0.programmable_nfet$1_0.g.n4 13.4425
R16101 programmable_folded_cascode_0.programmable_nfet$1_0.g programmable_folded_cascode_0.programmable_nfet$1_0.g.t16 12.5271
R16102 programmable_folded_cascode_0.programmable_nfet$1_0.g programmable_folded_cascode_0.programmable_nfet$1_0.g.t20 12.5271
R16103 programmable_folded_cascode_0.programmable_nfet$1_0.g programmable_folded_cascode_0.programmable_nfet$1_0.g.t15 12.5271
R16104 programmable_folded_cascode_0.programmable_nfet$1_0.g programmable_folded_cascode_0.programmable_nfet$1_0.g.t19 12.5271
R16105 programmable_folded_cascode_0.programmable_nfet$1_0.g.n0 programmable_folded_cascode_0.programmable_nfet$1_0.g.t18 12.2345
R16106 programmable_folded_cascode_0.programmable_nfet$1_0.g.n1 programmable_folded_cascode_0.programmable_nfet$1_0.g.t17 12.2345
R16107 programmable_folded_cascode_0.programmable_nfet$1_0.g.n6 programmable_folded_cascode_0.programmable_nfet$1_0.g.t30 12.2279
R16108 programmable_folded_cascode_0.programmable_nfet$1_0.g.n2 programmable_folded_cascode_0.programmable_nfet$1_0.g.t21 12.2279
R16109 programmable_folded_cascode_0.programmable_nfet$1_0.g.n24 programmable_folded_cascode_0.programmable_nfet$1_0.g.t7 7.53086
R16110 programmable_folded_cascode_0.programmable_nfet$1_0.g.n19 programmable_folded_cascode_0.programmable_nfet$1_0.g.t4 7.44027
R16111 programmable_folded_cascode_0.programmable_nfet$1_0.g.n25 programmable_folded_cascode_0.programmable_nfet$1_0.g.n24 7.34766
R16112 programmable_folded_cascode_0.programmable_nfet$1_0.g.n26 programmable_folded_cascode_0.programmable_nfet$1_0.g.n25 7.34766
R16113 programmable_folded_cascode_0.programmable_nfet$1_0.g.n27 programmable_folded_cascode_0.programmable_nfet$1_0.g.n26 7.34766
R16114 programmable_folded_cascode_0.programmable_nfet$1_0.g.n22 programmable_folded_cascode_0.programmable_nfet$1_0.g.n21 7.34766
R16115 programmable_folded_cascode_0.programmable_nfet$1_0.g.n21 programmable_folded_cascode_0.programmable_nfet$1_0.g.n20 7.30237
R16116 programmable_folded_cascode_0.programmable_nfet$1_0.g.n20 programmable_folded_cascode_0.programmable_nfet$1_0.g.n19 7.25708
R16117 programmable_folded_cascode_0.programmable_nfet$1_0.g.n17 programmable_folded_cascode_0.programmable_nfet$1_0.g.n16 6.03744
R16118 programmable_folded_cascode_0.programmable_nfet$1_0.g.n18 programmable_folded_cascode_0.programmable_nfet$1_0.g.n17 5.76175
R16119 programmable_folded_cascode_0.programmable_nfet$1_0.g.n17 programmable_folded_cascode_0.programmable_nfet$1_0.g.t6 5.58287
R16120 programmable_folded_cascode_0.programmable_nfet$1_0.g.n31 programmable_folded_cascode_0.programmable_nfet$1_0.g.n30 5.39224
R16121 programmable_folded_cascode_0.programmable_nfet$1_0.g.n28 programmable_folded_cascode_0.programmable_nfet$1_0.g.n23 5.38138
R16122 programmable_folded_cascode_0.programmable_nfet$1_0.g.n29 programmable_folded_cascode_0.programmable_nfet$1_0.g.n28 5.34313
R16123 programmable_folded_cascode_0.programmable_nfet$1_0.g.n28 programmable_folded_cascode_0.programmable_nfet$1_0.g.n27 5.16366
R16124 programmable_folded_cascode_0.programmable_nfet$1_0.g.n3 programmable_folded_cascode_0.programmable_nfet$1_0.g.n2 4.71086
R16125 programmable_folded_cascode_0.programmable_nfet$1_0.g.n31 programmable_folded_cascode_0.programmable_nfet$1_0.g.n6 4.71086
R16126 programmable_folded_cascode_0.programmable_nfet$1_0.g.n5 programmable_folded_cascode_0.programmable_nfet$1_0.g.n0 4.60893
R16127 programmable_folded_cascode_0.programmable_nfet$1_0.g.n4 programmable_folded_cascode_0.programmable_nfet$1_0.g.n1 4.60243
R16128 programmable_folded_cascode_0.programmable_nfet$1_0.g.n23 programmable_folded_cascode_0.programmable_nfet$1_0.g.n22 0.664842
R16129 programmable_folded_cascode_0.programmable_nfet$1_0.g.n29 programmable_folded_cascode_0.programmable_nfet$1_0.g.n15 0.663658
R16130 programmable_folded_cascode_0.programmable_nfet$1_0.g.n18 programmable_folded_cascode_0.programmable_nfet$1_0.g.t29 0.554711
R16131 programmable_folded_cascode_0.programmable_nfet$1_0.g.n21 programmable_folded_cascode_0.programmable_nfet$1_0.g.t3 0.183695
R16132 programmable_folded_cascode_0.programmable_nfet$1_0.g.n22 programmable_folded_cascode_0.programmable_nfet$1_0.g.t1 0.183695
R16133 programmable_folded_cascode_0.programmable_nfet$1_0.g.n27 programmable_folded_cascode_0.programmable_nfet$1_0.g.t10 0.183695
R16134 programmable_folded_cascode_0.programmable_nfet$1_0.g.n26 programmable_folded_cascode_0.programmable_nfet$1_0.g.t8 0.183695
R16135 programmable_folded_cascode_0.programmable_nfet$1_0.g.n25 programmable_folded_cascode_0.programmable_nfet$1_0.g.t11 0.183695
R16136 programmable_folded_cascode_0.programmable_nfet$1_0.g.n24 programmable_folded_cascode_0.programmable_nfet$1_0.g.t9 0.183695
R16137 programmable_folded_cascode_0.programmable_nfet$1_0.g.n19 programmable_folded_cascode_0.programmable_nfet$1_0.g.t2 0.183695
R16138 programmable_folded_cascode_0.programmable_nfet$1_0.g.n20 programmable_folded_cascode_0.programmable_nfet$1_0.g.t0 0.183695
R16139 programmable_folded_cascode_0.programmable_nfet$1_0.g.n16 programmable_folded_cascode_0.programmable_nfet$1_0.g.t32 0.1565
R16140 programmable_folded_cascode_0.programmable_nfet$1_0.g.n16 programmable_folded_cascode_0.programmable_nfet$1_0.g.t31 0.1565
R16141 programmable_folded_cascode_0.programmable_nfet$1_0.g.n4 programmable_folded_cascode_0.programmable_nfet$1_0.g 0.087247
R16142 programmable_folded_cascode_0.programmable_nfet$1_0.g.n9 programmable_folded_cascode_0.programmable_nfet$1_0.g.n8 0.084371
R16143 programmable_folded_cascode_0.programmable_nfet$1_0.g.n11 programmable_folded_cascode_0.programmable_nfet$1_0.g.n10 0.084371
R16144 programmable_folded_cascode_0.programmable_nfet$1_0.g.n13 programmable_folded_cascode_0.programmable_nfet$1_0.g.n12 0.084371
R16145 programmable_folded_cascode_0.programmable_nfet$1_0.g.n15 programmable_folded_cascode_0.programmable_nfet$1_0.g.n14 0.084371
R16146 programmable_folded_cascode_0.programmable_nfet$1_0.g programmable_folded_cascode_0.programmable_nfet$1_0.g.n5 0.080741
R16147 programmable_folded_cascode_0.programmable_nfet$1_0.g.n14 programmable_folded_cascode_0.programmable_nfet$1_0.g.t13 0.0619865
R16148 programmable_folded_cascode_0.programmable_nfet$1_0.g.n14 programmable_folded_cascode_0.programmable_nfet$1_0.g.t25 0.0619865
R16149 programmable_folded_cascode_0.programmable_nfet$1_0.g.n12 programmable_folded_cascode_0.programmable_nfet$1_0.g.t22 0.0619865
R16150 programmable_folded_cascode_0.programmable_nfet$1_0.g.n12 programmable_folded_cascode_0.programmable_nfet$1_0.g.t27 0.0619865
R16151 programmable_folded_cascode_0.programmable_nfet$1_0.g.n10 programmable_folded_cascode_0.programmable_nfet$1_0.g.t28 0.0619865
R16152 programmable_folded_cascode_0.programmable_nfet$1_0.g.n10 programmable_folded_cascode_0.programmable_nfet$1_0.g.t23 0.0619865
R16153 programmable_folded_cascode_0.programmable_nfet$1_0.g.n8 programmable_folded_cascode_0.programmable_nfet$1_0.g.t12 0.0619865
R16154 programmable_folded_cascode_0.programmable_nfet$1_0.g.n8 programmable_folded_cascode_0.programmable_nfet$1_0.g.t26 0.0619865
R16155 programmable_folded_cascode_0.programmable_nfet$1_0.g.n7 programmable_folded_cascode_0.programmable_nfet$1_0.g.t14 0.0619865
R16156 programmable_folded_cascode_0.programmable_nfet$1_0.g.n7 programmable_folded_cascode_0.programmable_nfet$1_0.g.t24 0.0619865
R16157 programmable_folded_cascode_0.programmable_nfet$1_0.g.n6 programmable_folded_cascode_0.programmable_nfet$1_0.g 0.0221867
R16158 programmable_folded_cascode_0.programmable_nfet$1_0.g.n2 programmable_folded_cascode_0.programmable_nfet$1_0.g 0.0221867
R16159 programmable_folded_cascode_0.programmable_nfet$1_0.g.n0 programmable_folded_cascode_0.programmable_nfet$1_0.g 0.0156807
R16160 programmable_folded_cascode_0.programmable_nfet$1_0.g.n1 programmable_folded_cascode_0.programmable_nfet$1_0.g 0.0156807
R16161 programmable_folded_cascode_0.programmable_nfet$1_0.g programmable_folded_cascode_0.programmable_nfet$1_0.g.n3 0.0113434
R16162 programmable_folded_cascode_0.programmable_nfet$1_0.g programmable_folded_cascode_0.programmable_nfet$1_0.g.n31 0.0113434
R16163 a_91570_47942.n24 a_91570_47942.n23 34.3794
R16164 a_91570_47942.n23 a_91570_47942.n11 10.3761
R16165 a_91570_47942.n23 a_91570_47942.n22 8.84614
R16166 a_91570_47942.n30 a_91570_47942.n29 5.975
R16167 a_91570_47942.n27 a_91570_47942.t12 5.87481
R16168 a_91570_47942.n33 a_91570_47942.n32 5.76428
R16169 a_91570_47942.n25 a_91570_47942.n24 5.63024
R16170 a_91570_47942.n29 a_91570_47942.n26 5.48
R16171 a_91570_47942.n16 a_91570_47942.n13 5.33
R16172 a_91570_47942.n5 a_91570_47942.n2 5.33
R16173 a_91570_47942.n16 a_91570_47942.n15 4.5005
R16174 a_91570_47942.n19 a_91570_47942.n18 4.5005
R16175 a_91570_47942.n22 a_91570_47942.n21 4.5005
R16176 a_91570_47942.n5 a_91570_47942.n4 4.5005
R16177 a_91570_47942.n8 a_91570_47942.n7 4.5005
R16178 a_91570_47942.n11 a_91570_47942.n10 4.5005
R16179 a_91570_47942.n29 a_91570_47942.n28 4.5005
R16180 a_91570_47942.n28 a_91570_47942.t17 3.51586
R16181 a_91570_47942.n26 a_91570_47942.t18 3.51586
R16182 a_91570_47942.n20 a_91570_47942.t28 3.4252
R16183 a_91570_47942.n17 a_91570_47942.t24 3.4252
R16184 a_91570_47942.n14 a_91570_47942.t23 3.4252
R16185 a_91570_47942.n12 a_91570_47942.t35 3.4252
R16186 a_91570_47942.n9 a_91570_47942.t2 3.4252
R16187 a_91570_47942.n6 a_91570_47942.t4 3.4252
R16188 a_91570_47942.n3 a_91570_47942.t15 3.4252
R16189 a_91570_47942.n1 a_91570_47942.t31 3.4252
R16190 a_91570_47942.n30 a_91570_47942.n0 3.40533
R16191 a_91570_47942.n28 a_91570_47942.n27 2.35945
R16192 a_91570_47942.n26 a_91570_47942.n25 2.35945
R16193 a_91570_47942.n32 a_91570_47942.n30 2.35945
R16194 a_91570_47942.n21 a_91570_47942.n20 2.02432
R16195 a_91570_47942.n18 a_91570_47942.n17 2.02432
R16196 a_91570_47942.n15 a_91570_47942.n14 2.02432
R16197 a_91570_47942.n10 a_91570_47942.n9 2.02432
R16198 a_91570_47942.n7 a_91570_47942.n6 2.02432
R16199 a_91570_47942.n4 a_91570_47942.n3 2.02432
R16200 a_91570_47942.n13 a_91570_47942.n12 2.02313
R16201 a_91570_47942.n2 a_91570_47942.n1 2.02313
R16202 a_91570_47942.n13 a_91570_47942.t33 1.40257
R16203 a_91570_47942.n2 a_91570_47942.t30 1.40257
R16204 a_91570_47942.n21 a_91570_47942.t25 1.40139
R16205 a_91570_47942.n18 a_91570_47942.t27 1.40139
R16206 a_91570_47942.n15 a_91570_47942.t21 1.40139
R16207 a_91570_47942.n10 a_91570_47942.t6 1.40139
R16208 a_91570_47942.n7 a_91570_47942.t7 1.40139
R16209 a_91570_47942.n4 a_91570_47942.t13 1.40139
R16210 a_91570_47942.n11 a_91570_47942.n8 0.68377
R16211 a_91570_47942.n22 a_91570_47942.n19 0.682068
R16212 a_91570_47942.n20 a_91570_47942.t26 0.495466
R16213 a_91570_47942.n17 a_91570_47942.t29 0.495466
R16214 a_91570_47942.n14 a_91570_47942.t22 0.495466
R16215 a_91570_47942.n12 a_91570_47942.t34 0.495466
R16216 a_91570_47942.n9 a_91570_47942.t3 0.495466
R16217 a_91570_47942.n6 a_91570_47942.t5 0.495466
R16218 a_91570_47942.n3 a_91570_47942.t14 0.495466
R16219 a_91570_47942.n1 a_91570_47942.t32 0.495466
R16220 a_91570_47942.n19 a_91570_47942.n16 0.4415
R16221 a_91570_47942.n8 a_91570_47942.n5 0.4415
R16222 a_91570_47942.n27 a_91570_47942.t16 0.245069
R16223 a_91570_47942.n25 a_91570_47942.t20 0.245069
R16224 a_91570_47942.n24 a_91570_47942.t19 0.245069
R16225 a_91570_47942.n32 a_91570_47942.n31 0.134543
R16226 a_91570_47942.n0 a_91570_47942.t11 0.0723421
R16227 a_91570_47942.n0 a_91570_47942.t8 0.0723421
R16228 a_91570_47942.n31 a_91570_47942.t1 0.0723421
R16229 a_91570_47942.n31 a_91570_47942.t10 0.0723421
R16230 a_91570_47942.t0 a_91570_47942.n33 0.0723421
R16231 a_91570_47942.n33 a_91570_47942.t9 0.0723421
R16232 a_61069_4063.t20 a_61069_4063.t22 184.591
R16233 a_61069_4063.t23 a_61069_4063.t20 184.591
R16234 a_61069_4063.t21 a_61069_4063.t23 184.591
R16235 a_61069_4063.t24 a_61069_4063.t21 184.591
R16236 a_61069_4063.t16 a_61069_4063.t18 184.57
R16237 a_61069_4063.t14 a_61069_4063.t16 184.57
R16238 a_61069_4063.t10 a_61069_4063.t14 184.57
R16239 a_61069_4063.t12 a_61069_4063.t10 184.57
R16240 a_61069_4063.n4 a_61069_4063.t24 101.275
R16241 a_61069_4063.n4 a_61069_4063.t12 100.242
R16242 a_61069_4063.n10 a_61069_4063.n9 16.0087
R16243 a_61069_4063.n5 a_61069_4063.t19 6.01087
R16244 a_61069_4063.n8 a_61069_4063.n7 5.77471
R16245 a_61069_4063.n7 a_61069_4063.n6 5.77471
R16246 a_61069_4063.n6 a_61069_4063.n5 5.77471
R16247 a_61069_4063.n0 a_61069_4063.t4 5.18707
R16248 a_61069_4063.n14 a_61069_4063.t0 5.18707
R16249 a_61069_4063.n9 a_61069_4063.n4 4.98879
R16250 a_61069_4063.n1 a_61069_4063.n0 4.91024
R16251 a_61069_4063.n2 a_61069_4063.n1 4.91024
R16252 a_61069_4063.n3 a_61069_4063.n2 4.91024
R16253 a_61069_4063.n12 a_61069_4063.n11 4.91024
R16254 a_61069_4063.n13 a_61069_4063.n12 4.91024
R16255 a_61069_4063.n14 a_61069_4063.n13 4.91024
R16256 a_61069_4063.n11 a_61069_4063.n10 4.76998
R16257 a_61069_4063.n9 a_61069_4063.n8 2.34524
R16258 a_61069_4063.n13 a_61069_4063.t2 0.277329
R16259 a_61069_4063.n12 a_61069_4063.t7 0.277329
R16260 a_61069_4063.n11 a_61069_4063.t3 0.277329
R16261 a_61069_4063.n3 a_61069_4063.t5 0.277329
R16262 a_61069_4063.n2 a_61069_4063.t1 0.277329
R16263 a_61069_4063.n1 a_61069_4063.t6 0.277329
R16264 a_61069_4063.n0 a_61069_4063.t8 0.277329
R16265 a_61069_4063.t9 a_61069_4063.n14 0.277329
R16266 a_61069_4063.n8 a_61069_4063.t13 0.236659
R16267 a_61069_4063.n7 a_61069_4063.t11 0.236659
R16268 a_61069_4063.n6 a_61069_4063.t15 0.236659
R16269 a_61069_4063.n5 a_61069_4063.t17 0.236659
R16270 a_61069_4063.n10 a_61069_4063.n3 0.14076
R16271 programmable_telescopic_cascode_0.programmable_pfet$2_0.transmission_gate$22_1.out.t5 programmable_telescopic_cascode_0.programmable_pfet$2_0.transmission_gate$22_1.out.t3 706.348
R16272 programmable_telescopic_cascode_0.programmable_pfet$2_0.transmission_gate$22_1.out.t6 programmable_telescopic_cascode_0.programmable_pfet$2_0.transmission_gate$22_1.out.t5 706.348
R16273 programmable_telescopic_cascode_0.programmable_pfet$2_0.transmission_gate$22_1.out.t7 programmable_telescopic_cascode_0.programmable_pfet$2_0.transmission_gate$22_1.out.t6 706.348
R16274 programmable_telescopic_cascode_0.programmable_pfet$2_0.transmission_gate$22_1.out.t4 programmable_telescopic_cascode_0.programmable_pfet$2_0.transmission_gate$22_1.out.t7 706.348
R16275 programmable_telescopic_cascode_0.programmable_pfet$2_0.transmission_gate$22_1.out.n0 programmable_telescopic_cascode_0.programmable_pfet$2_0.transmission_gate$22_1.out.t4 358.36
R16276 programmable_telescopic_cascode_0.programmable_pfet$2_0.transmission_gate$22_1.out.n0 programmable_telescopic_cascode_0.programmable_pfet$2_0.transmission_gate$22_1.out.t0 22.5385
R16277 programmable_telescopic_cascode_0.programmable_pfet$2_0.transmission_gate$22_1.out.n1 programmable_telescopic_cascode_0.programmable_pfet$2_0.transmission_gate$22_1.out.t1 12.5327
R16278 programmable_telescopic_cascode_0.programmable_pfet$2_0.transmission_gate$22_1.out programmable_telescopic_cascode_0.programmable_pfet$2_0.transmission_gate$22_1.out.t2 12.2669
R16279 programmable_telescopic_cascode_0.programmable_pfet$2_0.transmission_gate$22_1.out.n1 programmable_telescopic_cascode_0.programmable_pfet$2_0.transmission_gate$22_1.out.n0 10.0675
R16280 programmable_telescopic_cascode_0.programmable_pfet$2_0.transmission_gate$22_1.out programmable_telescopic_cascode_0.programmable_pfet$2_0.transmission_gate$22_1.out.n1 0.0245
R16281 programmable_telescopic_cascode_0.programmable_pfet$3_0.g.t57 programmable_telescopic_cascode_0.programmable_pfet$3_0.g.t62 604.149
R16282 programmable_telescopic_cascode_0.programmable_pfet$3_0.g.t63 programmable_telescopic_cascode_0.programmable_pfet$3_0.g.t57 604.149
R16283 programmable_telescopic_cascode_0.programmable_pfet$3_0.g.t55 programmable_telescopic_cascode_0.programmable_pfet$3_0.g.t63 604.149
R16284 programmable_telescopic_cascode_0.programmable_pfet$3_0.g.t56 programmable_telescopic_cascode_0.programmable_pfet$3_0.g.t55 604.149
R16285 programmable_telescopic_cascode_0.programmable_pfet$3_0.g.t53 programmable_telescopic_cascode_0.programmable_pfet$3_0.g.t56 604.149
R16286 programmable_telescopic_cascode_0.programmable_pfet$3_0.g.t61 programmable_telescopic_cascode_0.programmable_pfet$3_0.g.t52 604.149
R16287 programmable_telescopic_cascode_0.programmable_pfet$3_0.g.t54 programmable_telescopic_cascode_0.programmable_pfet$3_0.g.t61 604.149
R16288 programmable_telescopic_cascode_0.programmable_pfet$3_0.g.t59 programmable_telescopic_cascode_0.programmable_pfet$3_0.g.t54 604.149
R16289 programmable_telescopic_cascode_0.programmable_pfet$3_0.g.t60 programmable_telescopic_cascode_0.programmable_pfet$3_0.g.t59 604.149
R16290 programmable_telescopic_cascode_0.programmable_pfet$3_0.g.t58 programmable_telescopic_cascode_0.programmable_pfet$3_0.g.t60 604.149
R16291 programmable_telescopic_cascode_0.programmable_pfet$3_0.g.n49 programmable_telescopic_cascode_0.programmable_pfet$3_0.g.t53 307.154
R16292 programmable_telescopic_cascode_0.programmable_pfet$3_0.g.n47 programmable_telescopic_cascode_0.programmable_pfet$3_0.g.t58 307.154
R16293 programmable_telescopic_cascode_0.programmable_pfet$3_0.g.n8 programmable_telescopic_cascode_0.programmable_pfet$3_0.g.n6 19.9544
R16294 programmable_telescopic_cascode_0.programmable_pfet$3_0.g.n12 programmable_telescopic_cascode_0.programmable_pfet$3_0.g.n10 19.8881
R16295 programmable_telescopic_cascode_0.programmable_pfet$3_0.g.n10 programmable_telescopic_cascode_0.programmable_pfet$3_0.g.n8 19.8881
R16296 programmable_telescopic_cascode_0.programmable_pfet$3_0.g.n14 programmable_telescopic_cascode_0.programmable_pfet$3_0.g.n12 19.8881
R16297 programmable_telescopic_cascode_0.programmable_pfet$3_0.g.n15 programmable_telescopic_cascode_0.programmable_pfet$3_0.g.n14 17.2923
R16298 programmable_telescopic_cascode_0.programmable_pfet$3_0.g.n40 programmable_telescopic_cascode_0.programmable_pfet$3_0.g.n30 16.8033
R16299 programmable_telescopic_cascode_0.programmable_pfet$3_0.g.n45 programmable_telescopic_cascode_0.programmable_pfet$3_0.g.t1 12.5109
R16300 programmable_telescopic_cascode_0.programmable_pfet$3_0.g.n51 programmable_telescopic_cascode_0.programmable_pfet$3_0.g.t0 12.5109
R16301 programmable_telescopic_cascode_0.programmable_pfet$3_0.g.n0 programmable_telescopic_cascode_0.programmable_pfet$3_0.g.t24 12.5087
R16302 programmable_telescopic_cascode_0.programmable_pfet$3_0.g.n44 programmable_telescopic_cascode_0.programmable_pfet$3_0.g.t23 12.5087
R16303 programmable_telescopic_cascode_0.programmable_pfet$3_0.g programmable_telescopic_cascode_0.programmable_pfet$3_0.g.t2 12.2496
R16304 programmable_telescopic_cascode_0.programmable_pfet$3_0.g programmable_telescopic_cascode_0.programmable_pfet$3_0.g.t11 12.2496
R16305 programmable_telescopic_cascode_0.programmable_pfet$3_0.g programmable_telescopic_cascode_0.programmable_pfet$3_0.g.t17 12.2496
R16306 programmable_telescopic_cascode_0.programmable_pfet$3_0.g programmable_telescopic_cascode_0.programmable_pfet$3_0.g.t10 12.2496
R16307 programmable_telescopic_cascode_0.programmable_pfet$3_0.g.n43 programmable_telescopic_cascode_0.programmable_pfet$3_0.g.n23 12.0053
R16308 programmable_telescopic_cascode_0.programmable_pfet$3_0.g.n31 programmable_telescopic_cascode_0.programmable_pfet$3_0.g.t22 11.574
R16309 programmable_telescopic_cascode_0.programmable_pfet$3_0.g.n35 programmable_telescopic_cascode_0.programmable_pfet$3_0.g.t4 11.574
R16310 programmable_telescopic_cascode_0.programmable_pfet$3_0.g.n30 programmable_telescopic_cascode_0.programmable_pfet$3_0.g.n28 11.4601
R16311 programmable_telescopic_cascode_0.programmable_pfet$3_0.g.n28 programmable_telescopic_cascode_0.programmable_pfet$3_0.g.n26 11.4589
R16312 programmable_telescopic_cascode_0.programmable_pfet$3_0.g.n33 programmable_telescopic_cascode_0.programmable_pfet$3_0.g.n32 11.4589
R16313 programmable_telescopic_cascode_0.programmable_pfet$3_0.g.n32 programmable_telescopic_cascode_0.programmable_pfet$3_0.g.n31 11.4589
R16314 programmable_telescopic_cascode_0.programmable_pfet$3_0.g.n37 programmable_telescopic_cascode_0.programmable_pfet$3_0.g.n36 11.4589
R16315 programmable_telescopic_cascode_0.programmable_pfet$3_0.g.n36 programmable_telescopic_cascode_0.programmable_pfet$3_0.g.n35 11.4589
R16316 programmable_telescopic_cascode_0.programmable_pfet$3_0.g.n26 programmable_telescopic_cascode_0.programmable_pfet$3_0.g.n24 10.5155
R16317 programmable_telescopic_cascode_0.programmable_pfet$3_0.g.n16 programmable_telescopic_cascode_0.programmable_pfet$3_0.g.t30 10.5057
R16318 programmable_telescopic_cascode_0.programmable_pfet$3_0.g.n1 programmable_telescopic_cascode_0.programmable_pfet$3_0.g.t5 10.5057
R16319 programmable_telescopic_cascode_0.programmable_pfet$3_0.g.n28 programmable_telescopic_cascode_0.programmable_pfet$3_0.g.n27 10.0489
R16320 programmable_telescopic_cascode_0.programmable_pfet$3_0.g.n26 programmable_telescopic_cascode_0.programmable_pfet$3_0.g.n25 10.0489
R16321 programmable_telescopic_cascode_0.programmable_pfet$3_0.g.n30 programmable_telescopic_cascode_0.programmable_pfet$3_0.g.n29 10.0478
R16322 programmable_telescopic_cascode_0.programmable_pfet$3_0.g.n17 programmable_telescopic_cascode_0.programmable_pfet$3_0.g.n16 9.87873
R16323 programmable_telescopic_cascode_0.programmable_pfet$3_0.g.n18 programmable_telescopic_cascode_0.programmable_pfet$3_0.g.n17 9.87873
R16324 programmable_telescopic_cascode_0.programmable_pfet$3_0.g.n19 programmable_telescopic_cascode_0.programmable_pfet$3_0.g.n18 9.87873
R16325 programmable_telescopic_cascode_0.programmable_pfet$3_0.g.n2 programmable_telescopic_cascode_0.programmable_pfet$3_0.g.n1 9.87873
R16326 programmable_telescopic_cascode_0.programmable_pfet$3_0.g.n3 programmable_telescopic_cascode_0.programmable_pfet$3_0.g.n2 9.87873
R16327 programmable_telescopic_cascode_0.programmable_pfet$3_0.g.n4 programmable_telescopic_cascode_0.programmable_pfet$3_0.g.n3 9.87873
R16328 programmable_telescopic_cascode_0.programmable_pfet$3_0.g.n49 programmable_telescopic_cascode_0.programmable_pfet$3_0.g.n48 9.70289
R16329 programmable_telescopic_cascode_0.programmable_pfet$3_0.g.n43 programmable_telescopic_cascode_0.programmable_pfet$3_0.g.n42 9.03839
R16330 programmable_telescopic_cascode_0.programmable_pfet$3_0.g.n22 programmable_telescopic_cascode_0.programmable_pfet$3_0.g.n4 7.78764
R16331 programmable_telescopic_cascode_0.programmable_pfet$3_0.g.n20 programmable_telescopic_cascode_0.programmable_pfet$3_0.g.n19 7.78646
R16332 programmable_telescopic_cascode_0.programmable_pfet$3_0.g.n34 programmable_telescopic_cascode_0.programmable_pfet$3_0.g.n33 6.80853
R16333 programmable_telescopic_cascode_0.programmable_pfet$3_0.g.n38 programmable_telescopic_cascode_0.programmable_pfet$3_0.g.n37 6.80853
R16334 programmable_telescopic_cascode_0.programmable_pfet$3_0.g.n48 programmable_telescopic_cascode_0.programmable_pfet$3_0.g.n43 6.3905
R16335 programmable_telescopic_cascode_0.programmable_pfet$3_0.g.n40 programmable_telescopic_cascode_0.programmable_pfet$3_0.g.n39 5.70603
R16336 programmable_telescopic_cascode_0.programmable_pfet$3_0.g.n48 programmable_telescopic_cascode_0.programmable_pfet$3_0.g.n47 5.54084
R16337 programmable_telescopic_cascode_0.programmable_pfet$3_0.g.n47 programmable_telescopic_cascode_0.programmable_pfet$3_0.g.n46 5.31931
R16338 programmable_telescopic_cascode_0.programmable_pfet$3_0.g.n50 programmable_telescopic_cascode_0.programmable_pfet$3_0.g.n49 5.31931
R16339 programmable_telescopic_cascode_0.programmable_pfet$3_0.g programmable_telescopic_cascode_0.programmable_pfet$3_0.g.n15 5.18086
R16340 programmable_telescopic_cascode_0.programmable_pfet$3_0.g programmable_telescopic_cascode_0.programmable_pfet$3_0.g.n34 5.16247
R16341 programmable_telescopic_cascode_0.programmable_pfet$3_0.g.n22 programmable_telescopic_cascode_0.programmable_pfet$3_0.g.n21 5.07264
R16342 programmable_telescopic_cascode_0.programmable_pfet$3_0.g.n34 programmable_telescopic_cascode_0.programmable_pfet$3_0.g.t21 4.76597
R16343 programmable_telescopic_cascode_0.programmable_pfet$3_0.g.n38 programmable_telescopic_cascode_0.programmable_pfet$3_0.g.t13 4.76597
R16344 programmable_telescopic_cascode_0.programmable_pfet$3_0.g.n46 programmable_telescopic_cascode_0.programmable_pfet$3_0.g.n44 4.73024
R16345 programmable_telescopic_cascode_0.programmable_pfet$3_0.g.n50 programmable_telescopic_cascode_0.programmable_pfet$3_0.g.n0 4.73024
R16346 programmable_telescopic_cascode_0.programmable_pfet$3_0.g.n42 programmable_telescopic_cascode_0.programmable_pfet$3_0.g.n40 4.65089
R16347 programmable_telescopic_cascode_0.programmable_pfet$3_0.g programmable_telescopic_cascode_0.programmable_pfet$3_0.g.n45 4.63076
R16348 programmable_telescopic_cascode_0.programmable_pfet$3_0.g.n51 programmable_telescopic_cascode_0.programmable_pfet$3_0.g 4.63076
R16349 programmable_telescopic_cascode_0.programmable_pfet$3_0.g.n39 programmable_telescopic_cascode_0.programmable_pfet$3_0.g.n38 4.5005
R16350 programmable_telescopic_cascode_0.programmable_pfet$3_0.g.n21 programmable_telescopic_cascode_0.programmable_pfet$3_0.g.n20 4.5005
R16351 programmable_telescopic_cascode_0.programmable_pfet$3_0.g.n20 programmable_telescopic_cascode_0.programmable_pfet$3_0.g.t27 2.71979
R16352 programmable_telescopic_cascode_0.programmable_pfet$3_0.g.n15 programmable_telescopic_cascode_0.programmable_pfet$3_0.g.n5 2.66261
R16353 programmable_telescopic_cascode_0.programmable_pfet$3_0.g.n23 programmable_telescopic_cascode_0.programmable_pfet$3_0.g.n22 2.59629
R16354 programmable_telescopic_cascode_0.programmable_pfet$3_0.g.n39 programmable_telescopic_cascode_0.programmable_pfet$3_0.g 0.264579
R16355 programmable_telescopic_cascode_0.programmable_pfet$3_0.g.n23 programmable_telescopic_cascode_0.programmable_pfet$3_0.g.t8 0.122816
R16356 programmable_telescopic_cascode_0.programmable_pfet$3_0.g.n19 programmable_telescopic_cascode_0.programmable_pfet$3_0.g.t29 0.122816
R16357 programmable_telescopic_cascode_0.programmable_pfet$3_0.g.n18 programmable_telescopic_cascode_0.programmable_pfet$3_0.g.t26 0.122816
R16358 programmable_telescopic_cascode_0.programmable_pfet$3_0.g.n17 programmable_telescopic_cascode_0.programmable_pfet$3_0.g.t28 0.122816
R16359 programmable_telescopic_cascode_0.programmable_pfet$3_0.g.n16 programmable_telescopic_cascode_0.programmable_pfet$3_0.g.t25 0.122816
R16360 programmable_telescopic_cascode_0.programmable_pfet$3_0.g.n4 programmable_telescopic_cascode_0.programmable_pfet$3_0.g.t6 0.122816
R16361 programmable_telescopic_cascode_0.programmable_pfet$3_0.g.n3 programmable_telescopic_cascode_0.programmable_pfet$3_0.g.t15 0.122816
R16362 programmable_telescopic_cascode_0.programmable_pfet$3_0.g.n2 programmable_telescopic_cascode_0.programmable_pfet$3_0.g.t7 0.122816
R16363 programmable_telescopic_cascode_0.programmable_pfet$3_0.g.n1 programmable_telescopic_cascode_0.programmable_pfet$3_0.g.t16 0.122816
R16364 programmable_telescopic_cascode_0.programmable_pfet$3_0.g.n21 programmable_telescopic_cascode_0.programmable_pfet$3_0.g 0.1205
R16365 programmable_telescopic_cascode_0.programmable_pfet$3_0.g.n33 programmable_telescopic_cascode_0.programmable_pfet$3_0.g.t18 0.115578
R16366 programmable_telescopic_cascode_0.programmable_pfet$3_0.g.n32 programmable_telescopic_cascode_0.programmable_pfet$3_0.g.t19 0.115578
R16367 programmable_telescopic_cascode_0.programmable_pfet$3_0.g.n31 programmable_telescopic_cascode_0.programmable_pfet$3_0.g.t20 0.115578
R16368 programmable_telescopic_cascode_0.programmable_pfet$3_0.g.n37 programmable_telescopic_cascode_0.programmable_pfet$3_0.g.t3 0.115578
R16369 programmable_telescopic_cascode_0.programmable_pfet$3_0.g.n36 programmable_telescopic_cascode_0.programmable_pfet$3_0.g.t12 0.115578
R16370 programmable_telescopic_cascode_0.programmable_pfet$3_0.g.n35 programmable_telescopic_cascode_0.programmable_pfet$3_0.g.t14 0.115578
R16371 programmable_telescopic_cascode_0.programmable_pfet$3_0.g.n46 programmable_telescopic_cascode_0.programmable_pfet$3_0.g 0.0928684
R16372 programmable_telescopic_cascode_0.programmable_pfet$3_0.g programmable_telescopic_cascode_0.programmable_pfet$3_0.g.n50 0.0928684
R16373 programmable_telescopic_cascode_0.programmable_pfet$3_0.g.n8 programmable_telescopic_cascode_0.programmable_pfet$3_0.g.n7 0.0668158
R16374 programmable_telescopic_cascode_0.programmable_pfet$3_0.g.n10 programmable_telescopic_cascode_0.programmable_pfet$3_0.g.n9 0.0668158
R16375 programmable_telescopic_cascode_0.programmable_pfet$3_0.g.n12 programmable_telescopic_cascode_0.programmable_pfet$3_0.g.n11 0.0668158
R16376 programmable_telescopic_cascode_0.programmable_pfet$3_0.g.n14 programmable_telescopic_cascode_0.programmable_pfet$3_0.g.n13 0.0668158
R16377 programmable_telescopic_cascode_0.programmable_pfet$3_0.g.n42 programmable_telescopic_cascode_0.programmable_pfet$3_0.g.n41 0.0530253
R16378 programmable_telescopic_cascode_0.programmable_pfet$3_0.g.n41 programmable_telescopic_cascode_0.programmable_pfet$3_0.g.t39 0.0392234
R16379 programmable_telescopic_cascode_0.programmable_pfet$3_0.g.n41 programmable_telescopic_cascode_0.programmable_pfet$3_0.g.t37 0.0392234
R16380 programmable_telescopic_cascode_0.programmable_pfet$3_0.g.n29 programmable_telescopic_cascode_0.programmable_pfet$3_0.g.t34 0.0392234
R16381 programmable_telescopic_cascode_0.programmable_pfet$3_0.g.n29 programmable_telescopic_cascode_0.programmable_pfet$3_0.g.t40 0.0392234
R16382 programmable_telescopic_cascode_0.programmable_pfet$3_0.g.n27 programmable_telescopic_cascode_0.programmable_pfet$3_0.g.t36 0.0392234
R16383 programmable_telescopic_cascode_0.programmable_pfet$3_0.g.n27 programmable_telescopic_cascode_0.programmable_pfet$3_0.g.t33 0.0392234
R16384 programmable_telescopic_cascode_0.programmable_pfet$3_0.g.n25 programmable_telescopic_cascode_0.programmable_pfet$3_0.g.t41 0.0392234
R16385 programmable_telescopic_cascode_0.programmable_pfet$3_0.g.n25 programmable_telescopic_cascode_0.programmable_pfet$3_0.g.t38 0.0392234
R16386 programmable_telescopic_cascode_0.programmable_pfet$3_0.g.n24 programmable_telescopic_cascode_0.programmable_pfet$3_0.g.t35 0.0392234
R16387 programmable_telescopic_cascode_0.programmable_pfet$3_0.g.n24 programmable_telescopic_cascode_0.programmable_pfet$3_0.g.t42 0.0392234
R16388 programmable_telescopic_cascode_0.programmable_pfet$3_0.g.n5 programmable_telescopic_cascode_0.programmable_pfet$3_0.g.t51 0.0369
R16389 programmable_telescopic_cascode_0.programmable_pfet$3_0.g.n5 programmable_telescopic_cascode_0.programmable_pfet$3_0.g.t9 0.0369
R16390 programmable_telescopic_cascode_0.programmable_pfet$3_0.g.n13 programmable_telescopic_cascode_0.programmable_pfet$3_0.g.t47 0.0369
R16391 programmable_telescopic_cascode_0.programmable_pfet$3_0.g.n13 programmable_telescopic_cascode_0.programmable_pfet$3_0.g.t48 0.0369
R16392 programmable_telescopic_cascode_0.programmable_pfet$3_0.g.n11 programmable_telescopic_cascode_0.programmable_pfet$3_0.g.t31 0.0369
R16393 programmable_telescopic_cascode_0.programmable_pfet$3_0.g.n11 programmable_telescopic_cascode_0.programmable_pfet$3_0.g.t32 0.0369
R16394 programmable_telescopic_cascode_0.programmable_pfet$3_0.g.n9 programmable_telescopic_cascode_0.programmable_pfet$3_0.g.t49 0.0369
R16395 programmable_telescopic_cascode_0.programmable_pfet$3_0.g.n9 programmable_telescopic_cascode_0.programmable_pfet$3_0.g.t50 0.0369
R16396 programmable_telescopic_cascode_0.programmable_pfet$3_0.g.n7 programmable_telescopic_cascode_0.programmable_pfet$3_0.g.t43 0.0369
R16397 programmable_telescopic_cascode_0.programmable_pfet$3_0.g.n7 programmable_telescopic_cascode_0.programmable_pfet$3_0.g.t44 0.0369
R16398 programmable_telescopic_cascode_0.programmable_pfet$3_0.g.n6 programmable_telescopic_cascode_0.programmable_pfet$3_0.g.t45 0.0369
R16399 programmable_telescopic_cascode_0.programmable_pfet$3_0.g.n6 programmable_telescopic_cascode_0.programmable_pfet$3_0.g.t46 0.0369
R16400 programmable_telescopic_cascode_0.programmable_pfet$3_0.g.n0 programmable_telescopic_cascode_0.programmable_pfet$3_0.g 0.0189337
R16401 programmable_telescopic_cascode_0.programmable_pfet$3_0.g.n44 programmable_telescopic_cascode_0.programmable_pfet$3_0.g 0.0189337
R16402 programmable_telescopic_cascode_0.programmable_pfet$3_0.g.n45 programmable_telescopic_cascode_0.programmable_pfet$3_0.g 0.0167651
R16403 programmable_telescopic_cascode_0.programmable_pfet$3_0.g programmable_telescopic_cascode_0.programmable_pfet$3_0.g.n51 0.0167651
R16404 programmable_telescopic_cascode_0.programmable_pfet$3_0.d.n19 programmable_telescopic_cascode_0.programmable_pfet$3_0.d.n17 19.103
R16405 programmable_telescopic_cascode_0.programmable_pfet$3_0.d.n37 programmable_telescopic_cascode_0.programmable_pfet$3_0.d.n36 14.1504
R16406 programmable_telescopic_cascode_0.programmable_pfet$3_0.d.n9 programmable_telescopic_cascode_0.programmable_pfet$3_0.d.t1 11.574
R16407 programmable_telescopic_cascode_0.programmable_pfet$3_0.d.n38 programmable_telescopic_cascode_0.programmable_pfet$3_0.d.t17 11.574
R16408 programmable_telescopic_cascode_0.programmable_pfet$3_0.d.n4 programmable_telescopic_cascode_0.programmable_pfet$3_0.d.t38 11.574
R16409 programmable_telescopic_cascode_0.programmable_pfet$3_0.d.n0 programmable_telescopic_cascode_0.programmable_pfet$3_0.d.t31 11.574
R16410 programmable_telescopic_cascode_0.programmable_pfet$3_0.d.n40 programmable_telescopic_cascode_0.programmable_pfet$3_0.d.n39 11.4589
R16411 programmable_telescopic_cascode_0.programmable_pfet$3_0.d.n39 programmable_telescopic_cascode_0.programmable_pfet$3_0.d.n38 11.4589
R16412 programmable_telescopic_cascode_0.programmable_pfet$3_0.d.n6 programmable_telescopic_cascode_0.programmable_pfet$3_0.d.n5 11.4589
R16413 programmable_telescopic_cascode_0.programmable_pfet$3_0.d.n5 programmable_telescopic_cascode_0.programmable_pfet$3_0.d.n4 11.4589
R16414 programmable_telescopic_cascode_0.programmable_pfet$3_0.d.n2 programmable_telescopic_cascode_0.programmable_pfet$3_0.d.n1 11.4589
R16415 programmable_telescopic_cascode_0.programmable_pfet$3_0.d.n1 programmable_telescopic_cascode_0.programmable_pfet$3_0.d.n0 11.4589
R16416 programmable_telescopic_cascode_0.programmable_pfet$3_0.d.n11 programmable_telescopic_cascode_0.programmable_pfet$3_0.d.n10 11.4589
R16417 programmable_telescopic_cascode_0.programmable_pfet$3_0.d.n10 programmable_telescopic_cascode_0.programmable_pfet$3_0.d.n9 11.4589
R16418 programmable_telescopic_cascode_0.programmable_pfet$3_0.d.n24 programmable_telescopic_cascode_0.programmable_pfet$3_0.d.t42 9.93643
R16419 programmable_telescopic_cascode_0.programmable_pfet$3_0.d.n29 programmable_telescopic_cascode_0.programmable_pfet$3_0.d.t23 9.93643
R16420 programmable_telescopic_cascode_0.programmable_pfet$3_0.d.n23 programmable_telescopic_cascode_0.programmable_pfet$3_0.d.n21 9.80339
R16421 programmable_telescopic_cascode_0.programmable_pfet$3_0.d.n27 programmable_telescopic_cascode_0.programmable_pfet$3_0.d.n26 9.80103
R16422 programmable_telescopic_cascode_0.programmable_pfet$3_0.d.n26 programmable_telescopic_cascode_0.programmable_pfet$3_0.d.n25 9.80103
R16423 programmable_telescopic_cascode_0.programmable_pfet$3_0.d.n25 programmable_telescopic_cascode_0.programmable_pfet$3_0.d.n24 9.80103
R16424 programmable_telescopic_cascode_0.programmable_pfet$3_0.d.n32 programmable_telescopic_cascode_0.programmable_pfet$3_0.d.n31 9.80103
R16425 programmable_telescopic_cascode_0.programmable_pfet$3_0.d.n31 programmable_telescopic_cascode_0.programmable_pfet$3_0.d.n30 9.80103
R16426 programmable_telescopic_cascode_0.programmable_pfet$3_0.d.n30 programmable_telescopic_cascode_0.programmable_pfet$3_0.d.n29 9.80103
R16427 programmable_telescopic_cascode_0.programmable_pfet$3_0.d.n21 programmable_telescopic_cascode_0.programmable_pfet$3_0.d.n19 9.79866
R16428 programmable_telescopic_cascode_0.programmable_pfet$3_0.d.n17 programmable_telescopic_cascode_0.programmable_pfet$3_0.d.n15 9.71254
R16429 programmable_telescopic_cascode_0.programmable_pfet$3_0.d.n23 programmable_telescopic_cascode_0.programmable_pfet$3_0.d.n22 9.21398
R16430 programmable_telescopic_cascode_0.programmable_pfet$3_0.d.n19 programmable_telescopic_cascode_0.programmable_pfet$3_0.d.n18 9.21398
R16431 programmable_telescopic_cascode_0.programmable_pfet$3_0.d.n17 programmable_telescopic_cascode_0.programmable_pfet$3_0.d.n16 9.2128
R16432 programmable_telescopic_cascode_0.programmable_pfet$3_0.d.n21 programmable_telescopic_cascode_0.programmable_pfet$3_0.d.n20 9.21161
R16433 programmable_telescopic_cascode_0.programmable_pfet$3_0.d.n33 programmable_telescopic_cascode_0.programmable_pfet$3_0.d.n32 7.08682
R16434 programmable_telescopic_cascode_0.programmable_pfet$3_0.d.n28 programmable_telescopic_cascode_0.programmable_pfet$3_0.d.n27 7.08563
R16435 programmable_telescopic_cascode_0.programmable_pfet$3_0.d.n35 programmable_telescopic_cascode_0.programmable_pfet$3_0.d.n23 6.93168
R16436 programmable_telescopic_cascode_0.programmable_pfet$3_0.d.n12 programmable_telescopic_cascode_0.programmable_pfet$3_0.d.n11 6.56932
R16437 programmable_telescopic_cascode_0.programmable_pfet$3_0.d.n3 programmable_telescopic_cascode_0.programmable_pfet$3_0.d.n2 6.56813
R16438 programmable_telescopic_cascode_0.programmable_pfet$3_0.d.n7 programmable_telescopic_cascode_0.programmable_pfet$3_0.d.n6 6.56695
R16439 programmable_telescopic_cascode_0.programmable_pfet$3_0.d.n41 programmable_telescopic_cascode_0.programmable_pfet$3_0.d.n40 6.56576
R16440 programmable_telescopic_cascode_0.programmable_pfet$3_0.d.n34 programmable_telescopic_cascode_0.programmable_pfet$3_0.d.n28 5.5205
R16441 programmable_telescopic_cascode_0.programmable_pfet$3_0.d.n8 programmable_telescopic_cascode_0.programmable_pfet$3_0.d.n3 5.05826
R16442 programmable_telescopic_cascode_0.programmable_pfet$3_0.d.n7 programmable_telescopic_cascode_0.programmable_pfet$3_0.d.t33 5.00755
R16443 programmable_telescopic_cascode_0.programmable_pfet$3_0.d.n3 programmable_telescopic_cascode_0.programmable_pfet$3_0.d.t35 5.00637
R16444 programmable_telescopic_cascode_0.programmable_pfet$3_0.d.n35 programmable_telescopic_cascode_0.programmable_pfet$3_0.d 5.00528
R16445 programmable_telescopic_cascode_0.programmable_pfet$3_0.d.n12 programmable_telescopic_cascode_0.programmable_pfet$3_0.d.t11 5.00518
R16446 programmable_telescopic_cascode_0.programmable_pfet$3_0.d programmable_telescopic_cascode_0.programmable_pfet$3_0.d.n41 4.89011
R16447 programmable_telescopic_cascode_0.programmable_pfet$3_0.d.n34 programmable_telescopic_cascode_0.programmable_pfet$3_0.d.n33 4.5005
R16448 programmable_telescopic_cascode_0.programmable_pfet$3_0.d.n8 programmable_telescopic_cascode_0.programmable_pfet$3_0.d.n7 4.5005
R16449 programmable_telescopic_cascode_0.programmable_pfet$3_0.d.n13 programmable_telescopic_cascode_0.programmable_pfet$3_0.d.n12 4.5005
R16450 programmable_telescopic_cascode_0.programmable_pfet$3_0.d.n41 programmable_telescopic_cascode_0.programmable_pfet$3_0.d.n37 3.15287
R16451 programmable_telescopic_cascode_0.programmable_pfet$3_0.d.n28 programmable_telescopic_cascode_0.programmable_pfet$3_0.d.t25 2.8513
R16452 programmable_telescopic_cascode_0.programmable_pfet$3_0.d.n33 programmable_telescopic_cascode_0.programmable_pfet$3_0.d.t21 2.85012
R16453 programmable_telescopic_cascode_0.programmable_pfet$3_0.d.n36 programmable_telescopic_cascode_0.programmable_pfet$3_0.d.n14 2.54451
R16454 programmable_telescopic_cascode_0.programmable_pfet$3_0.d.n37 programmable_telescopic_cascode_0.programmable_pfet$3_0.d.t16 1.85637
R16455 programmable_telescopic_cascode_0.programmable_pfet$3_0.d programmable_telescopic_cascode_0.programmable_pfet$3_0.d.n34 0.824848
R16456 programmable_telescopic_cascode_0.programmable_pfet$3_0.d.n13 programmable_telescopic_cascode_0.programmable_pfet$3_0.d.n8 0.609184
R16457 programmable_telescopic_cascode_0.programmable_pfet$3_0.d programmable_telescopic_cascode_0.programmable_pfet$3_0.d.n13 0.536947
R16458 programmable_telescopic_cascode_0.programmable_pfet$3_0.d.n36 programmable_telescopic_cascode_0.programmable_pfet$3_0.d.n35 0.236158
R16459 programmable_telescopic_cascode_0.programmable_pfet$3_0.d.n27 programmable_telescopic_cascode_0.programmable_pfet$3_0.d.t27 0.135905
R16460 programmable_telescopic_cascode_0.programmable_pfet$3_0.d.n26 programmable_telescopic_cascode_0.programmable_pfet$3_0.d.t26 0.135905
R16461 programmable_telescopic_cascode_0.programmable_pfet$3_0.d.n25 programmable_telescopic_cascode_0.programmable_pfet$3_0.d.t43 0.135905
R16462 programmable_telescopic_cascode_0.programmable_pfet$3_0.d.n24 programmable_telescopic_cascode_0.programmable_pfet$3_0.d.t28 0.135905
R16463 programmable_telescopic_cascode_0.programmable_pfet$3_0.d.n32 programmable_telescopic_cascode_0.programmable_pfet$3_0.d.t19 0.135905
R16464 programmable_telescopic_cascode_0.programmable_pfet$3_0.d.n31 programmable_telescopic_cascode_0.programmable_pfet$3_0.d.t20 0.135905
R16465 programmable_telescopic_cascode_0.programmable_pfet$3_0.d.n30 programmable_telescopic_cascode_0.programmable_pfet$3_0.d.t22 0.135905
R16466 programmable_telescopic_cascode_0.programmable_pfet$3_0.d.n29 programmable_telescopic_cascode_0.programmable_pfet$3_0.d.t18 0.135905
R16467 programmable_telescopic_cascode_0.programmable_pfet$3_0.d.n10 programmable_telescopic_cascode_0.programmable_pfet$3_0.d.t10 0.115578
R16468 programmable_telescopic_cascode_0.programmable_pfet$3_0.d.n9 programmable_telescopic_cascode_0.programmable_pfet$3_0.d.t12 0.115578
R16469 programmable_telescopic_cascode_0.programmable_pfet$3_0.d.n40 programmable_telescopic_cascode_0.programmable_pfet$3_0.d.t13 0.115578
R16470 programmable_telescopic_cascode_0.programmable_pfet$3_0.d.n39 programmable_telescopic_cascode_0.programmable_pfet$3_0.d.t14 0.115578
R16471 programmable_telescopic_cascode_0.programmable_pfet$3_0.d.n38 programmable_telescopic_cascode_0.programmable_pfet$3_0.d.t15 0.115578
R16472 programmable_telescopic_cascode_0.programmable_pfet$3_0.d.n6 programmable_telescopic_cascode_0.programmable_pfet$3_0.d.t36 0.115578
R16473 programmable_telescopic_cascode_0.programmable_pfet$3_0.d.n5 programmable_telescopic_cascode_0.programmable_pfet$3_0.d.t29 0.115578
R16474 programmable_telescopic_cascode_0.programmable_pfet$3_0.d.n4 programmable_telescopic_cascode_0.programmable_pfet$3_0.d.t34 0.115578
R16475 programmable_telescopic_cascode_0.programmable_pfet$3_0.d.n2 programmable_telescopic_cascode_0.programmable_pfet$3_0.d.t30 0.115578
R16476 programmable_telescopic_cascode_0.programmable_pfet$3_0.d.n1 programmable_telescopic_cascode_0.programmable_pfet$3_0.d.t32 0.115578
R16477 programmable_telescopic_cascode_0.programmable_pfet$3_0.d.n0 programmable_telescopic_cascode_0.programmable_pfet$3_0.d.t37 0.115578
R16478 programmable_telescopic_cascode_0.programmable_pfet$3_0.d.n11 programmable_telescopic_cascode_0.programmable_pfet$3_0.d.t0 0.115578
R16479 programmable_telescopic_cascode_0.programmable_pfet$3_0.d.n14 programmable_telescopic_cascode_0.programmable_pfet$3_0.d.t4 0.046
R16480 programmable_telescopic_cascode_0.programmable_pfet$3_0.d.n14 programmable_telescopic_cascode_0.programmable_pfet$3_0.d.t6 0.046
R16481 programmable_telescopic_cascode_0.programmable_pfet$3_0.d.n16 programmable_telescopic_cascode_0.programmable_pfet$3_0.d.t24 0.046
R16482 programmable_telescopic_cascode_0.programmable_pfet$3_0.d.n16 programmable_telescopic_cascode_0.programmable_pfet$3_0.d.t9 0.046
R16483 programmable_telescopic_cascode_0.programmable_pfet$3_0.d.n22 programmable_telescopic_cascode_0.programmable_pfet$3_0.d.t40 0.046
R16484 programmable_telescopic_cascode_0.programmable_pfet$3_0.d.n22 programmable_telescopic_cascode_0.programmable_pfet$3_0.d.t8 0.046
R16485 programmable_telescopic_cascode_0.programmable_pfet$3_0.d.n20 programmable_telescopic_cascode_0.programmable_pfet$3_0.d.t39 0.046
R16486 programmable_telescopic_cascode_0.programmable_pfet$3_0.d.n20 programmable_telescopic_cascode_0.programmable_pfet$3_0.d.t7 0.046
R16487 programmable_telescopic_cascode_0.programmable_pfet$3_0.d.n18 programmable_telescopic_cascode_0.programmable_pfet$3_0.d.t3 0.046
R16488 programmable_telescopic_cascode_0.programmable_pfet$3_0.d.n18 programmable_telescopic_cascode_0.programmable_pfet$3_0.d.t41 0.046
R16489 programmable_telescopic_cascode_0.programmable_pfet$3_0.d.n15 programmable_telescopic_cascode_0.programmable_pfet$3_0.d.t2 0.046
R16490 programmable_telescopic_cascode_0.programmable_pfet$3_0.d.n15 programmable_telescopic_cascode_0.programmable_pfet$3_0.d.t5 0.046
R16491 programmable_common_source_0.programmable_pfet$5_0.transmission_gate$30_0.out.t3 programmable_common_source_0.programmable_pfet$5_0.transmission_gate$30_0.out.t17 77.2345
R16492 programmable_common_source_0.programmable_pfet$5_0.transmission_gate$30_0.out.t22 programmable_common_source_0.programmable_pfet$5_0.transmission_gate$30_0.out.t3 77.2345
R16493 programmable_common_source_0.programmable_pfet$5_0.transmission_gate$30_0.out.t10 programmable_common_source_0.programmable_pfet$5_0.transmission_gate$30_0.out.t22 77.2345
R16494 programmable_common_source_0.programmable_pfet$5_0.transmission_gate$30_0.out.t4 programmable_common_source_0.programmable_pfet$5_0.transmission_gate$30_0.out.t10 77.2345
R16495 programmable_common_source_0.programmable_pfet$5_0.transmission_gate$30_0.out.t18 programmable_common_source_0.programmable_pfet$5_0.transmission_gate$30_0.out.t4 77.2345
R16496 programmable_common_source_0.programmable_pfet$5_0.transmission_gate$30_0.out.t5 programmable_common_source_0.programmable_pfet$5_0.transmission_gate$30_0.out.t18 77.2345
R16497 programmable_common_source_0.programmable_pfet$5_0.transmission_gate$30_0.out.t19 programmable_common_source_0.programmable_pfet$5_0.transmission_gate$30_0.out.t5 77.2345
R16498 programmable_common_source_0.programmable_pfet$5_0.transmission_gate$30_0.out.t11 programmable_common_source_0.programmable_pfet$5_0.transmission_gate$30_0.out.t19 77.2345
R16499 programmable_common_source_0.programmable_pfet$5_0.transmission_gate$30_0.out.t6 programmable_common_source_0.programmable_pfet$5_0.transmission_gate$30_0.out.t11 77.2345
R16500 programmable_common_source_0.programmable_pfet$5_0.transmission_gate$30_0.out.t13 programmable_common_source_0.programmable_pfet$5_0.transmission_gate$30_0.out.t7 77.2345
R16501 programmable_common_source_0.programmable_pfet$5_0.transmission_gate$30_0.out.t12 programmable_common_source_0.programmable_pfet$5_0.transmission_gate$30_0.out.t13 77.2345
R16502 programmable_common_source_0.programmable_pfet$5_0.transmission_gate$30_0.out.t20 programmable_common_source_0.programmable_pfet$5_0.transmission_gate$30_0.out.t12 77.2345
R16503 programmable_common_source_0.programmable_pfet$5_0.transmission_gate$30_0.out.t14 programmable_common_source_0.programmable_pfet$5_0.transmission_gate$30_0.out.t20 77.2345
R16504 programmable_common_source_0.programmable_pfet$5_0.transmission_gate$30_0.out.t8 programmable_common_source_0.programmable_pfet$5_0.transmission_gate$30_0.out.t14 77.2345
R16505 programmable_common_source_0.programmable_pfet$5_0.transmission_gate$30_0.out.t15 programmable_common_source_0.programmable_pfet$5_0.transmission_gate$30_0.out.t8 77.2345
R16506 programmable_common_source_0.programmable_pfet$5_0.transmission_gate$30_0.out.t9 programmable_common_source_0.programmable_pfet$5_0.transmission_gate$30_0.out.t15 77.2345
R16507 programmable_common_source_0.programmable_pfet$5_0.transmission_gate$30_0.out.t21 programmable_common_source_0.programmable_pfet$5_0.transmission_gate$30_0.out.t9 77.2345
R16508 programmable_common_source_0.programmable_pfet$5_0.transmission_gate$30_0.out.t16 programmable_common_source_0.programmable_pfet$5_0.transmission_gate$30_0.out.t21 77.2345
R16509 programmable_common_source_0.programmable_pfet$5_0.transmission_gate$30_0.out.n0 programmable_common_source_0.programmable_pfet$5_0.transmission_gate$30_0.out.t16 49.6587
R16510 programmable_common_source_0.programmable_pfet$5_0.transmission_gate$30_0.out.n1 programmable_common_source_0.programmable_pfet$5_0.transmission_gate$30_0.out.t6 45.1575
R16511 programmable_common_source_0.programmable_pfet$5_0.transmission_gate$30_0.out.n0 programmable_common_source_0.programmable_pfet$5_0.transmission_gate$30_0.out.t0 17.7026
R16512 programmable_common_source_0.programmable_pfet$5_0.transmission_gate$30_0.out.n2 programmable_common_source_0.programmable_pfet$5_0.transmission_gate$30_0.out.t2 12.5327
R16513 programmable_common_source_0.programmable_pfet$5_0.transmission_gate$30_0.out programmable_common_source_0.programmable_pfet$5_0.transmission_gate$30_0.out.t1 12.2669
R16514 programmable_common_source_0.programmable_pfet$5_0.transmission_gate$30_0.out.n2 programmable_common_source_0.programmable_pfet$5_0.transmission_gate$30_0.out.n1 10.2704
R16515 programmable_common_source_0.programmable_pfet$5_0.transmission_gate$30_0.out.n1 programmable_common_source_0.programmable_pfet$5_0.transmission_gate$30_0.out.n0 4.84569
R16516 programmable_common_source_0.programmable_pfet$5_0.transmission_gate$30_0.out programmable_common_source_0.programmable_pfet$5_0.transmission_gate$30_0.out.n2 0.0245
R16517 programmable_folded_cascode_0.OUT.n9 programmable_folded_cascode_0.OUT.n7 16.4217
R16518 programmable_folded_cascode_0.OUT.n11 programmable_folded_cascode_0.OUT.n9 16.3379
R16519 programmable_folded_cascode_0.OUT.n13 programmable_folded_cascode_0.OUT.n11 16.3379
R16520 programmable_folded_cascode_0.OUT.n15 programmable_folded_cascode_0.OUT.n13 16.3379
R16521 programmable_folded_cascode_0.OUT.n22 programmable_folded_cascode_0.OUT.n21 11.2241
R16522 programmable_folded_cascode_0.OUT.n3 programmable_folded_cascode_0.OUT.t1 7.53086
R16523 programmable_folded_cascode_0.OUT.n16 programmable_folded_cascode_0.OUT.t19 7.44027
R16524 programmable_folded_cascode_0.OUT.n19 programmable_folded_cascode_0.OUT.n18 7.34766
R16525 programmable_folded_cascode_0.OUT.n4 programmable_folded_cascode_0.OUT.n3 7.34766
R16526 programmable_folded_cascode_0.OUT.n5 programmable_folded_cascode_0.OUT.n4 7.34766
R16527 programmable_folded_cascode_0.OUT.n6 programmable_folded_cascode_0.OUT.n5 7.34766
R16528 programmable_folded_cascode_0.OUT.n18 programmable_folded_cascode_0.OUT.n17 7.30237
R16529 programmable_folded_cascode_0.OUT.n17 programmable_folded_cascode_0.OUT.n16 7.25708
R16530 programmable_folded_cascode_0.OUT.n20 programmable_folded_cascode_0.OUT.n19 6.04572
R16531 programmable_folded_cascode_0.OUT.n1 programmable_folded_cascode_0.OUT.n0 6.03744
R16532 programmable_folded_cascode_0.OUT.n20 programmable_folded_cascode_0.OUT.n15 6.00628
R16533 programmable_folded_cascode_0.OUT.n22 programmable_folded_cascode_0.OUT.n2 5.8298
R16534 programmable_folded_cascode_0.OUT.n2 programmable_folded_cascode_0.OUT.n1 5.77596
R16535 programmable_folded_cascode_0.OUT.n1 programmable_folded_cascode_0.OUT.t0 5.58287
R16536 programmable_folded_cascode_0.OUT programmable_folded_cascode_0.OUT.n22 5.35905
R16537 programmable_folded_cascode_0.OUT.n21 programmable_folded_cascode_0.OUT.n20 4.5005
R16538 programmable_folded_cascode_0.OUT.n21 programmable_folded_cascode_0.OUT.n6 0.663658
R16539 programmable_folded_cascode_0.OUT.n2 programmable_folded_cascode_0.OUT.t16 0.5405
R16540 programmable_folded_cascode_0.OUT.n6 programmable_folded_cascode_0.OUT.t2 0.183695
R16541 programmable_folded_cascode_0.OUT.n19 programmable_folded_cascode_0.OUT.t23 0.183695
R16542 programmable_folded_cascode_0.OUT.n18 programmable_folded_cascode_0.OUT.t21 0.183695
R16543 programmable_folded_cascode_0.OUT.n17 programmable_folded_cascode_0.OUT.t20 0.183695
R16544 programmable_folded_cascode_0.OUT.n16 programmable_folded_cascode_0.OUT.t22 0.183695
R16545 programmable_folded_cascode_0.OUT.n5 programmable_folded_cascode_0.OUT.t4 0.183695
R16546 programmable_folded_cascode_0.OUT.n4 programmable_folded_cascode_0.OUT.t5 0.183695
R16547 programmable_folded_cascode_0.OUT.n3 programmable_folded_cascode_0.OUT.t3 0.183695
R16548 programmable_folded_cascode_0.OUT.n0 programmable_folded_cascode_0.OUT.t17 0.1565
R16549 programmable_folded_cascode_0.OUT.n0 programmable_folded_cascode_0.OUT.t18 0.1565
R16550 programmable_folded_cascode_0.OUT.n9 programmable_folded_cascode_0.OUT.n8 0.084371
R16551 programmable_folded_cascode_0.OUT.n11 programmable_folded_cascode_0.OUT.n10 0.084371
R16552 programmable_folded_cascode_0.OUT.n13 programmable_folded_cascode_0.OUT.n12 0.084371
R16553 programmable_folded_cascode_0.OUT.n15 programmable_folded_cascode_0.OUT.n14 0.084371
R16554 programmable_folded_cascode_0.OUT.n14 programmable_folded_cascode_0.OUT.t13 0.0619865
R16555 programmable_folded_cascode_0.OUT.n14 programmable_folded_cascode_0.OUT.t8 0.0619865
R16556 programmable_folded_cascode_0.OUT.n12 programmable_folded_cascode_0.OUT.t6 0.0619865
R16557 programmable_folded_cascode_0.OUT.n12 programmable_folded_cascode_0.OUT.t12 0.0619865
R16558 programmable_folded_cascode_0.OUT.n10 programmable_folded_cascode_0.OUT.t10 0.0619865
R16559 programmable_folded_cascode_0.OUT.n10 programmable_folded_cascode_0.OUT.t14 0.0619865
R16560 programmable_folded_cascode_0.OUT.n8 programmable_folded_cascode_0.OUT.t7 0.0619865
R16561 programmable_folded_cascode_0.OUT.n8 programmable_folded_cascode_0.OUT.t9 0.0619865
R16562 programmable_folded_cascode_0.OUT.n7 programmable_folded_cascode_0.OUT.t11 0.0619865
R16563 programmable_folded_cascode_0.OUT.n7 programmable_folded_cascode_0.OUT.t15 0.0619865
R16564 programmable_telescopic_cascode_0.programmable_pfet$2_1.transmission_gate$22_0.out.t12 programmable_telescopic_cascode_0.programmable_pfet$2_1.transmission_gate$22_0.out.t9 706.348
R16565 programmable_telescopic_cascode_0.programmable_pfet$2_1.transmission_gate$22_0.out.t3 programmable_telescopic_cascode_0.programmable_pfet$2_1.transmission_gate$22_0.out.t12 706.348
R16566 programmable_telescopic_cascode_0.programmable_pfet$2_1.transmission_gate$22_0.out.t7 programmable_telescopic_cascode_0.programmable_pfet$2_1.transmission_gate$22_0.out.t3 706.348
R16567 programmable_telescopic_cascode_0.programmable_pfet$2_1.transmission_gate$22_0.out.t11 programmable_telescopic_cascode_0.programmable_pfet$2_1.transmission_gate$22_0.out.t7 706.348
R16568 programmable_telescopic_cascode_0.programmable_pfet$2_1.transmission_gate$22_0.out.t8 programmable_telescopic_cascode_0.programmable_pfet$2_1.transmission_gate$22_0.out.t5 706.348
R16569 programmable_telescopic_cascode_0.programmable_pfet$2_1.transmission_gate$22_0.out.t10 programmable_telescopic_cascode_0.programmable_pfet$2_1.transmission_gate$22_0.out.t8 706.348
R16570 programmable_telescopic_cascode_0.programmable_pfet$2_1.transmission_gate$22_0.out.t4 programmable_telescopic_cascode_0.programmable_pfet$2_1.transmission_gate$22_0.out.t10 706.348
R16571 programmable_telescopic_cascode_0.programmable_pfet$2_1.transmission_gate$22_0.out.t6 programmable_telescopic_cascode_0.programmable_pfet$2_1.transmission_gate$22_0.out.t4 706.348
R16572 programmable_telescopic_cascode_0.programmable_pfet$2_1.transmission_gate$22_0.out.n0 programmable_telescopic_cascode_0.programmable_pfet$2_1.transmission_gate$22_0.out.t6 367.495
R16573 programmable_telescopic_cascode_0.programmable_pfet$2_1.transmission_gate$22_0.out.n0 programmable_telescopic_cascode_0.programmable_pfet$2_1.transmission_gate$22_0.out.t11 358.255
R16574 programmable_telescopic_cascode_0.programmable_pfet$2_1.transmission_gate$22_0.out.n1 programmable_telescopic_cascode_0.programmable_pfet$2_1.transmission_gate$22_0.out.t2 22.4639
R16575 programmable_telescopic_cascode_0.programmable_pfet$2_1.transmission_gate$22_0.out.n2 programmable_telescopic_cascode_0.programmable_pfet$2_1.transmission_gate$22_0.out.t1 12.5303
R16576 programmable_telescopic_cascode_0.programmable_pfet$2_1.transmission_gate$22_0.out programmable_telescopic_cascode_0.programmable_pfet$2_1.transmission_gate$22_0.out.t0 12.2669
R16577 programmable_telescopic_cascode_0.programmable_pfet$2_1.transmission_gate$22_0.out.n2 programmable_telescopic_cascode_0.programmable_pfet$2_1.transmission_gate$22_0.out.n1 10.0023
R16578 programmable_telescopic_cascode_0.programmable_pfet$2_1.transmission_gate$22_0.out.n1 programmable_telescopic_cascode_0.programmable_pfet$2_1.transmission_gate$22_0.out.n0 0.167474
R16579 programmable_telescopic_cascode_0.programmable_pfet$2_1.transmission_gate$22_0.out programmable_telescopic_cascode_0.programmable_pfet$2_1.transmission_gate$22_0.out.n2 0.0269
R16580 programmable_telescopic_cascode_0.programmable_pfet$3_1.d.n25 programmable_telescopic_cascode_0.programmable_pfet$3_1.d.n23 19.103
R16581 programmable_telescopic_cascode_0.programmable_pfet$3_1.d.n20 programmable_telescopic_cascode_0.programmable_pfet$3_1.d.n19 14.1504
R16582 programmable_telescopic_cascode_0.programmable_pfet$3_1.d.n1 programmable_telescopic_cascode_0.programmable_pfet$3_1.d.t40 11.574
R16583 programmable_telescopic_cascode_0.programmable_pfet$3_1.d.n13 programmable_telescopic_cascode_0.programmable_pfet$3_1.d.t20 11.574
R16584 programmable_telescopic_cascode_0.programmable_pfet$3_1.d.n8 programmable_telescopic_cascode_0.programmable_pfet$3_1.d.t9 11.574
R16585 programmable_telescopic_cascode_0.programmable_pfet$3_1.d.n4 programmable_telescopic_cascode_0.programmable_pfet$3_1.d.t13 11.574
R16586 programmable_telescopic_cascode_0.programmable_pfet$3_1.d.n15 programmable_telescopic_cascode_0.programmable_pfet$3_1.d.n14 11.4589
R16587 programmable_telescopic_cascode_0.programmable_pfet$3_1.d.n14 programmable_telescopic_cascode_0.programmable_pfet$3_1.d.n13 11.4589
R16588 programmable_telescopic_cascode_0.programmable_pfet$3_1.d.n10 programmable_telescopic_cascode_0.programmable_pfet$3_1.d.n9 11.4589
R16589 programmable_telescopic_cascode_0.programmable_pfet$3_1.d.n9 programmable_telescopic_cascode_0.programmable_pfet$3_1.d.n8 11.4589
R16590 programmable_telescopic_cascode_0.programmable_pfet$3_1.d.n6 programmable_telescopic_cascode_0.programmable_pfet$3_1.d.n5 11.4589
R16591 programmable_telescopic_cascode_0.programmable_pfet$3_1.d.n5 programmable_telescopic_cascode_0.programmable_pfet$3_1.d.n4 11.4589
R16592 programmable_telescopic_cascode_0.programmable_pfet$3_1.d.n3 programmable_telescopic_cascode_0.programmable_pfet$3_1.d.n2 11.4589
R16593 programmable_telescopic_cascode_0.programmable_pfet$3_1.d.n2 programmable_telescopic_cascode_0.programmable_pfet$3_1.d.n1 11.4589
R16594 programmable_telescopic_cascode_0.programmable_pfet$3_1.d.n31 programmable_telescopic_cascode_0.programmable_pfet$3_1.d.t4 9.93643
R16595 programmable_telescopic_cascode_0.programmable_pfet$3_1.d.n36 programmable_telescopic_cascode_0.programmable_pfet$3_1.d.t31 9.93643
R16596 programmable_telescopic_cascode_0.programmable_pfet$3_1.d.n29 programmable_telescopic_cascode_0.programmable_pfet$3_1.d.n27 9.80339
R16597 programmable_telescopic_cascode_0.programmable_pfet$3_1.d.n39 programmable_telescopic_cascode_0.programmable_pfet$3_1.d.n38 9.80103
R16598 programmable_telescopic_cascode_0.programmable_pfet$3_1.d.n38 programmable_telescopic_cascode_0.programmable_pfet$3_1.d.n37 9.80103
R16599 programmable_telescopic_cascode_0.programmable_pfet$3_1.d.n37 programmable_telescopic_cascode_0.programmable_pfet$3_1.d.n36 9.80103
R16600 programmable_telescopic_cascode_0.programmable_pfet$3_1.d.n34 programmable_telescopic_cascode_0.programmable_pfet$3_1.d.n33 9.80103
R16601 programmable_telescopic_cascode_0.programmable_pfet$3_1.d.n33 programmable_telescopic_cascode_0.programmable_pfet$3_1.d.n32 9.80103
R16602 programmable_telescopic_cascode_0.programmable_pfet$3_1.d.n32 programmable_telescopic_cascode_0.programmable_pfet$3_1.d.n31 9.80103
R16603 programmable_telescopic_cascode_0.programmable_pfet$3_1.d.n27 programmable_telescopic_cascode_0.programmable_pfet$3_1.d.n25 9.79866
R16604 programmable_telescopic_cascode_0.programmable_pfet$3_1.d.n23 programmable_telescopic_cascode_0.programmable_pfet$3_1.d.n21 9.71254
R16605 programmable_telescopic_cascode_0.programmable_pfet$3_1.d.n29 programmable_telescopic_cascode_0.programmable_pfet$3_1.d.n28 9.21398
R16606 programmable_telescopic_cascode_0.programmable_pfet$3_1.d.n25 programmable_telescopic_cascode_0.programmable_pfet$3_1.d.n24 9.21398
R16607 programmable_telescopic_cascode_0.programmable_pfet$3_1.d.n23 programmable_telescopic_cascode_0.programmable_pfet$3_1.d.n22 9.2128
R16608 programmable_telescopic_cascode_0.programmable_pfet$3_1.d.n27 programmable_telescopic_cascode_0.programmable_pfet$3_1.d.n26 9.21161
R16609 programmable_telescopic_cascode_0.programmable_pfet$3_1.d.n40 programmable_telescopic_cascode_0.programmable_pfet$3_1.d.n39 7.08682
R16610 programmable_telescopic_cascode_0.programmable_pfet$3_1.d.n35 programmable_telescopic_cascode_0.programmable_pfet$3_1.d.n34 7.08563
R16611 programmable_telescopic_cascode_0.programmable_pfet$3_1.d.n30 programmable_telescopic_cascode_0.programmable_pfet$3_1.d.n29 6.93168
R16612 programmable_telescopic_cascode_0.programmable_pfet$3_1.d.n16 programmable_telescopic_cascode_0.programmable_pfet$3_1.d.n15 6.56932
R16613 programmable_telescopic_cascode_0.programmable_pfet$3_1.d.n7 programmable_telescopic_cascode_0.programmable_pfet$3_1.d.n6 6.56813
R16614 programmable_telescopic_cascode_0.programmable_pfet$3_1.d.n11 programmable_telescopic_cascode_0.programmable_pfet$3_1.d.n10 6.56695
R16615 programmable_telescopic_cascode_0.programmable_pfet$3_1.d.n18 programmable_telescopic_cascode_0.programmable_pfet$3_1.d.n3 6.56576
R16616 programmable_telescopic_cascode_0.programmable_pfet$3_1.d.n41 programmable_telescopic_cascode_0.programmable_pfet$3_1.d.n35 5.5205
R16617 programmable_telescopic_cascode_0.programmable_pfet$3_1.d.n12 programmable_telescopic_cascode_0.programmable_pfet$3_1.d.n7 5.05826
R16618 programmable_telescopic_cascode_0.programmable_pfet$3_1.d.n11 programmable_telescopic_cascode_0.programmable_pfet$3_1.d.t7 5.00755
R16619 programmable_telescopic_cascode_0.programmable_pfet$3_1.d.n7 programmable_telescopic_cascode_0.programmable_pfet$3_1.d.t12 5.00637
R16620 programmable_telescopic_cascode_0.programmable_pfet$3_1.d programmable_telescopic_cascode_0.programmable_pfet$3_1.d.n30 5.00528
R16621 programmable_telescopic_cascode_0.programmable_pfet$3_1.d.n16 programmable_telescopic_cascode_0.programmable_pfet$3_1.d.t17 5.00518
R16622 programmable_telescopic_cascode_0.programmable_pfet$3_1.d.n18 programmable_telescopic_cascode_0.programmable_pfet$3_1.d 4.89011
R16623 programmable_telescopic_cascode_0.programmable_pfet$3_1.d.n12 programmable_telescopic_cascode_0.programmable_pfet$3_1.d.n11 4.5005
R16624 programmable_telescopic_cascode_0.programmable_pfet$3_1.d.n17 programmable_telescopic_cascode_0.programmable_pfet$3_1.d.n16 4.5005
R16625 programmable_telescopic_cascode_0.programmable_pfet$3_1.d.n41 programmable_telescopic_cascode_0.programmable_pfet$3_1.d.n40 4.5005
R16626 programmable_telescopic_cascode_0.programmable_pfet$3_1.d.n19 programmable_telescopic_cascode_0.programmable_pfet$3_1.d.n18 3.78642
R16627 programmable_telescopic_cascode_0.programmable_pfet$3_1.d.n35 programmable_telescopic_cascode_0.programmable_pfet$3_1.d.t0 2.8513
R16628 programmable_telescopic_cascode_0.programmable_pfet$3_1.d.n40 programmable_telescopic_cascode_0.programmable_pfet$3_1.d.t35 2.85012
R16629 programmable_telescopic_cascode_0.programmable_pfet$3_1.d.n20 programmable_telescopic_cascode_0.programmable_pfet$3_1.d.n0 1.91096
R16630 programmable_telescopic_cascode_0.programmable_pfet$3_1.d.n19 programmable_telescopic_cascode_0.programmable_pfet$3_1.d.t36 1.22282
R16631 programmable_telescopic_cascode_0.programmable_pfet$3_1.d.n30 programmable_telescopic_cascode_0.programmable_pfet$3_1.d.n20 0.86971
R16632 programmable_telescopic_cascode_0.programmable_pfet$3_1.d programmable_telescopic_cascode_0.programmable_pfet$3_1.d.n41 0.824848
R16633 programmable_telescopic_cascode_0.programmable_pfet$3_1.d.n17 programmable_telescopic_cascode_0.programmable_pfet$3_1.d.n12 0.609184
R16634 programmable_telescopic_cascode_0.programmable_pfet$3_1.d programmable_telescopic_cascode_0.programmable_pfet$3_1.d.n17 0.536947
R16635 programmable_telescopic_cascode_0.programmable_pfet$3_1.d.n34 programmable_telescopic_cascode_0.programmable_pfet$3_1.d.t2 0.135905
R16636 programmable_telescopic_cascode_0.programmable_pfet$3_1.d.n33 programmable_telescopic_cascode_0.programmable_pfet$3_1.d.t1 0.135905
R16637 programmable_telescopic_cascode_0.programmable_pfet$3_1.d.n32 programmable_telescopic_cascode_0.programmable_pfet$3_1.d.t5 0.135905
R16638 programmable_telescopic_cascode_0.programmable_pfet$3_1.d.n31 programmable_telescopic_cascode_0.programmable_pfet$3_1.d.t3 0.135905
R16639 programmable_telescopic_cascode_0.programmable_pfet$3_1.d.n39 programmable_telescopic_cascode_0.programmable_pfet$3_1.d.t33 0.135905
R16640 programmable_telescopic_cascode_0.programmable_pfet$3_1.d.n38 programmable_telescopic_cascode_0.programmable_pfet$3_1.d.t34 0.135905
R16641 programmable_telescopic_cascode_0.programmable_pfet$3_1.d.n37 programmable_telescopic_cascode_0.programmable_pfet$3_1.d.t30 0.135905
R16642 programmable_telescopic_cascode_0.programmable_pfet$3_1.d.n36 programmable_telescopic_cascode_0.programmable_pfet$3_1.d.t32 0.135905
R16643 programmable_telescopic_cascode_0.programmable_pfet$3_1.d.n3 programmable_telescopic_cascode_0.programmable_pfet$3_1.d.t39 0.115578
R16644 programmable_telescopic_cascode_0.programmable_pfet$3_1.d.n2 programmable_telescopic_cascode_0.programmable_pfet$3_1.d.t38 0.115578
R16645 programmable_telescopic_cascode_0.programmable_pfet$3_1.d.n1 programmable_telescopic_cascode_0.programmable_pfet$3_1.d.t37 0.115578
R16646 programmable_telescopic_cascode_0.programmable_pfet$3_1.d.n15 programmable_telescopic_cascode_0.programmable_pfet$3_1.d.t19 0.115578
R16647 programmable_telescopic_cascode_0.programmable_pfet$3_1.d.n14 programmable_telescopic_cascode_0.programmable_pfet$3_1.d.t16 0.115578
R16648 programmable_telescopic_cascode_0.programmable_pfet$3_1.d.n13 programmable_telescopic_cascode_0.programmable_pfet$3_1.d.t18 0.115578
R16649 programmable_telescopic_cascode_0.programmable_pfet$3_1.d.n10 programmable_telescopic_cascode_0.programmable_pfet$3_1.d.t11 0.115578
R16650 programmable_telescopic_cascode_0.programmable_pfet$3_1.d.n9 programmable_telescopic_cascode_0.programmable_pfet$3_1.d.t15 0.115578
R16651 programmable_telescopic_cascode_0.programmable_pfet$3_1.d.n8 programmable_telescopic_cascode_0.programmable_pfet$3_1.d.t6 0.115578
R16652 programmable_telescopic_cascode_0.programmable_pfet$3_1.d.n6 programmable_telescopic_cascode_0.programmable_pfet$3_1.d.t14 0.115578
R16653 programmable_telescopic_cascode_0.programmable_pfet$3_1.d.n5 programmable_telescopic_cascode_0.programmable_pfet$3_1.d.t8 0.115578
R16654 programmable_telescopic_cascode_0.programmable_pfet$3_1.d.n4 programmable_telescopic_cascode_0.programmable_pfet$3_1.d.t10 0.115578
R16655 programmable_telescopic_cascode_0.programmable_pfet$3_1.d.n0 programmable_telescopic_cascode_0.programmable_pfet$3_1.d.t24 0.046
R16656 programmable_telescopic_cascode_0.programmable_pfet$3_1.d.n0 programmable_telescopic_cascode_0.programmable_pfet$3_1.d.t41 0.046
R16657 programmable_telescopic_cascode_0.programmable_pfet$3_1.d.n22 programmable_telescopic_cascode_0.programmable_pfet$3_1.d.t21 0.046
R16658 programmable_telescopic_cascode_0.programmable_pfet$3_1.d.n22 programmable_telescopic_cascode_0.programmable_pfet$3_1.d.t29 0.046
R16659 programmable_telescopic_cascode_0.programmable_pfet$3_1.d.n28 programmable_telescopic_cascode_0.programmable_pfet$3_1.d.t26 0.046
R16660 programmable_telescopic_cascode_0.programmable_pfet$3_1.d.n28 programmable_telescopic_cascode_0.programmable_pfet$3_1.d.t28 0.046
R16661 programmable_telescopic_cascode_0.programmable_pfet$3_1.d.n26 programmable_telescopic_cascode_0.programmable_pfet$3_1.d.t25 0.046
R16662 programmable_telescopic_cascode_0.programmable_pfet$3_1.d.n26 programmable_telescopic_cascode_0.programmable_pfet$3_1.d.t43 0.046
R16663 programmable_telescopic_cascode_0.programmable_pfet$3_1.d.n24 programmable_telescopic_cascode_0.programmable_pfet$3_1.d.t27 0.046
R16664 programmable_telescopic_cascode_0.programmable_pfet$3_1.d.n24 programmable_telescopic_cascode_0.programmable_pfet$3_1.d.t23 0.046
R16665 programmable_telescopic_cascode_0.programmable_pfet$3_1.d.n21 programmable_telescopic_cascode_0.programmable_pfet$3_1.d.t42 0.046
R16666 programmable_telescopic_cascode_0.programmable_pfet$3_1.d.n21 programmable_telescopic_cascode_0.programmable_pfet$3_1.d.t22 0.046
R16667 programmable_telescopic_cascode_0.programmable_nfet$4_0.transmission_gate$24_0.out.t6 programmable_telescopic_cascode_0.programmable_nfet$4_0.transmission_gate$24_0.out.t8 838.953
R16668 programmable_telescopic_cascode_0.programmable_nfet$4_0.transmission_gate$24_0.out.t12 programmable_telescopic_cascode_0.programmable_nfet$4_0.transmission_gate$24_0.out.t6 838.953
R16669 programmable_telescopic_cascode_0.programmable_nfet$4_0.transmission_gate$24_0.out.t4 programmable_telescopic_cascode_0.programmable_nfet$4_0.transmission_gate$24_0.out.t12 838.953
R16670 programmable_telescopic_cascode_0.programmable_nfet$4_0.transmission_gate$24_0.out.t10 programmable_telescopic_cascode_0.programmable_nfet$4_0.transmission_gate$24_0.out.t4 838.953
R16671 programmable_telescopic_cascode_0.programmable_nfet$4_0.transmission_gate$24_0.out.t14 programmable_telescopic_cascode_0.programmable_nfet$4_0.transmission_gate$24_0.out.t10 838.953
R16672 programmable_telescopic_cascode_0.programmable_nfet$4_0.transmission_gate$24_0.out.t5 programmable_telescopic_cascode_0.programmable_nfet$4_0.transmission_gate$24_0.out.t7 838.953
R16673 programmable_telescopic_cascode_0.programmable_nfet$4_0.transmission_gate$24_0.out.t11 programmable_telescopic_cascode_0.programmable_nfet$4_0.transmission_gate$24_0.out.t5 838.953
R16674 programmable_telescopic_cascode_0.programmable_nfet$4_0.transmission_gate$24_0.out.t3 programmable_telescopic_cascode_0.programmable_nfet$4_0.transmission_gate$24_0.out.t11 838.953
R16675 programmable_telescopic_cascode_0.programmable_nfet$4_0.transmission_gate$24_0.out.t9 programmable_telescopic_cascode_0.programmable_nfet$4_0.transmission_gate$24_0.out.t3 838.953
R16676 programmable_telescopic_cascode_0.programmable_nfet$4_0.transmission_gate$24_0.out.t13 programmable_telescopic_cascode_0.programmable_nfet$4_0.transmission_gate$24_0.out.t9 838.953
R16677 programmable_telescopic_cascode_0.programmable_nfet$4_0.transmission_gate$24_0.out.n1 programmable_telescopic_cascode_0.programmable_nfet$4_0.transmission_gate$24_0.out.t14 431.887
R16678 programmable_telescopic_cascode_0.programmable_nfet$4_0.transmission_gate$24_0.out.n0 programmable_telescopic_cascode_0.programmable_nfet$4_0.transmission_gate$24_0.out.t13 431.885
R16679 programmable_telescopic_cascode_0.programmable_nfet$4_0.transmission_gate$24_0.out.n0 programmable_telescopic_cascode_0.programmable_nfet$4_0.transmission_gate$24_0.out.t0 17.7431
R16680 programmable_telescopic_cascode_0.programmable_nfet$4_0.transmission_gate$24_0.out.n2 programmable_telescopic_cascode_0.programmable_nfet$4_0.transmission_gate$24_0.out.t2 12.3005
R16681 programmable_telescopic_cascode_0.programmable_nfet$4_0.transmission_gate$24_0.out programmable_telescopic_cascode_0.programmable_nfet$4_0.transmission_gate$24_0.out.t1 12.2669
R16682 programmable_telescopic_cascode_0.programmable_nfet$4_0.transmission_gate$24_0.out.n2 programmable_telescopic_cascode_0.programmable_nfet$4_0.transmission_gate$24_0.out.n1 5.32728
R16683 programmable_telescopic_cascode_0.programmable_nfet$4_0.transmission_gate$24_0.out programmable_telescopic_cascode_0.programmable_nfet$4_0.transmission_gate$24_0.out.n2 0.2567
R16684 programmable_telescopic_cascode_0.programmable_nfet$4_0.transmission_gate$24_0.out.n1 programmable_telescopic_cascode_0.programmable_nfet$4_0.transmission_gate$24_0.out.n0 0.218395
R16685 programmable_telescopic_cascode_0.programmable_nfet$4_0.s.n24 programmable_telescopic_cascode_0.programmable_nfet$4_0.s.n23 13.9066
R16686 programmable_telescopic_cascode_0.programmable_nfet$4_0.s.n5 programmable_telescopic_cascode_0.programmable_nfet$4_0.s.t2 10.7455
R16687 programmable_telescopic_cascode_0.programmable_nfet$4_0.s.n10 programmable_telescopic_cascode_0.programmable_nfet$4_0.s.t13 10.7455
R16688 programmable_telescopic_cascode_0.programmable_nfet$4_0.s.n1 programmable_telescopic_cascode_0.programmable_nfet$4_0.s.t21 10.6833
R16689 programmable_telescopic_cascode_0.programmable_nfet$4_0.s.n16 programmable_telescopic_cascode_0.programmable_nfet$4_0.s.t20 10.4697
R16690 programmable_telescopic_cascode_0.programmable_nfet$4_0.s.n6 programmable_telescopic_cascode_0.programmable_nfet$4_0.s.n5 10.3582
R16691 programmable_telescopic_cascode_0.programmable_nfet$4_0.s.n7 programmable_telescopic_cascode_0.programmable_nfet$4_0.s.n6 10.3582
R16692 programmable_telescopic_cascode_0.programmable_nfet$4_0.s.n8 programmable_telescopic_cascode_0.programmable_nfet$4_0.s.n7 10.3582
R16693 programmable_telescopic_cascode_0.programmable_nfet$4_0.s.n11 programmable_telescopic_cascode_0.programmable_nfet$4_0.s.n10 10.3582
R16694 programmable_telescopic_cascode_0.programmable_nfet$4_0.s.n12 programmable_telescopic_cascode_0.programmable_nfet$4_0.s.n11 10.3582
R16695 programmable_telescopic_cascode_0.programmable_nfet$4_0.s.n13 programmable_telescopic_cascode_0.programmable_nfet$4_0.s.n12 10.3582
R16696 programmable_telescopic_cascode_0.programmable_nfet$4_0.s.n2 programmable_telescopic_cascode_0.programmable_nfet$4_0.s.n1 10.2339
R16697 programmable_telescopic_cascode_0.programmable_nfet$4_0.s.n3 programmable_telescopic_cascode_0.programmable_nfet$4_0.s.n2 10.2339
R16698 programmable_telescopic_cascode_0.programmable_nfet$4_0.s.n4 programmable_telescopic_cascode_0.programmable_nfet$4_0.s.n3 10.2339
R16699 programmable_telescopic_cascode_0.programmable_nfet$4_0.s.n17 programmable_telescopic_cascode_0.programmable_nfet$4_0.s.n16 9.78627
R16700 programmable_telescopic_cascode_0.programmable_nfet$4_0.s.n18 programmable_telescopic_cascode_0.programmable_nfet$4_0.s.n17 9.78627
R16701 programmable_telescopic_cascode_0.programmable_nfet$4_0.s.n19 programmable_telescopic_cascode_0.programmable_nfet$4_0.s.n18 9.78627
R16702 programmable_telescopic_cascode_0.programmable_nfet$4_0.s.n25 programmable_telescopic_cascode_0.programmable_nfet$4_0.s.t0 8.70157
R16703 programmable_telescopic_cascode_0.programmable_nfet$4_0.s.n25 programmable_telescopic_cascode_0.programmable_nfet$4_0.s.t1 8.00782
R16704 programmable_telescopic_cascode_0.programmable_nfet$4_0.s.n9 programmable_telescopic_cascode_0.programmable_nfet$4_0.s.n8 7.78698
R16705 programmable_telescopic_cascode_0.programmable_nfet$4_0.s.n14 programmable_telescopic_cascode_0.programmable_nfet$4_0.s.n13 7.78343
R16706 programmable_telescopic_cascode_0.programmable_nfet$4_0.s.n22 programmable_telescopic_cascode_0.programmable_nfet$4_0.s.n4 7.72601
R16707 programmable_telescopic_cascode_0.programmable_nfet$4_0.s.n20 programmable_telescopic_cascode_0.programmable_nfet$4_0.s.n19 7.50764
R16708 programmable_telescopic_cascode_0.programmable_nfet$4_0.s programmable_telescopic_cascode_0.programmable_nfet$4_0.s.n24 6.01392
R16709 programmable_telescopic_cascode_0.programmable_nfet$4_0.s.n22 programmable_telescopic_cascode_0.programmable_nfet$4_0.s.n21 4.99204
R16710 programmable_telescopic_cascode_0.programmable_nfet$4_0.s programmable_telescopic_cascode_0.programmable_nfet$4_0.s.n9 4.98627
R16711 programmable_telescopic_cascode_0.programmable_nfet$4_0.s.n21 programmable_telescopic_cascode_0.programmable_nfet$4_0.s.n20 4.5005
R16712 programmable_telescopic_cascode_0.programmable_nfet$4_0.s.n15 programmable_telescopic_cascode_0.programmable_nfet$4_0.s.n14 4.5005
R16713 programmable_telescopic_cascode_0.programmable_nfet$4_0.s.n14 programmable_telescopic_cascode_0.programmable_nfet$4_0.s.t10 2.96255
R16714 programmable_telescopic_cascode_0.programmable_nfet$4_0.s.n20 programmable_telescopic_cascode_0.programmable_nfet$4_0.s.t14 2.96255
R16715 programmable_telescopic_cascode_0.programmable_nfet$4_0.s.n9 programmable_telescopic_cascode_0.programmable_nfet$4_0.s.t5 2.959
R16716 programmable_telescopic_cascode_0.programmable_nfet$4_0.s.n24 programmable_telescopic_cascode_0.programmable_nfet$4_0.s.n0 2.6979
R16717 programmable_telescopic_cascode_0.programmable_nfet$4_0.s.n23 programmable_telescopic_cascode_0.programmable_nfet$4_0.s.n22 2.048
R16718 programmable_telescopic_cascode_0.programmable_nfet$4_0.s.n23 programmable_telescopic_cascode_0.programmable_nfet$4_0.s.t15 0.910316
R16719 programmable_telescopic_cascode_0.programmable_nfet$4_0.s.n21 programmable_telescopic_cascode_0.programmable_nfet$4_0.s.n15 0.338577
R16720 programmable_telescopic_cascode_0.programmable_nfet$4_0.s programmable_telescopic_cascode_0.programmable_nfet$4_0.s.n25 0.19425
R16721 programmable_telescopic_cascode_0.programmable_nfet$4_0.s.n15 programmable_telescopic_cascode_0.programmable_nfet$4_0.s 0.129731
R16722 programmable_telescopic_cascode_0.programmable_nfet$4_0.s.n8 programmable_telescopic_cascode_0.programmable_nfet$4_0.s.t3 0.122816
R16723 programmable_telescopic_cascode_0.programmable_nfet$4_0.s.n7 programmable_telescopic_cascode_0.programmable_nfet$4_0.s.t6 0.122816
R16724 programmable_telescopic_cascode_0.programmable_nfet$4_0.s.n6 programmable_telescopic_cascode_0.programmable_nfet$4_0.s.t4 0.122816
R16725 programmable_telescopic_cascode_0.programmable_nfet$4_0.s.n5 programmable_telescopic_cascode_0.programmable_nfet$4_0.s.t7 0.122816
R16726 programmable_telescopic_cascode_0.programmable_nfet$4_0.s.n13 programmable_telescopic_cascode_0.programmable_nfet$4_0.s.t12 0.122816
R16727 programmable_telescopic_cascode_0.programmable_nfet$4_0.s.n12 programmable_telescopic_cascode_0.programmable_nfet$4_0.s.t9 0.122816
R16728 programmable_telescopic_cascode_0.programmable_nfet$4_0.s.n11 programmable_telescopic_cascode_0.programmable_nfet$4_0.s.t11 0.122816
R16729 programmable_telescopic_cascode_0.programmable_nfet$4_0.s.n10 programmable_telescopic_cascode_0.programmable_nfet$4_0.s.t8 0.122816
R16730 programmable_telescopic_cascode_0.programmable_nfet$4_0.s.n19 programmable_telescopic_cascode_0.programmable_nfet$4_0.s.t18 0.122816
R16731 programmable_telescopic_cascode_0.programmable_nfet$4_0.s.n18 programmable_telescopic_cascode_0.programmable_nfet$4_0.s.t24 0.122816
R16732 programmable_telescopic_cascode_0.programmable_nfet$4_0.s.n17 programmable_telescopic_cascode_0.programmable_nfet$4_0.s.t16 0.122816
R16733 programmable_telescopic_cascode_0.programmable_nfet$4_0.s.n16 programmable_telescopic_cascode_0.programmable_nfet$4_0.s.t22 0.122816
R16734 programmable_telescopic_cascode_0.programmable_nfet$4_0.s.n4 programmable_telescopic_cascode_0.programmable_nfet$4_0.s.t19 0.122816
R16735 programmable_telescopic_cascode_0.programmable_nfet$4_0.s.n3 programmable_telescopic_cascode_0.programmable_nfet$4_0.s.t25 0.122816
R16736 programmable_telescopic_cascode_0.programmable_nfet$4_0.s.n2 programmable_telescopic_cascode_0.programmable_nfet$4_0.s.t17 0.122816
R16737 programmable_telescopic_cascode_0.programmable_nfet$4_0.s.n1 programmable_telescopic_cascode_0.programmable_nfet$4_0.s.t23 0.122816
R16738 programmable_telescopic_cascode_0.programmable_nfet$4_0.s.n0 programmable_telescopic_cascode_0.programmable_nfet$4_0.s.t26 0.0551
R16739 programmable_telescopic_cascode_0.programmable_nfet$4_0.s.n0 programmable_telescopic_cascode_0.programmable_nfet$4_0.s.t27 0.0551
R16740 IBIAS IBIAS.t22 239.025
R16741 IBIAS.t18 IBIAS.t15 204.911
R16742 IBIAS.t14 IBIAS.t17 173.522
R16743 IBIAS.t21 IBIAS.t14 173.522
R16744 IBIAS.n0 IBIAS.t4 122.966
R16745 IBIAS.n32 IBIAS.t20 115.597
R16746 IBIAS.n14 IBIAS.t18 110.602
R16747 IBIAS.n8 IBIAS.t16 110.419
R16748 IBIAS.n33 IBIAS.t19 110.419
R16749 IBIAS.n2 IBIAS.t21 95.6069
R16750 IBIAS.n15 IBIAS 59.1118
R16751 IBIAS.n9 IBIAS.n4 45.6082
R16752 IBIAS.n9 IBIAS.n8 22.8392
R16753 IBIAS.n32 IBIAS.n31 17.1483
R16754 IBIAS.n31 IBIAS.n30 13.6508
R16755 IBIAS IBIAS.t3 12.5271
R16756 IBIAS IBIAS.t2 12.5271
R16757 IBIAS IBIAS.t9 12.5271
R16758 IBIAS IBIAS.t11 12.5271
R16759 IBIAS.n12 IBIAS.t0 12.5195
R16760 IBIAS.n11 IBIAS.t12 12.5185
R16761 IBIAS IBIAS.t10 12.2496
R16762 IBIAS IBIAS.t8 12.2496
R16763 IBIAS.n6 IBIAS.t6 12.2345
R16764 IBIAS.n3 IBIAS.t7 12.2345
R16765 IBIAS.n5 IBIAS.t1 12.2279
R16766 IBIAS.n1 IBIAS.t13 12.2279
R16767 IBIAS.n30 IBIAS.n15 12.1665
R16768 IBIAS.n31 IBIAS.n10 10.7302
R16769 IBIAS.n15 IBIAS.n14 10.6532
R16770 IBIAS.n2 IBIAS 8.6974
R16771 IBIAS.n10 IBIAS.n9 8.38613
R16772 IBIAS.n8 IBIAS.n7 5.38511
R16773 IBIAS.n33 IBIAS.n32 5.15542
R16774 IBIAS.n13 IBIAS.n11 4.799
R16775 IBIAS.n13 IBIAS.n12 4.7675
R16776 IBIAS.n4 IBIAS.n1 4.71086
R16777 IBIAS IBIAS.n6 4.68917
R16778 IBIAS IBIAS.n3 4.68917
R16779 IBIAS IBIAS.n5 4.67616
R16780 IBIAS IBIAS.n13 4.60116
R16781 IBIAS.n4 IBIAS.n2 4.5005
R16782 IBIAS.n25 IBIAS.n24 4.5005
R16783 IBIAS.n17 IBIAS.n16 4.5005
R16784 IBIAS.n19 IBIAS.n18 4.5005
R16785 IBIAS.n27 IBIAS.n26 4.5005
R16786 IBIAS.n21 IBIAS.n20 4.5005
R16787 IBIAS.n23 IBIAS.n22 4.5005
R16788 IBIAS.n30 IBIAS.n29 2.5382
R16789 IBIAS.n24 IBIAS.n23 2.28512
R16790 IBIAS.n28 IBIAS.n27 2.27153
R16791 IBIAS.n29 IBIAS.n28 2.25269
R16792 IBIAS.n14 IBIAS 0.480105
R16793 IBIAS.n10 IBIAS.n0 0.398395
R16794 IBIAS.n22 IBIAS 0.293271
R16795 IBIAS IBIAS.n33 0.2711
R16796 IBIAS.n0 IBIAS.t5 0.204015
R16797 IBIAS.n7 IBIAS 0.0351988
R16798 IBIAS.n29 IBIAS.n16 0.0342104
R16799 IBIAS.n20 IBIAS.n19 0.0303193
R16800 IBIAS.n28 IBIAS.n17 0.0301415
R16801 IBIAS.n5 IBIAS 0.0221867
R16802 IBIAS.n1 IBIAS 0.0221867
R16803 IBIAS.n21 IBIAS.n18 0.0203795
R16804 IBIAS.n6 IBIAS 0.0156807
R16805 IBIAS.n3 IBIAS 0.0156807
R16806 IBIAS.n7 IBIAS 0.0113434
R16807 IBIAS.n4 IBIAS 0.0113434
R16808 IBIAS.n11 IBIAS 0.0091747
R16809 IBIAS.n12 IBIAS 0.00809036
R16810 IBIAS.n24 IBIAS.n16 0.00251278
R16811 IBIAS.n25 IBIAS.n17 0.00239759
R16812 IBIAS.n23 IBIAS.n20 0.00131325
R16813 IBIAS.n26 IBIAS.n19 0.00131325
R16814 IBIAS.n22 IBIAS.n21 0.00104217
R16815 IBIAS.n27 IBIAS.n18 0.00104217
R16816 IBIAS.n26 IBIAS.n25 0.000771084
R16817 programmable_folded_cascode_0.EN0.n22 programmable_folded_cascode_0.EN0.n21 57.5519
R16818 programmable_folded_cascode_0.EN0.n23 programmable_folded_cascode_0.EN0.n22 52.0394
R16819 programmable_folded_cascode_0.EN0.n24 programmable_folded_cascode_0.EN0.n23 37.503
R16820 programmable_folded_cascode_0.EN0 programmable_folded_cascode_0.EN0.t6 30.3647
R16821 programmable_folded_cascode_0.EN0 programmable_folded_cascode_0.EN0.t20 30.3647
R16822 programmable_folded_cascode_0.EN0 programmable_folded_cascode_0.EN0.t5 30.3647
R16823 programmable_folded_cascode_0.EN0 programmable_folded_cascode_0.EN0.t17 30.3647
R16824 programmable_folded_cascode_0.EN0 programmable_folded_cascode_0.EN0.t13 30.3647
R16825 programmable_folded_cascode_0.EN0 programmable_folded_cascode_0.EN0.t16 30.3647
R16826 programmable_folded_cascode_0.EN0 programmable_folded_cascode_0.EN0.t14 30.3647
R16827 programmable_folded_cascode_0.EN0 programmable_folded_cascode_0.EN0.t8 25.0275
R16828 programmable_folded_cascode_0.EN0 programmable_folded_cascode_0.EN0.t9 24.9481
R16829 programmable_folded_cascode_0.EN0.n0 programmable_folded_cascode_0.EN0.t21 24.9469
R16830 programmable_folded_cascode_0.EN0.n3 programmable_folded_cascode_0.EN0.t3 24.9469
R16831 programmable_folded_cascode_0.EN0.n13 programmable_folded_cascode_0.EN0.t11 24.9469
R16832 programmable_folded_cascode_0.EN0.n14 programmable_folded_cascode_0.EN0.t10 24.9469
R16833 programmable_folded_cascode_0.EN0.n9 programmable_folded_cascode_0.EN0.t7 24.9469
R16834 programmable_folded_cascode_0.EN0.n10 programmable_folded_cascode_0.EN0.t4 24.9469
R16835 programmable_folded_cascode_0.EN0.n5 programmable_folded_cascode_0.EN0.t19 24.9469
R16836 programmable_folded_cascode_0.EN0.n6 programmable_folded_cascode_0.EN0.t15 24.9469
R16837 programmable_folded_cascode_0.EN0.n17 programmable_folded_cascode_0.EN0.t22 24.9469
R16838 programmable_folded_cascode_0.EN0.n18 programmable_folded_cascode_0.EN0.t18 24.9469
R16839 programmable_folded_cascode_0.EN0.n21 programmable_folded_cascode_0.EN0.t12 24.9469
R16840 programmable_folded_cascode_0.EN0 programmable_folded_cascode_0.EN0.t0 17.2081
R16841 programmable_folded_cascode_0.EN0.n2 programmable_folded_cascode_0.EN0.t2 17.1605
R16842 programmable_folded_cascode_0.EN0.n1 programmable_folded_cascode_0.EN0.t1 16.7833
R16843 programmable_folded_cascode_0.EN0 programmable_folded_cascode_0.EN0.n0 15.6278
R16844 programmable_folded_cascode_0.EN0.n23 programmable_folded_cascode_0.EN0.n3 9.43866
R16845 programmable_folded_cascode_0.EN0.n4 programmable_folded_cascode_0.EN0 5.92335
R16846 programmable_folded_cascode_0.EN0.n13 programmable_folded_cascode_0.EN0 4.84984
R16847 programmable_folded_cascode_0.EN0.n14 programmable_folded_cascode_0.EN0 4.84984
R16848 programmable_folded_cascode_0.EN0.n9 programmable_folded_cascode_0.EN0 4.84984
R16849 programmable_folded_cascode_0.EN0.n10 programmable_folded_cascode_0.EN0 4.84984
R16850 programmable_folded_cascode_0.EN0.n5 programmable_folded_cascode_0.EN0 4.84984
R16851 programmable_folded_cascode_0.EN0.n6 programmable_folded_cascode_0.EN0 4.84984
R16852 programmable_folded_cascode_0.EN0.n20 programmable_folded_cascode_0.EN0.n19 4.5005
R16853 programmable_folded_cascode_0.EN0.n8 programmable_folded_cascode_0.EN0.n7 4.5005
R16854 programmable_folded_cascode_0.EN0.n12 programmable_folded_cascode_0.EN0.n11 4.5005
R16855 programmable_folded_cascode_0.EN0.n16 programmable_folded_cascode_0.EN0.n15 4.5005
R16856 programmable_folded_cascode_0.EN0.n22 programmable_folded_cascode_0.EN0.n20 3.87879
R16857 programmable_folded_cascode_0.EN0.n20 programmable_folded_cascode_0.EN0.n16 3.58747
R16858 programmable_folded_cascode_0.EN0.n8 programmable_folded_cascode_0.EN0.n4 3.19905
R16859 programmable_folded_cascode_0.EN0.n12 programmable_folded_cascode_0.EN0.n8 3.14103
R16860 programmable_folded_cascode_0.EN0.n16 programmable_folded_cascode_0.EN0.n12 3.09603
R16861 programmable_folded_cascode_0.EN0.n19 programmable_folded_cascode_0.EN0 2.25879
R16862 programmable_folded_cascode_0.EN0.n7 programmable_folded_cascode_0.EN0 2.2166
R16863 programmable_folded_cascode_0.EN0.n11 programmable_folded_cascode_0.EN0 2.21427
R16864 programmable_folded_cascode_0.EN0.n15 programmable_folded_cascode_0.EN0 2.21193
R16865 programmable_folded_cascode_0.EN0.n4 programmable_folded_cascode_0.EN0 2.17234
R16866 programmable_folded_cascode_0.EN0.n19 programmable_folded_cascode_0.EN0 1.40853
R16867 programmable_folded_cascode_0.EN0.n15 programmable_folded_cascode_0.EN0 1.40076
R16868 programmable_folded_cascode_0.EN0.n11 programmable_folded_cascode_0.EN0 1.39842
R16869 programmable_folded_cascode_0.EN0.n7 programmable_folded_cascode_0.EN0 1.39608
R16870 programmable_folded_cascode_0.EN0.n2 programmable_folded_cascode_0.EN0.n1 0.386214
R16871 programmable_folded_cascode_0.EN0 programmable_folded_cascode_0.EN0.n2 0.182107
R16872 programmable_folded_cascode_0.EN0.n24 programmable_folded_cascode_0.EN0 0.143536
R16873 programmable_folded_cascode_0.EN0.n1 programmable_folded_cascode_0.EN0 0.140321
R16874 programmable_folded_cascode_0.EN0.n0 programmable_folded_cascode_0.EN0 0.0721524
R16875 programmable_folded_cascode_0.EN0 programmable_folded_cascode_0.EN0.n24 0.0294286
R16876 programmable_folded_cascode_0.EN0.n3 programmable_folded_cascode_0.EN0 0.0265526
R16877 programmable_folded_cascode_0.EN0.n17 programmable_folded_cascode_0.EN0 0.0265526
R16878 programmable_folded_cascode_0.EN0.n18 programmable_folded_cascode_0.EN0 0.0265526
R16879 programmable_folded_cascode_0.EN0.n21 programmable_folded_cascode_0.EN0 0.0265526
R16880 programmable_folded_cascode_0.EN0.n3 programmable_folded_cascode_0.EN0 0.00168421
R16881 programmable_folded_cascode_0.EN0 programmable_folded_cascode_0.EN0.n17 0.00168421
R16882 programmable_folded_cascode_0.EN0 programmable_folded_cascode_0.EN0.n18 0.00168421
R16883 programmable_folded_cascode_0.EN0.n21 programmable_folded_cascode_0.EN0 0.00168421
R16884 programmable_folded_cascode_0.EN0 programmable_folded_cascode_0.EN0.n13 0.00166883
R16885 programmable_folded_cascode_0.EN0 programmable_folded_cascode_0.EN0.n14 0.00166883
R16886 programmable_folded_cascode_0.EN0 programmable_folded_cascode_0.EN0.n9 0.00166883
R16887 programmable_folded_cascode_0.EN0 programmable_folded_cascode_0.EN0.n10 0.00166883
R16888 programmable_folded_cascode_0.EN0 programmable_folded_cascode_0.EN0.n5 0.00166883
R16889 programmable_folded_cascode_0.EN0 programmable_folded_cascode_0.EN0.n6 0.00166883
R16890 programmable_folded_cascode_0.programmable_pfet_1.transmission_gate$16_0.out.t3 programmable_folded_cascode_0.programmable_pfet_1.transmission_gate$16_0.out.t10 264.151
R16891 programmable_folded_cascode_0.programmable_pfet_1.transmission_gate$16_0.out.t9 programmable_folded_cascode_0.programmable_pfet_1.transmission_gate$16_0.out.t8 264.115
R16892 programmable_folded_cascode_0.programmable_pfet_1.transmission_gate$16_0.out.t10 programmable_folded_cascode_0.programmable_pfet_1.transmission_gate$16_0.out.t9 264.115
R16893 programmable_folded_cascode_0.programmable_pfet_1.transmission_gate$16_0.out.t11 programmable_folded_cascode_0.programmable_pfet_1.transmission_gate$16_0.out.t3 264.115
R16894 programmable_folded_cascode_0.programmable_pfet_1.transmission_gate$16_0.out.t6 programmable_folded_cascode_0.programmable_pfet_1.transmission_gate$16_0.out.t11 264.115
R16895 programmable_folded_cascode_0.programmable_pfet_1.transmission_gate$16_0.out.t7 programmable_folded_cascode_0.programmable_pfet_1.transmission_gate$16_0.out.t6 264.115
R16896 programmable_folded_cascode_0.programmable_pfet_1.transmission_gate$16_0.out.t4 programmable_folded_cascode_0.programmable_pfet_1.transmission_gate$16_0.out.t7 264.115
R16897 programmable_folded_cascode_0.programmable_pfet_1.transmission_gate$16_0.out.t12 programmable_folded_cascode_0.programmable_pfet_1.transmission_gate$16_0.out.t4 264.115
R16898 programmable_folded_cascode_0.programmable_pfet_1.transmission_gate$16_0.out.t5 programmable_folded_cascode_0.programmable_pfet_1.transmission_gate$16_0.out.t12 264.115
R16899 programmable_folded_cascode_0.programmable_pfet_1.transmission_gate$16_0.out.n0 programmable_folded_cascode_0.programmable_pfet_1.transmission_gate$16_0.out.t5 138.597
R16900 programmable_folded_cascode_0.programmable_pfet_1.transmission_gate$16_0.out.n0 programmable_folded_cascode_0.programmable_pfet_1.transmission_gate$16_0.out.t2 22.607
R16901 programmable_folded_cascode_0.programmable_pfet_1.transmission_gate$16_0.out.n1 programmable_folded_cascode_0.programmable_pfet_1.transmission_gate$16_0.out.t1 12.5243
R16902 programmable_folded_cascode_0.programmable_pfet_1.transmission_gate$16_0.out programmable_folded_cascode_0.programmable_pfet_1.transmission_gate$16_0.out.t0 12.2669
R16903 programmable_folded_cascode_0.programmable_pfet_1.transmission_gate$16_0.out.n1 programmable_folded_cascode_0.programmable_pfet_1.transmission_gate$16_0.out.n0 10.3256
R16904 programmable_folded_cascode_0.programmable_pfet_1.transmission_gate$16_0.out programmable_folded_cascode_0.programmable_pfet_1.transmission_gate$16_0.out.n1 0.0329
R16905 programmable_5tOTA_0.programmable_pfet$4_0.transmission_gate$27_0.out.t6 programmable_5tOTA_0.programmable_pfet$4_0.transmission_gate$27_0.out.t5 750.149
R16906 programmable_5tOTA_0.programmable_pfet$4_0.transmission_gate$27_0.out.t4 programmable_5tOTA_0.programmable_pfet$4_0.transmission_gate$27_0.out.t3 750.149
R16907 programmable_5tOTA_0.programmable_pfet$4_0.transmission_gate$27_0.out.n1 programmable_5tOTA_0.programmable_pfet$4_0.transmission_gate$27_0.out.t4 394.604
R16908 programmable_5tOTA_0.programmable_pfet$4_0.transmission_gate$27_0.out.n0 programmable_5tOTA_0.programmable_pfet$4_0.transmission_gate$27_0.out.t6 390.029
R16909 programmable_5tOTA_0.programmable_pfet$4_0.transmission_gate$27_0.out.n2 programmable_5tOTA_0.programmable_pfet$4_0.transmission_gate$27_0.out.n1 14.7704
R16910 programmable_5tOTA_0.programmable_pfet$4_0.transmission_gate$27_0.out.n0 programmable_5tOTA_0.programmable_pfet$4_0.transmission_gate$27_0.out.t2 13.0317
R16911 programmable_5tOTA_0.programmable_pfet$4_0.transmission_gate$27_0.out.n2 programmable_5tOTA_0.programmable_pfet$4_0.transmission_gate$27_0.out.t1 12.5327
R16912 programmable_5tOTA_0.programmable_pfet$4_0.transmission_gate$27_0.out programmable_5tOTA_0.programmable_pfet$4_0.transmission_gate$27_0.out.t0 12.2669
R16913 programmable_5tOTA_0.programmable_pfet$4_0.transmission_gate$27_0.out.n1 programmable_5tOTA_0.programmable_pfet$4_0.transmission_gate$27_0.out.n0 5.01658
R16914 programmable_5tOTA_0.programmable_pfet$4_0.transmission_gate$27_0.out programmable_5tOTA_0.programmable_pfet$4_0.transmission_gate$27_0.out.n2 0.0245
R16915 programmable_folded_cascode_0.programmable_nfet$2_0.g.n3 programmable_folded_cascode_0.programmable_nfet$2_0.g.t17 91.7224
R16916 programmable_folded_cascode_0.programmable_nfet$2_0.g.n13 programmable_folded_cascode_0.programmable_nfet$2_0.g.t11 86.3307
R16917 programmable_folded_cascode_0.programmable_nfet$2_0.g.n5 programmable_folded_cascode_0.programmable_nfet$2_0.g.n4 13.4425
R16918 programmable_folded_cascode_0.programmable_nfet$2_0.g programmable_folded_cascode_0.programmable_nfet$2_0.g.t3 12.5271
R16919 programmable_folded_cascode_0.programmable_nfet$2_0.g programmable_folded_cascode_0.programmable_nfet$2_0.g.t8 12.5271
R16920 programmable_folded_cascode_0.programmable_nfet$2_0.g programmable_folded_cascode_0.programmable_nfet$2_0.g.t4 12.5271
R16921 programmable_folded_cascode_0.programmable_nfet$2_0.g programmable_folded_cascode_0.programmable_nfet$2_0.g.t7 12.5271
R16922 programmable_folded_cascode_0.programmable_nfet$2_0.g.n0 programmable_folded_cascode_0.programmable_nfet$2_0.g.t6 12.2345
R16923 programmable_folded_cascode_0.programmable_nfet$2_0.g.n1 programmable_folded_cascode_0.programmable_nfet$2_0.g.t5 12.2345
R16924 programmable_folded_cascode_0.programmable_nfet$2_0.g.n2 programmable_folded_cascode_0.programmable_nfet$2_0.g.t1 12.2279
R16925 programmable_folded_cascode_0.programmable_nfet$2_0.g.n15 programmable_folded_cascode_0.programmable_nfet$2_0.g.t0 12.2279
R16926 programmable_folded_cascode_0.programmable_nfet$2_0.g.n10 programmable_folded_cascode_0.programmable_nfet$2_0.g.n9 10.5909
R16927 programmable_folded_cascode_0.programmable_nfet$2_0.g.n13 programmable_folded_cascode_0.programmable_nfet$2_0.g.n12 10.1392
R16928 programmable_folded_cascode_0.programmable_nfet$2_0.g.n11 programmable_folded_cascode_0.programmable_nfet$2_0.g.n6 7.07373
R16929 programmable_folded_cascode_0.programmable_nfet$2_0.g.n11 programmable_folded_cascode_0.programmable_nfet$2_0.g.n10 5.83796
R16930 programmable_folded_cascode_0.programmable_nfet$2_0.g.n7 programmable_folded_cascode_0.programmable_nfet$2_0.g.t14 5.8143
R16931 programmable_folded_cascode_0.programmable_nfet$2_0.g.n14 programmable_folded_cascode_0.programmable_nfet$2_0.g.n13 5.39221
R16932 programmable_folded_cascode_0.programmable_nfet$2_0.g.n8 programmable_folded_cascode_0.programmable_nfet$2_0.g.t15 5.22524
R16933 programmable_folded_cascode_0.programmable_nfet$2_0.g.n7 programmable_folded_cascode_0.programmable_nfet$2_0.g.t2 5.22168
R16934 programmable_folded_cascode_0.programmable_nfet$2_0.g.n9 programmable_folded_cascode_0.programmable_nfet$2_0.g.n8 5.1799
R16935 programmable_folded_cascode_0.programmable_nfet$2_0.g.n3 programmable_folded_cascode_0.programmable_nfet$2_0.g.n2 4.71086
R16936 programmable_folded_cascode_0.programmable_nfet$2_0.g.n15 programmable_folded_cascode_0.programmable_nfet$2_0.g.n14 4.71086
R16937 programmable_folded_cascode_0.programmable_nfet$2_0.g.n4 programmable_folded_cascode_0.programmable_nfet$2_0.g.n1 4.61436
R16938 programmable_folded_cascode_0.programmable_nfet$2_0.g.n5 programmable_folded_cascode_0.programmable_nfet$2_0.g.n0 4.6111
R16939 programmable_folded_cascode_0.programmable_nfet$2_0.g.n12 programmable_folded_cascode_0.programmable_nfet$2_0.g.n11 4.5005
R16940 programmable_folded_cascode_0.programmable_nfet$2_0.g.n12 programmable_folded_cascode_0.programmable_nfet$2_0.g.t12 1.89941
R16941 programmable_folded_cascode_0.programmable_nfet$2_0.g.n10 programmable_folded_cascode_0.programmable_nfet$2_0.g.t13 1.39849
R16942 programmable_folded_cascode_0.programmable_nfet$2_0.g.n8 programmable_folded_cascode_0.programmable_nfet$2_0.g.n7 0.594071
R16943 programmable_folded_cascode_0.programmable_nfet$2_0.g.n9 programmable_folded_cascode_0.programmable_nfet$2_0.g.t16 0.5405
R16944 programmable_folded_cascode_0.programmable_nfet$2_0.g.n6 programmable_folded_cascode_0.programmable_nfet$2_0.g.t10 0.0804024
R16945 programmable_folded_cascode_0.programmable_nfet$2_0.g.n6 programmable_folded_cascode_0.programmable_nfet$2_0.g.t9 0.0804024
R16946 programmable_folded_cascode_0.programmable_nfet$2_0.g programmable_folded_cascode_0.programmable_nfet$2_0.g.n5 0.0785723
R16947 programmable_folded_cascode_0.programmable_nfet$2_0.g.n4 programmable_folded_cascode_0.programmable_nfet$2_0.g 0.0753193
R16948 programmable_folded_cascode_0.programmable_nfet$2_0.g.n2 programmable_folded_cascode_0.programmable_nfet$2_0.g 0.0221867
R16949 programmable_folded_cascode_0.programmable_nfet$2_0.g programmable_folded_cascode_0.programmable_nfet$2_0.g.n15 0.0221867
R16950 programmable_folded_cascode_0.programmable_nfet$2_0.g.n0 programmable_folded_cascode_0.programmable_nfet$2_0.g 0.0156807
R16951 programmable_folded_cascode_0.programmable_nfet$2_0.g.n1 programmable_folded_cascode_0.programmable_nfet$2_0.g 0.0156807
R16952 programmable_folded_cascode_0.programmable_nfet$2_0.g programmable_folded_cascode_0.programmable_nfet$2_0.g.n3 0.0113434
R16953 programmable_folded_cascode_0.programmable_nfet$2_0.g.n14 programmable_folded_cascode_0.programmable_nfet$2_0.g 0.0113434
R16954 programmable_folded_cascode_0.programmable_pfet$1_1.transmission_gate$17_1.out.t10 programmable_folded_cascode_0.programmable_pfet$1_1.transmission_gate$17_1.out.t12 452.308
R16955 programmable_folded_cascode_0.programmable_pfet$1_1.transmission_gate$17_1.out.t9 programmable_folded_cascode_0.programmable_pfet$1_1.transmission_gate$17_1.out.t10 452.308
R16956 programmable_folded_cascode_0.programmable_pfet$1_1.transmission_gate$17_1.out.t11 programmable_folded_cascode_0.programmable_pfet$1_1.transmission_gate$17_1.out.t3 452.308
R16957 programmable_folded_cascode_0.programmable_pfet$1_1.transmission_gate$17_1.out.t7 programmable_folded_cascode_0.programmable_pfet$1_1.transmission_gate$17_1.out.t5 452.308
R16958 programmable_folded_cascode_0.programmable_pfet$1_1.transmission_gate$17_1.out.t4 programmable_folded_cascode_0.programmable_pfet$1_1.transmission_gate$17_1.out.t7 452.308
R16959 programmable_folded_cascode_0.programmable_pfet$1_1.transmission_gate$17_1.out.t6 programmable_folded_cascode_0.programmable_pfet$1_1.transmission_gate$17_1.out.t8 452.308
R16960 programmable_folded_cascode_0.programmable_pfet$1_1.transmission_gate$17_1.out.t8 programmable_folded_cascode_0.programmable_pfet$1_1.transmission_gate$17_1.out.t4 452.245
R16961 programmable_folded_cascode_0.programmable_pfet$1_1.transmission_gate$17_1.out.t3 programmable_folded_cascode_0.programmable_pfet$1_1.transmission_gate$17_1.out.t9 452.241
R16962 programmable_folded_cascode_0.programmable_pfet$1_1.transmission_gate$17_1.out.n0 programmable_folded_cascode_0.programmable_pfet$1_1.transmission_gate$17_1.out.t11 232.097
R16963 programmable_folded_cascode_0.programmable_pfet$1_1.transmission_gate$17_1.out.n1 programmable_folded_cascode_0.programmable_pfet$1_1.transmission_gate$17_1.out.t6 231.773
R16964 programmable_folded_cascode_0.programmable_pfet$1_1.transmission_gate$17_1.out.n0 programmable_folded_cascode_0.programmable_pfet$1_1.transmission_gate$17_1.out.t2 13.0317
R16965 programmable_folded_cascode_0.programmable_pfet$1_1.transmission_gate$17_1.out.n2 programmable_folded_cascode_0.programmable_pfet$1_1.transmission_gate$17_1.out.t1 12.5327
R16966 programmable_folded_cascode_0.programmable_pfet$1_1.transmission_gate$17_1.out programmable_folded_cascode_0.programmable_pfet$1_1.transmission_gate$17_1.out.t0 12.2669
R16967 programmable_folded_cascode_0.programmable_pfet$1_1.transmission_gate$17_1.out.n2 programmable_folded_cascode_0.programmable_pfet$1_1.transmission_gate$17_1.out.n1 10.2254
R16968 programmable_folded_cascode_0.programmable_pfet$1_1.transmission_gate$17_1.out.n1 programmable_folded_cascode_0.programmable_pfet$1_1.transmission_gate$17_1.out.n0 9.51658
R16969 programmable_folded_cascode_0.programmable_pfet$1_1.transmission_gate$17_1.out programmable_folded_cascode_0.programmable_pfet$1_1.transmission_gate$17_1.out.n2 0.0245
R16970 a_55661_23626.n19 a_55661_23626.n18 28.9581
R16971 a_55661_23626.n19 a_55661_23626.n11 13.4276
R16972 a_55661_23626.n3 a_55661_23626.t1 7.32611
R16973 a_55661_23626.n15 a_55661_23626.t20 7.32611
R16974 a_55661_23626.n0 a_55661_23626.t19 7.24116
R16975 a_55661_23626.n12 a_55661_23626.t14 7.24116
R16976 a_55661_23626.n1 a_55661_23626.t7 7.20026
R16977 a_55661_23626.n13 a_55661_23626.t5 7.20026
R16978 a_55661_23626.n2 a_55661_23626.n0 7.01568
R16979 a_55661_23626.n14 a_55661_23626.n12 7.01568
R16980 a_55661_23626.n4 a_55661_23626.n3 6.56127
R16981 a_55661_23626.n16 a_55661_23626.n15 6.56127
R16982 a_55661_23626.n17 a_55661_23626.t22 6.48689
R16983 a_55661_23626.t3 a_55661_23626.n21 6.48689
R16984 a_55661_23626.n2 a_55661_23626.n1 6.48383
R16985 a_55661_23626.n14 a_55661_23626.n13 6.48383
R16986 a_55661_23626.n20 a_55661_23626.n4 6.38573
R16987 a_55661_23626.n9 a_55661_23626.n7 6.02046
R16988 a_55661_23626.n10 a_55661_23626.n9 5.98227
R16989 a_55661_23626.n18 a_55661_23626.n16 5.66164
R16990 a_55661_23626.n9 a_55661_23626.n8 5.28727
R16991 a_55661_23626.n20 a_55661_23626.n19 5.01193
R16992 a_55661_23626.n8 a_55661_23626.t12 4.34102
R16993 a_55661_23626.n7 a_55661_23626.n5 3.45997
R16994 a_55661_23626.n11 a_55661_23626.t17 2.74071
R16995 a_55661_23626.n18 a_55661_23626.n17 1.08868
R16996 a_55661_23626.n4 a_55661_23626.n2 0.504136
R16997 a_55661_23626.n16 a_55661_23626.n14 0.504136
R16998 a_55661_23626.n11 a_55661_23626.n10 0.440882
R16999 a_55661_23626.n21 a_55661_23626.n20 0.364591
R17000 a_55661_23626.n10 a_55661_23626.t16 0.2765
R17001 a_55661_23626.n8 a_55661_23626.t13 0.2765
R17002 a_55661_23626.n21 a_55661_23626.t0 0.186113
R17003 a_55661_23626.n0 a_55661_23626.t18 0.186113
R17004 a_55661_23626.n1 a_55661_23626.t8 0.186113
R17005 a_55661_23626.n3 a_55661_23626.t2 0.186113
R17006 a_55661_23626.n17 a_55661_23626.t21 0.186113
R17007 a_55661_23626.n12 a_55661_23626.t15 0.186113
R17008 a_55661_23626.n13 a_55661_23626.t4 0.186113
R17009 a_55661_23626.n15 a_55661_23626.t23 0.186113
R17010 a_55661_23626.n7 a_55661_23626.n6 0.1505
R17011 a_55661_23626.n5 a_55661_23626.t6 0.0824
R17012 a_55661_23626.n5 a_55661_23626.t11 0.0824
R17013 a_55661_23626.n6 a_55661_23626.t10 0.0824
R17014 a_55661_23626.n6 a_55661_23626.t9 0.0824
R17015 programmable_5tOTA_0.programmable_nfet$8_0.transmission_gate$29_0.out.t5 programmable_5tOTA_0.programmable_nfet$8_0.transmission_gate$29_0.out.t3 173.522
R17016 programmable_5tOTA_0.programmable_nfet$8_0.transmission_gate$29_0.out.t4 programmable_5tOTA_0.programmable_nfet$8_0.transmission_gate$29_0.out.t5 173.522
R17017 programmable_5tOTA_0.programmable_nfet$8_0.transmission_gate$29_0.out.n0 programmable_5tOTA_0.programmable_nfet$8_0.transmission_gate$29_0.out.t4 99.2245
R17018 programmable_5tOTA_0.programmable_nfet$8_0.transmission_gate$29_0.out.n0 programmable_5tOTA_0.programmable_nfet$8_0.transmission_gate$29_0.out.t0 18.0427
R17019 programmable_5tOTA_0.programmable_nfet$8_0.transmission_gate$29_0.out.n1 programmable_5tOTA_0.programmable_nfet$8_0.transmission_gate$29_0.out.t1 12.3005
R17020 programmable_5tOTA_0.programmable_nfet$8_0.transmission_gate$29_0.out programmable_5tOTA_0.programmable_nfet$8_0.transmission_gate$29_0.out.t2 12.2669
R17021 programmable_5tOTA_0.programmable_nfet$8_0.transmission_gate$29_0.out.n1 programmable_5tOTA_0.programmable_nfet$8_0.transmission_gate$29_0.out.n0 5.54197
R17022 programmable_5tOTA_0.programmable_nfet$8_0.transmission_gate$29_0.out programmable_5tOTA_0.programmable_nfet$8_0.transmission_gate$29_0.out.n1 0.2567
R17023 programmable_telescopic_cascode_0.programmable_pfet$3_0.transmission_gate$23_1.out.t8 programmable_telescopic_cascode_0.programmable_pfet$3_0.transmission_gate$23_1.out.t3 604.149
R17024 programmable_telescopic_cascode_0.programmable_pfet$3_0.transmission_gate$23_1.out.t4 programmable_telescopic_cascode_0.programmable_pfet$3_0.transmission_gate$23_1.out.t8 604.149
R17025 programmable_telescopic_cascode_0.programmable_pfet$3_0.transmission_gate$23_1.out.t6 programmable_telescopic_cascode_0.programmable_pfet$3_0.transmission_gate$23_1.out.t4 604.149
R17026 programmable_telescopic_cascode_0.programmable_pfet$3_0.transmission_gate$23_1.out.t7 programmable_telescopic_cascode_0.programmable_pfet$3_0.transmission_gate$23_1.out.t6 604.149
R17027 programmable_telescopic_cascode_0.programmable_pfet$3_0.transmission_gate$23_1.out.t5 programmable_telescopic_cascode_0.programmable_pfet$3_0.transmission_gate$23_1.out.t7 604.149
R17028 programmable_telescopic_cascode_0.programmable_pfet$3_0.transmission_gate$23_1.out.n0 programmable_telescopic_cascode_0.programmable_pfet$3_0.transmission_gate$23_1.out.t5 307.418
R17029 programmable_telescopic_cascode_0.programmable_pfet$3_0.transmission_gate$23_1.out.n0 programmable_telescopic_cascode_0.programmable_pfet$3_0.transmission_gate$23_1.out.t1 22.4615
R17030 programmable_telescopic_cascode_0.programmable_pfet$3_0.transmission_gate$23_1.out.n1 programmable_telescopic_cascode_0.programmable_pfet$3_0.transmission_gate$23_1.out.t0 12.5327
R17031 programmable_telescopic_cascode_0.programmable_pfet$3_0.transmission_gate$23_1.out programmable_telescopic_cascode_0.programmable_pfet$3_0.transmission_gate$23_1.out.t2 12.2669
R17032 programmable_telescopic_cascode_0.programmable_pfet$3_0.transmission_gate$23_1.out.n1 programmable_telescopic_cascode_0.programmable_pfet$3_0.transmission_gate$23_1.out.n0 9.99997
R17033 programmable_telescopic_cascode_0.programmable_pfet$3_0.transmission_gate$23_1.out programmable_telescopic_cascode_0.programmable_pfet$3_0.transmission_gate$23_1.out.n1 0.0245
R17034 programmable_5tOTA_0.programmable_nfet$8_0.transmission_gate$29_1.out.t4 programmable_5tOTA_0.programmable_nfet$8_0.transmission_gate$29_1.out.t8 173.522
R17035 programmable_5tOTA_0.programmable_nfet$8_0.transmission_gate$29_1.out.t3 programmable_5tOTA_0.programmable_nfet$8_0.transmission_gate$29_1.out.t4 173.522
R17036 programmable_5tOTA_0.programmable_nfet$8_0.transmission_gate$29_1.out.t7 programmable_5tOTA_0.programmable_nfet$8_0.transmission_gate$29_1.out.t5 173.522
R17037 programmable_5tOTA_0.programmable_nfet$8_0.transmission_gate$29_1.out.t6 programmable_5tOTA_0.programmable_nfet$8_0.transmission_gate$29_1.out.t7 173.522
R17038 programmable_5tOTA_0.programmable_nfet$8_0.transmission_gate$29_1.out.n0 programmable_5tOTA_0.programmable_nfet$8_0.transmission_gate$29_1.out.t6 99.2292
R17039 programmable_5tOTA_0.programmable_nfet$8_0.transmission_gate$29_1.out.n1 programmable_5tOTA_0.programmable_nfet$8_0.transmission_gate$29_1.out.t3 99.2257
R17040 programmable_5tOTA_0.programmable_nfet$8_0.transmission_gate$29_1.out.n0 programmable_5tOTA_0.programmable_nfet$8_0.transmission_gate$29_1.out.t0 17.7382
R17041 programmable_5tOTA_0.programmable_nfet$8_0.transmission_gate$29_1.out.n2 programmable_5tOTA_0.programmable_nfet$8_0.transmission_gate$29_1.out.t2 12.3005
R17042 programmable_5tOTA_0.programmable_nfet$8_0.transmission_gate$29_1.out programmable_5tOTA_0.programmable_nfet$8_0.transmission_gate$29_1.out.t1 12.2669
R17043 programmable_5tOTA_0.programmable_nfet$8_0.transmission_gate$29_1.out.n2 programmable_5tOTA_0.programmable_nfet$8_0.transmission_gate$29_1.out.n1 5.55089
R17044 programmable_5tOTA_0.programmable_nfet$8_0.transmission_gate$29_1.out.n1 programmable_5tOTA_0.programmable_nfet$8_0.transmission_gate$29_1.out.n0 0.354579
R17045 programmable_5tOTA_0.programmable_nfet$8_0.transmission_gate$29_1.out programmable_5tOTA_0.programmable_nfet$8_0.transmission_gate$29_1.out.n2 0.2567
R17046 programmable_common_source_0.EN0.n4 programmable_common_source_0.EN0.n2 74.8224
R17047 programmable_common_source_0.EN0 programmable_common_source_0.EN0.t3 30.5031
R17048 programmable_common_source_0.EN0 programmable_common_source_0.EN0.t7 25.0275
R17049 programmable_common_source_0.EN0.n3 programmable_common_source_0.EN0.t4 24.9469
R17050 programmable_common_source_0.EN0.n1 programmable_common_source_0.EN0.t5 24.9469
R17051 programmable_common_source_0.EN0.n0 programmable_common_source_0.EN0.t6 24.9469
R17052 programmable_common_source_0.EN0 programmable_common_source_0.EN0.t2 17.2081
R17053 programmable_common_source_0.EN0.n6 programmable_common_source_0.EN0.t0 17.1605
R17054 programmable_common_source_0.EN0.n5 programmable_common_source_0.EN0.t1 16.7833
R17055 programmable_common_source_0.EN0.n4 programmable_common_source_0.EN0.n3 15.5587
R17056 programmable_common_source_0.EN0.n2 programmable_common_source_0.EN0 6.47915
R17057 programmable_common_source_0.EN0.n0 programmable_common_source_0.EN0 4.84155
R17058 programmable_common_source_0.EN0.n2 programmable_common_source_0.EN0 1.07889
R17059 programmable_common_source_0.EN0.n6 programmable_common_source_0.EN0.n5 0.386214
R17060 programmable_common_source_0.EN0 programmable_common_source_0.EN0.n6 0.190143
R17061 programmable_common_source_0.EN0.n5 programmable_common_source_0.EN0 0.140321
R17062 programmable_common_source_0.EN0.n3 programmable_common_source_0.EN0 0.0721524
R17063 programmable_common_source_0.EN0 programmable_common_source_0.EN0.n4 0.0696071
R17064 programmable_common_source_0.EN0.n1 programmable_common_source_0.EN0 0.0262143
R17065 programmable_common_source_0.EN0 programmable_common_source_0.EN0.n0 0.00168421
R17066 programmable_common_source_0.EN0 programmable_common_source_0.EN0.n1 0.00166883
R17067 programmable_telescopic_cascode_0.EN0 programmable_telescopic_cascode_0.EN0.t12 30.72
R17068 programmable_telescopic_cascode_0.EN0 programmable_telescopic_cascode_0.EN0.t16 30.72
R17069 programmable_telescopic_cascode_0.EN0 programmable_telescopic_cascode_0.EN0.t5 30.7176
R17070 programmable_telescopic_cascode_0.EN0 programmable_telescopic_cascode_0.EN0.t13 30.7129
R17071 programmable_telescopic_cascode_0.EN0 programmable_telescopic_cascode_0.EN0.t10 30.7129
R17072 programmable_telescopic_cascode_0.EN0 programmable_telescopic_cascode_0.EN0.t7 25.0275
R17073 programmable_telescopic_cascode_0.EN0.n0 programmable_telescopic_cascode_0.EN0.t3 24.9469
R17074 programmable_telescopic_cascode_0.EN0.n10 programmable_telescopic_cascode_0.EN0.t9 24.9469
R17075 programmable_telescopic_cascode_0.EN0.n8 programmable_telescopic_cascode_0.EN0.t8 24.9469
R17076 programmable_telescopic_cascode_0.EN0.n6 programmable_telescopic_cascode_0.EN0.t11 24.9469
R17077 programmable_telescopic_cascode_0.EN0.n4 programmable_telescopic_cascode_0.EN0.t15 24.9469
R17078 programmable_telescopic_cascode_0.EN0.n3 programmable_telescopic_cascode_0.EN0.t17 24.9469
R17079 programmable_telescopic_cascode_0.EN0.n18 programmable_telescopic_cascode_0.EN0.t14 24.9469
R17080 programmable_telescopic_cascode_0.EN0.n16 programmable_telescopic_cascode_0.EN0.t6 24.9469
R17081 programmable_telescopic_cascode_0.EN0.n14 programmable_telescopic_cascode_0.EN0.t4 24.9469
R17082 programmable_telescopic_cascode_0.EN0.n12 programmable_telescopic_cascode_0.EN0.t18 24.9469
R17083 programmable_telescopic_cascode_0.EN0 programmable_telescopic_cascode_0.EN0.t2 17.2081
R17084 programmable_telescopic_cascode_0.EN0.n2 programmable_telescopic_cascode_0.EN0.t0 17.1605
R17085 programmable_telescopic_cascode_0.EN0.n1 programmable_telescopic_cascode_0.EN0.t1 16.7833
R17086 programmable_telescopic_cascode_0.EN0 programmable_telescopic_cascode_0.EN0.n0 15.6278
R17087 programmable_telescopic_cascode_0.EN0.n20 programmable_telescopic_cascode_0.EN0.n19 11.0784
R17088 programmable_telescopic_cascode_0.EN0.n5 programmable_telescopic_cascode_0.EN0 7.74586
R17089 programmable_telescopic_cascode_0.EN0.n19 programmable_telescopic_cascode_0.EN0 6.56025
R17090 programmable_telescopic_cascode_0.EN0.n17 programmable_telescopic_cascode_0.EN0 4.75948
R17091 programmable_telescopic_cascode_0.EN0.n9 programmable_telescopic_cascode_0.EN0 4.73872
R17092 programmable_telescopic_cascode_0.EN0.n11 programmable_telescopic_cascode_0.EN0 4.73632
R17093 programmable_telescopic_cascode_0.EN0.n13 programmable_telescopic_cascode_0.EN0 4.7344
R17094 programmable_telescopic_cascode_0.EN0.n5 programmable_telescopic_cascode_0.EN0 4.73379
R17095 programmable_telescopic_cascode_0.EN0.n7 programmable_telescopic_cascode_0.EN0 4.73193
R17096 programmable_telescopic_cascode_0.EN0.n15 programmable_telescopic_cascode_0.EN0 4.73127
R17097 programmable_telescopic_cascode_0.EN0.n10 programmable_telescopic_cascode_0.EN0 4.50879
R17098 programmable_telescopic_cascode_0.EN0.n8 programmable_telescopic_cascode_0.EN0 4.50879
R17099 programmable_telescopic_cascode_0.EN0.n6 programmable_telescopic_cascode_0.EN0 4.50879
R17100 programmable_telescopic_cascode_0.EN0.n4 programmable_telescopic_cascode_0.EN0 4.50879
R17101 programmable_telescopic_cascode_0.EN0.n3 programmable_telescopic_cascode_0.EN0 4.50405
R17102 programmable_telescopic_cascode_0.EN0.n17 programmable_telescopic_cascode_0.EN0.n15 3.938
R17103 programmable_telescopic_cascode_0.EN0.n15 programmable_telescopic_cascode_0.EN0.n13 3.92476
R17104 programmable_telescopic_cascode_0.EN0.n13 programmable_telescopic_cascode_0.EN0.n11 3.47079
R17105 programmable_telescopic_cascode_0.EN0.n7 programmable_telescopic_cascode_0.EN0.n5 3.01153
R17106 programmable_telescopic_cascode_0.EN0.n9 programmable_telescopic_cascode_0.EN0.n7 3.01021
R17107 programmable_telescopic_cascode_0.EN0 programmable_telescopic_cascode_0.EN0.n9 2.59991
R17108 programmable_telescopic_cascode_0.EN0.n19 programmable_telescopic_cascode_0.EN0.n17 2.11285
R17109 programmable_telescopic_cascode_0.EN0.n11 programmable_telescopic_cascode_0.EN0 0.410794
R17110 programmable_telescopic_cascode_0.EN0.n2 programmable_telescopic_cascode_0.EN0.n1 0.386214
R17111 programmable_telescopic_cascode_0.EN0.n20 programmable_telescopic_cascode_0.EN0.n2 0.19175
R17112 programmable_telescopic_cascode_0.EN0.n1 programmable_telescopic_cascode_0.EN0 0.140321
R17113 programmable_telescopic_cascode_0.EN0.n0 programmable_telescopic_cascode_0.EN0 0.0721524
R17114 programmable_telescopic_cascode_0.EN0.n16 programmable_telescopic_cascode_0.EN0 0.00634416
R17115 programmable_telescopic_cascode_0.EN0.n18 programmable_telescopic_cascode_0.EN0 0.00626923
R17116 programmable_telescopic_cascode_0.EN0.n12 programmable_telescopic_cascode_0.EN0 0.00517532
R17117 programmable_telescopic_cascode_0.EN0.n14 programmable_telescopic_cascode_0.EN0 0.00511538
R17118 programmable_telescopic_cascode_0.EN0 programmable_telescopic_cascode_0.EN0.n20 0.00210714
R17119 programmable_telescopic_cascode_0.EN0 programmable_telescopic_cascode_0.EN0.n10 0.00168421
R17120 programmable_telescopic_cascode_0.EN0 programmable_telescopic_cascode_0.EN0.n8 0.00168421
R17121 programmable_telescopic_cascode_0.EN0 programmable_telescopic_cascode_0.EN0.n4 0.00168421
R17122 programmable_telescopic_cascode_0.EN0 programmable_telescopic_cascode_0.EN0.n3 0.00168421
R17123 programmable_telescopic_cascode_0.EN0 programmable_telescopic_cascode_0.EN0.n6 0.00166883
R17124 programmable_telescopic_cascode_0.EN0 programmable_telescopic_cascode_0.EN0.n16 0.00166883
R17125 programmable_telescopic_cascode_0.EN0 programmable_telescopic_cascode_0.EN0.n12 0.00166883
R17126 programmable_telescopic_cascode_0.EN0 programmable_telescopic_cascode_0.EN0.n18 0.00165385
R17127 programmable_telescopic_cascode_0.EN0 programmable_telescopic_cascode_0.EN0.n14 0.00165385
R17128 programmable_folded_cascode_0.programmable_pfet$1_1.transmission_gate$17_0.out.t5 programmable_folded_cascode_0.programmable_pfet$1_1.transmission_gate$17_0.out.t7 452.308
R17129 programmable_folded_cascode_0.programmable_pfet$1_1.transmission_gate$17_0.out.t3 programmable_folded_cascode_0.programmable_pfet$1_1.transmission_gate$17_0.out.t5 452.308
R17130 programmable_folded_cascode_0.programmable_pfet$1_1.transmission_gate$17_0.out.t4 programmable_folded_cascode_0.programmable_pfet$1_1.transmission_gate$17_0.out.t6 452.308
R17131 programmable_folded_cascode_0.programmable_pfet$1_1.transmission_gate$17_0.out.t6 programmable_folded_cascode_0.programmable_pfet$1_1.transmission_gate$17_0.out.t3 452.238
R17132 programmable_folded_cascode_0.programmable_pfet$1_1.transmission_gate$17_0.out.n0 programmable_folded_cascode_0.programmable_pfet$1_1.transmission_gate$17_0.out.t4 231.762
R17133 programmable_folded_cascode_0.programmable_pfet$1_1.transmission_gate$17_0.out.n0 programmable_folded_cascode_0.programmable_pfet$1_1.transmission_gate$17_0.out.t2 22.6519
R17134 programmable_folded_cascode_0.programmable_pfet$1_1.transmission_gate$17_0.out.n1 programmable_folded_cascode_0.programmable_pfet$1_1.transmission_gate$17_0.out.t1 12.5243
R17135 programmable_folded_cascode_0.programmable_pfet$1_1.transmission_gate$17_0.out programmable_folded_cascode_0.programmable_pfet$1_1.transmission_gate$17_0.out.t0 12.2669
R17136 programmable_folded_cascode_0.programmable_pfet$1_1.transmission_gate$17_0.out.n1 programmable_folded_cascode_0.programmable_pfet$1_1.transmission_gate$17_0.out.n0 10.9105
R17137 programmable_folded_cascode_0.programmable_pfet$1_1.transmission_gate$17_0.out programmable_folded_cascode_0.programmable_pfet$1_1.transmission_gate$17_0.out.n1 0.0329
R17138 IN_CS.t4 IN_CS.t10 77.2345
R17139 IN_CS.t13 IN_CS.t4 77.2345
R17140 IN_CS.t8 IN_CS.t13 77.2345
R17141 IN_CS.t5 IN_CS.t8 77.2345
R17142 IN_CS.t11 IN_CS.t5 77.2345
R17143 IN_CS.t6 IN_CS.t11 77.2345
R17144 IN_CS.t12 IN_CS.t6 77.2345
R17145 IN_CS.t9 IN_CS.t12 77.2345
R17146 IN_CS.t7 IN_CS.t9 77.2345
R17147 IN_CS.n3 IN_CS.t7 50.3491
R17148 IN_CS.n2 IN_CS 18.7862
R17149 IN_CS.n1 IN_CS.t0 12.487
R17150 IN_CS.n0 IN_CS.t2 12.4859
R17151 IN_CS IN_CS.t3 12.2496
R17152 IN_CS IN_CS.t1 12.2496
R17153 IN_CS IN_CS.n0 4.76124
R17154 IN_CS.n2 IN_CS.n1 4.59976
R17155 IN_CS.n3 IN_CS.n2 0.122265
R17156 IN_CS.n0 IN_CS 0.0417048
R17157 IN_CS.n1 IN_CS 0.0406205
R17158 IN_CS IN_CS.n3 0.0150588
R17159 INP_FOLDED.t4 INP_FOLDED.n3 234.008
R17160 INP_FOLDED.n4 INP_FOLDED.t5 225.917
R17161 INP_FOLDED.n4 INP_FOLDED.t4 225.639
R17162 INP_FOLDED.n16 INP_FOLDED.n15 30.4364
R17163 INP_FOLDED INP_FOLDED.t1 12.5271
R17164 INP_FOLDED INP_FOLDED.t3 12.5271
R17165 INP_FOLDED.n0 INP_FOLDED.t2 12.2345
R17166 INP_FOLDED.n1 INP_FOLDED.t0 12.2279
R17167 INP_FOLDED.n16 INP_FOLDED.n5 8.12075
R17168 INP_FOLDED.n5 INP_FOLDED.n4 8.0005
R17169 INP_FOLDED.n5 INP_FOLDED.n3 7.32455
R17170 INP_FOLDED.n3 INP_FOLDED.n2 5.38813
R17171 INP_FOLDED.n2 INP_FOLDED.n1 4.71086
R17172 INP_FOLDED INP_FOLDED.n0 4.68917
R17173 INP_FOLDED.n15 INP_FOLDED.n14 4.50104
R17174 INP_FOLDED.n12 INP_FOLDED.n9 4.50073
R17175 INP_FOLDED.n10 INP_FOLDED.n8 4.5005
R17176 INP_FOLDED.n7 INP_FOLDED.n6 4.5005
R17177 INP_FOLDED.n12 INP_FOLDED.n11 4.5005
R17178 INP_FOLDED.n14 INP_FOLDED.n13 4.5005
R17179 INP_FOLDED.n9 INP_FOLDED 0.0574277
R17180 INP_FOLDED.n13 INP_FOLDED.n8 0.0501241
R17181 INP_FOLDED.n1 INP_FOLDED 0.0221867
R17182 INP_FOLDED.n14 INP_FOLDED.n7 0.0211024
R17183 INP_FOLDED.n11 INP_FOLDED.n10 0.0203795
R17184 INP_FOLDED INP_FOLDED.n16 0.0194474
R17185 INP_FOLDED.n0 INP_FOLDED 0.0156807
R17186 INP_FOLDED.n2 INP_FOLDED 0.0113434
R17187 INP_FOLDED.n10 INP_FOLDED.n9 0.00104217
R17188 INP_FOLDED.n11 INP_FOLDED.n7 0.00104217
R17189 INP_FOLDED.n15 INP_FOLDED.n6 0.000725564
R17190 INP_FOLDED.n8 INP_FOLDED.n6 0.000725564
R17191 INP_FOLDED.n13 INP_FOLDED.n12 0.000725564
R17192 transmission_gate$2$1_5.out transmission_gate$2$1_5.out.t21 30.4906
R17193 transmission_gate$2$1_5.out.n24 transmission_gate$2$1_5.out.t19 25.4329
R17194 transmission_gate$2$1_5.out.n21 transmission_gate$2$1_5.out.t5 25.4329
R17195 transmission_gate$2$1_5.out.n18 transmission_gate$2$1_5.out.t13 25.4306
R17196 transmission_gate$2$1_5.out.n15 transmission_gate$2$1_5.out.t10 25.4306
R17197 transmission_gate$2$1_5.out transmission_gate$2$1_5.out.t14 25.0251
R17198 transmission_gate$2$1_5.out transmission_gate$2$1_5.out.t11 25.0251
R17199 transmission_gate$2$1_5.out.n2 transmission_gate$2$1_5.out.t23 25.0227
R17200 transmission_gate$2$1_5.out.n3 transmission_gate$2$1_5.out.t16 24.9469
R17201 transmission_gate$2$1_5.out.n23 transmission_gate$2$1_5.out.t17 24.9469
R17202 transmission_gate$2$1_5.out.n20 transmission_gate$2$1_5.out.t22 24.9469
R17203 transmission_gate$2$1_5.out.n17 transmission_gate$2$1_5.out.t20 24.9469
R17204 transmission_gate$2$1_5.out.n14 transmission_gate$2$1_5.out.t12 24.9469
R17205 transmission_gate$2$1_5.out.n12 transmission_gate$2$1_5.out.t6 24.9469
R17206 transmission_gate$2$1_5.out.n10 transmission_gate$2$1_5.out.t8 24.9469
R17207 transmission_gate$2$1_5.out.n8 transmission_gate$2$1_5.out.t7 24.9469
R17208 transmission_gate$2$1_5.out.n6 transmission_gate$2$1_5.out.t9 24.9469
R17209 transmission_gate$2$1_5.out.n5 transmission_gate$2$1_5.out.t18 24.9469
R17210 transmission_gate$2$1_5.out.n27 transmission_gate$2$1_5.out.t15 24.9469
R17211 transmission_gate$2$1_5.out.n0 transmission_gate$2$1_5.out.t1 17.5462
R17212 transmission_gate$2$1_5.out.n1 transmission_gate$2$1_5.out.t4 16.7838
R17213 transmission_gate$2$1_5.out.n0 transmission_gate$2$1_5.out.t2 16.7833
R17214 transmission_gate$2$1_5.out.n16 transmission_gate$2$1_5.out 14.5855
R17215 transmission_gate$2$1_5.out.n26 transmission_gate$2$1_5.out.n25 13.0629
R17216 transmission_gate$2$1_5.out transmission_gate$2$1_5.out.t3 12.5567
R17217 transmission_gate$2$1_5.out.n30 transmission_gate$2$1_5.out.t0 12.0263
R17218 transmission_gate$2$1_5.out.n4 transmission_gate$2$1_5.out 10.455
R17219 transmission_gate$2$1_5.out.n25 transmission_gate$2$1_5.out.n24 9.27353
R17220 transmission_gate$2$1_5.out.n7 transmission_gate$2$1_5.out 7.61724
R17221 transmission_gate$2$1_5.out transmission_gate$2$1_5.out.n3 6.06552
R17222 transmission_gate$2$1_5.out.n29 transmission_gate$2$1_5.out 5.58854
R17223 transmission_gate$2$1_5.out.n22 transmission_gate$2$1_5.out.n21 5.49078
R17224 transmission_gate$2$1_5.out.n19 transmission_gate$2$1_5.out.n18 5.39752
R17225 transmission_gate$2$1_5.out.n16 transmission_gate$2$1_5.out.n15 5.39632
R17226 transmission_gate$2$1_5.out transmission_gate$2$1_5.out.n17 5.37563
R17227 transmission_gate$2$1_5.out transmission_gate$2$1_5.out.n14 5.37563
R17228 transmission_gate$2$1_5.out transmission_gate$2$1_5.out.n27 5.30534
R17229 transmission_gate$2$1_5.out transmission_gate$2$1_5.out.n2 5.12246
R17230 transmission_gate$2$1_5.out.n24 transmission_gate$2$1_5.out 5.07721
R17231 transmission_gate$2$1_5.out.n21 transmission_gate$2$1_5.out 5.07721
R17232 transmission_gate$2$1_5.out transmission_gate$2$1_5.out.n23 4.94576
R17233 transmission_gate$2$1_5.out transmission_gate$2$1_5.out.n20 4.94576
R17234 transmission_gate$2$1_5.out.n9 transmission_gate$2$1_5.out.n8 4.71011
R17235 transmission_gate$2$1_5.out.n7 transmission_gate$2$1_5.out.n6 4.71011
R17236 transmission_gate$2$1_5.out.n13 transmission_gate$2$1_5.out 4.6857
R17237 transmission_gate$2$1_5.out.n11 transmission_gate$2$1_5.out 4.68168
R17238 transmission_gate$2$1_5.out.n18 transmission_gate$2$1_5.out 4.67813
R17239 transmission_gate$2$1_5.out.n15 transmission_gate$2$1_5.out 4.67813
R17240 transmission_gate$2$1_5.out.n29 transmission_gate$2$1_5.out.n28 4.5005
R17241 transmission_gate$2$1_5.out.n22 transmission_gate$2$1_5.out.n19 4.27907
R17242 transmission_gate$2$1_5.out.n19 transmission_gate$2$1_5.out.n16 4.23907
R17243 transmission_gate$2$1_5.out.n11 transmission_gate$2$1_5.out.n9 2.92174
R17244 transmission_gate$2$1_5.out.n9 transmission_gate$2$1_5.out.n7 2.92164
R17245 transmission_gate$2$1_5.out.n13 transmission_gate$2$1_5.out.n11 2.70179
R17246 transmission_gate$2$1_5.out.n30 transmission_gate$2$1_5.out.n29 1.24764
R17247 transmission_gate$2$1_5.out transmission_gate$2$1_5.out.n1 0.947107
R17248 transmission_gate$2$1_5.out.n25 transmission_gate$2$1_5.out.n22 0.447643
R17249 transmission_gate$2$1_5.out.n1 transmission_gate$2$1_5.out 0.424786
R17250 transmission_gate$2$1_5.out transmission_gate$2$1_5.out.n30 0.2411
R17251 transmission_gate$2$1_5.out.n28 transmission_gate$2$1_5.out.n26 0.166036
R17252 transmission_gate$2$1_5.out transmission_gate$2$1_5.out.n0 0.140321
R17253 transmission_gate$2$1_5.out.n3 transmission_gate$2$1_5.out 0.0751053
R17254 transmission_gate$2$1_5.out.n27 transmission_gate$2$1_5.out 0.0751053
R17255 transmission_gate$2$1_5.out transmission_gate$2$1_5.out.n13 0.0699286
R17256 transmission_gate$2$1_5.out.n28 transmission_gate$2$1_5.out 0.0599643
R17257 transmission_gate$2$1_5.out transmission_gate$2$1_5.out.n12 0.0265526
R17258 transmission_gate$2$1_5.out transmission_gate$2$1_5.out.n10 0.0265526
R17259 transmission_gate$2$1_5.out transmission_gate$2$1_5.out.n5 0.0170789
R17260 transmission_gate$2$1_5.out.n2 transmission_gate$2$1_5.out 0.00878947
R17261 transmission_gate$2$1_5.out.n23 transmission_gate$2$1_5.out 0.00760526
R17262 transmission_gate$2$1_5.out.n20 transmission_gate$2$1_5.out 0.00760526
R17263 transmission_gate$2$1_5.out.n17 transmission_gate$2$1_5.out 0.00760526
R17264 transmission_gate$2$1_5.out.n14 transmission_gate$2$1_5.out 0.00760526
R17265 transmission_gate$2$1_5.out.n12 transmission_gate$2$1_5.out 0.00760526
R17266 transmission_gate$2$1_5.out.n10 transmission_gate$2$1_5.out 0.00760526
R17267 transmission_gate$2$1_5.out.n5 transmission_gate$2$1_5.out 0.00760526
R17268 transmission_gate$2$1_5.out.n8 transmission_gate$2$1_5.out 0.00405263
R17269 transmission_gate$2$1_5.out.n6 transmission_gate$2$1_5.out 0.00405263
R17270 transmission_gate$2$1_5.out.n4 transmission_gate$2$1_5.out 0.00371429
R17271 transmission_gate$2$1_5.out.n26 transmission_gate$2$1_5.out.n4 0.00210714
R17272 programmable_telescopic_cascode_0.programmable_pfet$3_1.transmission_gate$23_1.out.t6 programmable_telescopic_cascode_0.programmable_pfet$3_1.transmission_gate$23_1.out.t7 604.149
R17273 programmable_telescopic_cascode_0.programmable_pfet$3_1.transmission_gate$23_1.out.t8 programmable_telescopic_cascode_0.programmable_pfet$3_1.transmission_gate$23_1.out.t6 604.149
R17274 programmable_telescopic_cascode_0.programmable_pfet$3_1.transmission_gate$23_1.out.t4 programmable_telescopic_cascode_0.programmable_pfet$3_1.transmission_gate$23_1.out.t8 604.149
R17275 programmable_telescopic_cascode_0.programmable_pfet$3_1.transmission_gate$23_1.out.t5 programmable_telescopic_cascode_0.programmable_pfet$3_1.transmission_gate$23_1.out.t4 604.149
R17276 programmable_telescopic_cascode_0.programmable_pfet$3_1.transmission_gate$23_1.out.t3 programmable_telescopic_cascode_0.programmable_pfet$3_1.transmission_gate$23_1.out.t5 604.149
R17277 programmable_telescopic_cascode_0.programmable_pfet$3_1.transmission_gate$23_1.out.n0 programmable_telescopic_cascode_0.programmable_pfet$3_1.transmission_gate$23_1.out.t3 307.418
R17278 programmable_telescopic_cascode_0.programmable_pfet$3_1.transmission_gate$23_1.out.n0 programmable_telescopic_cascode_0.programmable_pfet$3_1.transmission_gate$23_1.out.t1 22.4615
R17279 programmable_telescopic_cascode_0.programmable_pfet$3_1.transmission_gate$23_1.out.n1 programmable_telescopic_cascode_0.programmable_pfet$3_1.transmission_gate$23_1.out.t0 12.5327
R17280 programmable_telescopic_cascode_0.programmable_pfet$3_1.transmission_gate$23_1.out programmable_telescopic_cascode_0.programmable_pfet$3_1.transmission_gate$23_1.out.t2 12.2669
R17281 programmable_telescopic_cascode_0.programmable_pfet$3_1.transmission_gate$23_1.out.n1 programmable_telescopic_cascode_0.programmable_pfet$3_1.transmission_gate$23_1.out.n0 9.99997
R17282 programmable_telescopic_cascode_0.programmable_pfet$3_1.transmission_gate$23_1.out programmable_telescopic_cascode_0.programmable_pfet$3_1.transmission_gate$23_1.out.n1 0.0245
R17283 programmable_telescopic_cascode_0.programmable_pfet$2_1.transmission_gate$22_1.out.t4 programmable_telescopic_cascode_0.programmable_pfet$2_1.transmission_gate$22_1.out.t7 706.348
R17284 programmable_telescopic_cascode_0.programmable_pfet$2_1.transmission_gate$22_1.out.t5 programmable_telescopic_cascode_0.programmable_pfet$2_1.transmission_gate$22_1.out.t4 706.348
R17285 programmable_telescopic_cascode_0.programmable_pfet$2_1.transmission_gate$22_1.out.t6 programmable_telescopic_cascode_0.programmable_pfet$2_1.transmission_gate$22_1.out.t5 706.348
R17286 programmable_telescopic_cascode_0.programmable_pfet$2_1.transmission_gate$22_1.out.t3 programmable_telescopic_cascode_0.programmable_pfet$2_1.transmission_gate$22_1.out.t6 706.348
R17287 programmable_telescopic_cascode_0.programmable_pfet$2_1.transmission_gate$22_1.out.n0 programmable_telescopic_cascode_0.programmable_pfet$2_1.transmission_gate$22_1.out.t3 358.36
R17288 programmable_telescopic_cascode_0.programmable_pfet$2_1.transmission_gate$22_1.out.n0 programmable_telescopic_cascode_0.programmable_pfet$2_1.transmission_gate$22_1.out.t1 22.5385
R17289 programmable_telescopic_cascode_0.programmable_pfet$2_1.transmission_gate$22_1.out.n1 programmable_telescopic_cascode_0.programmable_pfet$2_1.transmission_gate$22_1.out.t0 12.5327
R17290 programmable_telescopic_cascode_0.programmable_pfet$2_1.transmission_gate$22_1.out programmable_telescopic_cascode_0.programmable_pfet$2_1.transmission_gate$22_1.out.t2 12.2669
R17291 programmable_telescopic_cascode_0.programmable_pfet$2_1.transmission_gate$22_1.out.n1 programmable_telescopic_cascode_0.programmable_pfet$2_1.transmission_gate$22_1.out.n0 10.0675
R17292 programmable_telescopic_cascode_0.programmable_pfet$2_1.transmission_gate$22_1.out programmable_telescopic_cascode_0.programmable_pfet$2_1.transmission_gate$22_1.out.n1 0.0245
R17293 programmable_folded_cascode_0.programmable_nfet$3_0.g.t12 programmable_folded_cascode_0.programmable_nfet$3_0.g.t11 153.008
R17294 programmable_folded_cascode_0.programmable_nfet$3_0.g.n6 programmable_folded_cascode_0.programmable_nfet$3_0.g.t9 115.142
R17295 programmable_folded_cascode_0.programmable_nfet$3_0.g.n7 programmable_folded_cascode_0.programmable_nfet$3_0.g.t12 85.3938
R17296 programmable_folded_cascode_0.programmable_nfet$3_0.g.n7 programmable_folded_cascode_0.programmable_nfet$3_0.g.n6 28.554
R17297 programmable_folded_cascode_0.programmable_nfet$3_0.g.n5 programmable_folded_cascode_0.programmable_nfet$3_0.g.n4 16.5321
R17298 programmable_folded_cascode_0.programmable_nfet$3_0.g programmable_folded_cascode_0.programmable_nfet$3_0.g.t6 12.5271
R17299 programmable_folded_cascode_0.programmable_nfet$3_0.g programmable_folded_cascode_0.programmable_nfet$3_0.g.t8 12.5271
R17300 programmable_folded_cascode_0.programmable_nfet$3_0.g.n0 programmable_folded_cascode_0.programmable_nfet$3_0.g.t7 12.2345
R17301 programmable_folded_cascode_0.programmable_nfet$3_0.g.n9 programmable_folded_cascode_0.programmable_nfet$3_0.g.t0 12.2279
R17302 programmable_folded_cascode_0.programmable_nfet$3_0.g.n6 programmable_folded_cascode_0.programmable_nfet$3_0.g.n5 7.81803
R17303 programmable_folded_cascode_0.programmable_nfet$3_0.g.n1 programmable_folded_cascode_0.programmable_nfet$3_0.g.t1 6.01087
R17304 programmable_folded_cascode_0.programmable_nfet$3_0.g.n3 programmable_folded_cascode_0.programmable_nfet$3_0.g.t3 6.01087
R17305 programmable_folded_cascode_0.programmable_nfet$3_0.g.n2 programmable_folded_cascode_0.programmable_nfet$3_0.g.n1 5.77471
R17306 programmable_folded_cascode_0.programmable_nfet$3_0.g.n4 programmable_folded_cascode_0.programmable_nfet$3_0.g.n3 4.98484
R17307 programmable_folded_cascode_0.programmable_nfet$3_0.g.n9 programmable_folded_cascode_0.programmable_nfet$3_0.g.n8 4.71086
R17308 programmable_folded_cascode_0.programmable_nfet$3_0.g programmable_folded_cascode_0.programmable_nfet$3_0.g.n0 4.68917
R17309 programmable_folded_cascode_0.programmable_nfet$3_0.g.n8 programmable_folded_cascode_0.programmable_nfet$3_0.g.n7 4.5005
R17310 programmable_folded_cascode_0.programmable_nfet$3_0.g.n4 programmable_folded_cascode_0.programmable_nfet$3_0.g.n2 0.790368
R17311 programmable_folded_cascode_0.programmable_nfet$3_0.g.n1 programmable_folded_cascode_0.programmable_nfet$3_0.g.t4 0.236659
R17312 programmable_folded_cascode_0.programmable_nfet$3_0.g.n2 programmable_folded_cascode_0.programmable_nfet$3_0.g.t2 0.236659
R17313 programmable_folded_cascode_0.programmable_nfet$3_0.g.n3 programmable_folded_cascode_0.programmable_nfet$3_0.g.t5 0.236659
R17314 programmable_folded_cascode_0.programmable_nfet$3_0.g.n5 programmable_folded_cascode_0.programmable_nfet$3_0.g.t10 0.204015
R17315 programmable_folded_cascode_0.programmable_nfet$3_0.g programmable_folded_cascode_0.programmable_nfet$3_0.g.n9 0.0221867
R17316 programmable_folded_cascode_0.programmable_nfet$3_0.g.n0 programmable_folded_cascode_0.programmable_nfet$3_0.g 0.0156807
R17317 programmable_folded_cascode_0.programmable_nfet$3_0.g.n8 programmable_folded_cascode_0.programmable_nfet$3_0.g 0.0113434
R17318 programmable_telescopic_cascode_0.programmable_pfet$3_0.transmission_gate$23_0.out.t6 programmable_telescopic_cascode_0.programmable_pfet$3_0.transmission_gate$23_0.out.t10 604.149
R17319 programmable_telescopic_cascode_0.programmable_pfet$3_0.transmission_gate$23_0.out.t13 programmable_telescopic_cascode_0.programmable_pfet$3_0.transmission_gate$23_0.out.t6 604.149
R17320 programmable_telescopic_cascode_0.programmable_pfet$3_0.transmission_gate$23_0.out.t4 programmable_telescopic_cascode_0.programmable_pfet$3_0.transmission_gate$23_0.out.t13 604.149
R17321 programmable_telescopic_cascode_0.programmable_pfet$3_0.transmission_gate$23_0.out.t5 programmable_telescopic_cascode_0.programmable_pfet$3_0.transmission_gate$23_0.out.t4 604.149
R17322 programmable_telescopic_cascode_0.programmable_pfet$3_0.transmission_gate$23_0.out.t3 programmable_telescopic_cascode_0.programmable_pfet$3_0.transmission_gate$23_0.out.t5 604.149
R17323 programmable_telescopic_cascode_0.programmable_pfet$3_0.transmission_gate$23_0.out.t14 programmable_telescopic_cascode_0.programmable_pfet$3_0.transmission_gate$23_0.out.t7 604.149
R17324 programmable_telescopic_cascode_0.programmable_pfet$3_0.transmission_gate$23_0.out.t8 programmable_telescopic_cascode_0.programmable_pfet$3_0.transmission_gate$23_0.out.t14 604.149
R17325 programmable_telescopic_cascode_0.programmable_pfet$3_0.transmission_gate$23_0.out.t11 programmable_telescopic_cascode_0.programmable_pfet$3_0.transmission_gate$23_0.out.t8 604.149
R17326 programmable_telescopic_cascode_0.programmable_pfet$3_0.transmission_gate$23_0.out.t12 programmable_telescopic_cascode_0.programmable_pfet$3_0.transmission_gate$23_0.out.t11 604.149
R17327 programmable_telescopic_cascode_0.programmable_pfet$3_0.transmission_gate$23_0.out.t9 programmable_telescopic_cascode_0.programmable_pfet$3_0.transmission_gate$23_0.out.t12 604.149
R17328 programmable_telescopic_cascode_0.programmable_pfet$3_0.transmission_gate$23_0.out.n0 programmable_telescopic_cascode_0.programmable_pfet$3_0.transmission_gate$23_0.out.t9 316.365
R17329 programmable_telescopic_cascode_0.programmable_pfet$3_0.transmission_gate$23_0.out.n0 programmable_telescopic_cascode_0.programmable_pfet$3_0.transmission_gate$23_0.out.t3 307.156
R17330 programmable_telescopic_cascode_0.programmable_pfet$3_0.transmission_gate$23_0.out.n1 programmable_telescopic_cascode_0.programmable_pfet$3_0.transmission_gate$23_0.out.t2 22.452
R17331 programmable_telescopic_cascode_0.programmable_pfet$3_0.transmission_gate$23_0.out.n2 programmable_telescopic_cascode_0.programmable_pfet$3_0.transmission_gate$23_0.out.t1 12.5291
R17332 programmable_telescopic_cascode_0.programmable_pfet$3_0.transmission_gate$23_0.out programmable_telescopic_cascode_0.programmable_pfet$3_0.transmission_gate$23_0.out.t0 12.2669
R17333 programmable_telescopic_cascode_0.programmable_pfet$3_0.transmission_gate$23_0.out.n2 programmable_telescopic_cascode_0.programmable_pfet$3_0.transmission_gate$23_0.out.n1 10.0035
R17334 programmable_telescopic_cascode_0.programmable_pfet$3_0.transmission_gate$23_0.out.n1 programmable_telescopic_cascode_0.programmable_pfet$3_0.transmission_gate$23_0.out.n0 0.269316
R17335 programmable_telescopic_cascode_0.programmable_pfet$3_0.transmission_gate$23_0.out programmable_telescopic_cascode_0.programmable_pfet$3_0.transmission_gate$23_0.out.n2 0.0281
R17336 programmable_5tOTA_0.programmable_pfet$4_0.transmission_gate$27_1.out.t3 programmable_5tOTA_0.programmable_pfet$4_0.transmission_gate$27_1.out.t4 750.149
R17337 programmable_5tOTA_0.programmable_pfet$4_0.transmission_gate$27_1.out.n0 programmable_5tOTA_0.programmable_pfet$4_0.transmission_gate$27_1.out.t3 394.526
R17338 programmable_5tOTA_0.programmable_pfet$4_0.transmission_gate$27_1.out.n0 programmable_5tOTA_0.programmable_pfet$4_0.transmission_gate$27_1.out.t2 17.8479
R17339 programmable_5tOTA_0.programmable_pfet$4_0.transmission_gate$27_1.out.n1 programmable_5tOTA_0.programmable_pfet$4_0.transmission_gate$27_1.out.n0 15.0696
R17340 programmable_5tOTA_0.programmable_pfet$4_0.transmission_gate$27_1.out.n1 programmable_5tOTA_0.programmable_pfet$4_0.transmission_gate$27_1.out.t1 12.5243
R17341 programmable_5tOTA_0.programmable_pfet$4_0.transmission_gate$27_1.out programmable_5tOTA_0.programmable_pfet$4_0.transmission_gate$27_1.out.t0 12.2669
R17342 programmable_5tOTA_0.programmable_pfet$4_0.transmission_gate$27_1.out programmable_5tOTA_0.programmable_pfet$4_0.transmission_gate$27_1.out.n1 0.0329
R17343 PROG_ENA PROG_ENA.t9 30.4906
R17344 PROG_ENA.n34 PROG_ENA.t3 25.0263
R17345 PROG_ENA PROG_ENA.t8 24.9481
R17346 PROG_ENA PROG_ENA.t7 24.9481
R17347 PROG_ENA PROG_ENA.t1 24.9481
R17348 PROG_ENA PROG_ENA.t4 24.9481
R17349 PROG_ENA PROG_ENA.t2 24.9481
R17350 PROG_ENA PROG_ENA.t5 24.9481
R17351 PROG_ENA PROG_ENA.t6 24.9481
R17352 PROG_ENA PROG_ENA.t0 24.9481
R17353 PROG_ENA.n34 PROG_ENA.n33 14.592
R17354 PROG_ENA.n26 PROG_ENA 13.6213
R17355 PROG_ENA.n27 PROG_ENA.n26 9.12011
R17356 PROG_ENA.n28 PROG_ENA.n27 9.12011
R17357 PROG_ENA.n29 PROG_ENA.n28 9.12011
R17358 PROG_ENA.n30 PROG_ENA.n29 9.12011
R17359 PROG_ENA.n31 PROG_ENA.n30 9.12011
R17360 PROG_ENA.n32 PROG_ENA.n31 9.12011
R17361 PROG_ENA.n33 PROG_ENA.n32 7.58008
R17362 PROG_ENA.n14 PROG_ENA.n12 4.51471
R17363 PROG_ENA.n32 PROG_ENA 4.50168
R17364 PROG_ENA.n31 PROG_ENA 4.50168
R17365 PROG_ENA.n30 PROG_ENA 4.50168
R17366 PROG_ENA.n29 PROG_ENA 4.50168
R17367 PROG_ENA.n28 PROG_ENA 4.50168
R17368 PROG_ENA.n27 PROG_ENA 4.50168
R17369 PROG_ENA.n26 PROG_ENA 4.50168
R17370 PROG_ENA.n11 PROG_ENA.n10 4.50104
R17371 PROG_ENA.n8 PROG_ENA.n5 4.50073
R17372 PROG_ENA.n21 PROG_ENA.n13 4.50064
R17373 PROG_ENA.n25 PROG_ENA.n24 4.5005
R17374 PROG_ENA.n19 PROG_ENA.n0 4.5005
R17375 PROG_ENA.n15 PROG_ENA.n14 4.5005
R17376 PROG_ENA.n16 PROG_ENA.n1 4.5005
R17377 PROG_ENA.n18 PROG_ENA.n17 4.5005
R17378 PROG_ENA.n23 PROG_ENA.n22 4.5005
R17379 PROG_ENA.n21 PROG_ENA.n20 4.5005
R17380 PROG_ENA.n6 PROG_ENA.n4 4.5005
R17381 PROG_ENA.n3 PROG_ENA.n2 4.5005
R17382 PROG_ENA.n8 PROG_ENA.n7 4.5005
R17383 PROG_ENA.n10 PROG_ENA.n9 4.5005
R17384 PROG_ENA.n33 PROG_ENA.n25 2.76117
R17385 PROG_ENA.n23 PROG_ENA.n11 0.115538
R17386 PROG_ENA.n5 PROG_ENA 0.0534518
R17387 PROG_ENA.n9 PROG_ENA.n4 0.0501241
R17388 PROG_ENA.n20 PROG_ENA.n1 0.0372669
R17389 PROG_ENA.n18 PROG_ENA.n13 0.0280188
R17390 PROG_ENA.n10 PROG_ENA.n3 0.0211024
R17391 PROG_ENA.n7 PROG_ENA.n6 0.0203795
R17392 PROG_ENA.n16 PROG_ENA.n15 0.0174462
R17393 PROG_ENA.n22 PROG_ENA.n12 0.0167342
R17394 PROG_ENA.n19 PROG_ENA.n18 0.0147105
R17395 PROG_ENA.n24 PROG_ENA.n1 0.0147105
R17396 PROG_ENA PROG_ENA.n34 0.00523684
R17397 PROG_ENA.n14 PROG_ENA.n13 0.00117669
R17398 PROG_ENA.n20 PROG_ENA.n19 0.00117669
R17399 PROG_ENA.n24 PROG_ENA.n23 0.00117669
R17400 PROG_ENA.n25 PROG_ENA.n0 0.00106962
R17401 PROG_ENA.n17 PROG_ENA.n16 0.00106962
R17402 PROG_ENA.n22 PROG_ENA.n21 0.00106962
R17403 PROG_ENA.n6 PROG_ENA.n5 0.00104217
R17404 PROG_ENA.n7 PROG_ENA.n3 0.00104217
R17405 PROG_ENA.n11 PROG_ENA.n2 0.000725564
R17406 PROG_ENA.n4 PROG_ENA.n2 0.000725564
R17407 PROG_ENA.n9 PROG_ENA.n8 0.000725564
R17408 PROG_ENA.n15 PROG_ENA.n0 0.000642405
R17409 PROG_ENA.n17 PROG_ENA.n12 0.000642405
R17410 programmable_common_source_0.EN1.n7 programmable_common_source_0.EN1.n5 62.4148
R17411 programmable_common_source_0.EN1 programmable_common_source_0.EN1.t10 30.4906
R17412 programmable_common_source_0.EN1.n4 programmable_common_source_0.EN1.t7 30.073
R17413 programmable_common_source_0.EN1 programmable_common_source_0.EN1.t6 25.0251
R17414 programmable_common_source_0.EN1 programmable_common_source_0.EN1.t9 25.0251
R17415 programmable_common_source_0.EN1.n1 programmable_common_source_0.EN1.t11 25.0227
R17416 programmable_common_source_0.EN1.n6 programmable_common_source_0.EN1.t8 24.9469
R17417 programmable_common_source_0.EN1.n3 programmable_common_source_0.EN1.t13 24.9469
R17418 programmable_common_source_0.EN1.n2 programmable_common_source_0.EN1.t5 24.9469
R17419 programmable_common_source_0.EN1.n8 programmable_common_source_0.EN1.t12 24.9469
R17420 programmable_common_source_0.EN1.n11 programmable_common_source_0.EN1.t1 17.5462
R17421 programmable_common_source_0.EN1.n12 programmable_common_source_0.EN1.t0 16.7838
R17422 programmable_common_source_0.EN1.n11 programmable_common_source_0.EN1.t2 16.7833
R17423 programmable_common_source_0.EN1 programmable_common_source_0.EN1.t4 12.5567
R17424 programmable_common_source_0.EN1.n0 programmable_common_source_0.EN1.t3 12.0263
R17425 programmable_common_source_0.EN1.n7 programmable_common_source_0.EN1 10.455
R17426 programmable_common_source_0.EN1 programmable_common_source_0.EN1.n6 6.06552
R17427 programmable_common_source_0.EN1 programmable_common_source_0.EN1.n2 5.78063
R17428 programmable_common_source_0.EN1 programmable_common_source_0.EN1.n10 5.58854
R17429 programmable_common_source_0.EN1.n9 programmable_common_source_0.EN1.n8 5.3648
R17430 programmable_common_source_0.EN1 programmable_common_source_0.EN1.n1 5.12246
R17431 programmable_common_source_0.EN1 programmable_common_source_0.EN1.n3 5.03221
R17432 programmable_common_source_0.EN1.n10 programmable_common_source_0.EN1.n9 4.5005
R17433 programmable_common_source_0.EN1.n10 programmable_common_source_0.EN1.n0 1.24764
R17434 programmable_common_source_0.EN1 programmable_common_source_0.EN1.n12 0.947107
R17435 programmable_common_source_0.EN1.n4 programmable_common_source_0.EN1 0.509711
R17436 programmable_common_source_0.EN1.n5 programmable_common_source_0.EN1.n4 0.429184
R17437 programmable_common_source_0.EN1.n12 programmable_common_source_0.EN1 0.424786
R17438 programmable_common_source_0.EN1.n0 programmable_common_source_0.EN1 0.2411
R17439 programmable_common_source_0.EN1.n5 programmable_common_source_0.EN1 0.236158
R17440 programmable_common_source_0.EN1 programmable_common_source_0.EN1.n7 0.151571
R17441 programmable_common_source_0.EN1 programmable_common_source_0.EN1.n11 0.140321
R17442 programmable_common_source_0.EN1.n6 programmable_common_source_0.EN1 0.0751053
R17443 programmable_common_source_0.EN1.n8 programmable_common_source_0.EN1 0.0751053
R17444 programmable_common_source_0.EN1.n9 programmable_common_source_0.EN1 0.0165714
R17445 programmable_common_source_0.EN1.n1 programmable_common_source_0.EN1 0.00878947
R17446 programmable_common_source_0.EN1.n3 programmable_common_source_0.EN1 0.00760526
R17447 programmable_common_source_0.EN1.n2 programmable_common_source_0.EN1 0.00760526
R17448 programmable_common_source_0.EN1.n7 programmable_common_source_0.EN1 0.00371429
R17449 programmable_common_source_0.EN1.n2 programmable_common_source_0.EN1 0.00168421
R17450 programmable_telescopic_cascode_0.programmable_pfet$2_0.g.t18 programmable_telescopic_cascode_0.programmable_pfet$2_0.g.t14 706.348
R17451 programmable_telescopic_cascode_0.programmable_pfet$2_0.g.t20 programmable_telescopic_cascode_0.programmable_pfet$2_0.g.t18 706.348
R17452 programmable_telescopic_cascode_0.programmable_pfet$2_0.g.t13 programmable_telescopic_cascode_0.programmable_pfet$2_0.g.t20 706.348
R17453 programmable_telescopic_cascode_0.programmable_pfet$2_0.g.t17 programmable_telescopic_cascode_0.programmable_pfet$2_0.g.t13 706.348
R17454 programmable_telescopic_cascode_0.programmable_pfet$2_0.g.t16 programmable_telescopic_cascode_0.programmable_pfet$2_0.g.t12 706.348
R17455 programmable_telescopic_cascode_0.programmable_pfet$2_0.g.t19 programmable_telescopic_cascode_0.programmable_pfet$2_0.g.t16 706.348
R17456 programmable_telescopic_cascode_0.programmable_pfet$2_0.g.t11 programmable_telescopic_cascode_0.programmable_pfet$2_0.g.t19 706.348
R17457 programmable_telescopic_cascode_0.programmable_pfet$2_0.g.t15 programmable_telescopic_cascode_0.programmable_pfet$2_0.g.t11 706.348
R17458 programmable_telescopic_cascode_0.programmable_pfet$2_0.g.n6 programmable_telescopic_cascode_0.programmable_pfet$2_0.g.t17 358.255
R17459 programmable_telescopic_cascode_0.programmable_pfet$2_0.g.n10 programmable_telescopic_cascode_0.programmable_pfet$2_0.g.t15 358.255
R17460 programmable_telescopic_cascode_0.programmable_pfet$2_0.g.n9 programmable_telescopic_cascode_0.programmable_pfet$2_0.g.n8 82.5621
R17461 programmable_telescopic_cascode_0.programmable_pfet$2_0.g.n7 programmable_telescopic_cascode_0.programmable_pfet$2_0.g.t0 25.9585
R17462 programmable_telescopic_cascode_0.programmable_pfet$2_0.g.n4 programmable_telescopic_cascode_0.programmable_pfet$2_0.g.t2 12.5098
R17463 programmable_telescopic_cascode_0.programmable_pfet$2_0.g.n1 programmable_telescopic_cascode_0.programmable_pfet$2_0.g.t3 12.5098
R17464 programmable_telescopic_cascode_0.programmable_pfet$2_0.g.n3 programmable_telescopic_cascode_0.programmable_pfet$2_0.g.t8 12.5087
R17465 programmable_telescopic_cascode_0.programmable_pfet$2_0.g.n0 programmable_telescopic_cascode_0.programmable_pfet$2_0.g.t9 12.5087
R17466 programmable_telescopic_cascode_0.programmable_pfet$2_0.g programmable_telescopic_cascode_0.programmable_pfet$2_0.g.t6 12.2496
R17467 programmable_telescopic_cascode_0.programmable_pfet$2_0.g programmable_telescopic_cascode_0.programmable_pfet$2_0.g.t4 12.2496
R17468 programmable_telescopic_cascode_0.programmable_pfet$2_0.g programmable_telescopic_cascode_0.programmable_pfet$2_0.g.t7 12.2496
R17469 programmable_telescopic_cascode_0.programmable_pfet$2_0.g programmable_telescopic_cascode_0.programmable_pfet$2_0.g.t5 12.2496
R17470 programmable_telescopic_cascode_0.programmable_pfet$2_0.g.n8 programmable_telescopic_cascode_0.programmable_pfet$2_0.g.t1 9.67857
R17471 programmable_telescopic_cascode_0.programmable_pfet$2_0.g.n7 programmable_telescopic_cascode_0.programmable_pfet$2_0.g.t10 8.77168
R17472 programmable_telescopic_cascode_0.programmable_pfet$2_0.g.n9 programmable_telescopic_cascode_0.programmable_pfet$2_0.g.n6 7.56061
R17473 programmable_telescopic_cascode_0.programmable_pfet$2_0.g.n10 programmable_telescopic_cascode_0.programmable_pfet$2_0.g.n9 6.96698
R17474 programmable_telescopic_cascode_0.programmable_pfet$2_0.g.n5 programmable_telescopic_cascode_0.programmable_pfet$2_0.g.n3 4.72668
R17475 programmable_telescopic_cascode_0.programmable_pfet$2_0.g.n2 programmable_telescopic_cascode_0.programmable_pfet$2_0.g.n0 4.72668
R17476 programmable_telescopic_cascode_0.programmable_pfet$2_0.g.n5 programmable_telescopic_cascode_0.programmable_pfet$2_0.g.n4 4.72313
R17477 programmable_telescopic_cascode_0.programmable_pfet$2_0.g.n2 programmable_telescopic_cascode_0.programmable_pfet$2_0.g.n1 4.72313
R17478 programmable_telescopic_cascode_0.programmable_pfet$2_0.g.n8 programmable_telescopic_cascode_0.programmable_pfet$2_0.g.n7 4.6673
R17479 programmable_telescopic_cascode_0.programmable_pfet$2_0.g programmable_telescopic_cascode_0.programmable_pfet$2_0.g.n5 4.63668
R17480 programmable_telescopic_cascode_0.programmable_pfet$2_0.g programmable_telescopic_cascode_0.programmable_pfet$2_0.g.n2 4.63668
R17481 programmable_telescopic_cascode_0.programmable_pfet$2_0.g.n6 programmable_telescopic_cascode_0.programmable_pfet$2_0.g 0.586684
R17482 programmable_telescopic_cascode_0.programmable_pfet$2_0.g programmable_telescopic_cascode_0.programmable_pfet$2_0.g.n10 0.586684
R17483 programmable_telescopic_cascode_0.programmable_pfet$2_0.g.n3 programmable_telescopic_cascode_0.programmable_pfet$2_0.g 0.0189337
R17484 programmable_telescopic_cascode_0.programmable_pfet$2_0.g.n0 programmable_telescopic_cascode_0.programmable_pfet$2_0.g 0.0189337
R17485 programmable_telescopic_cascode_0.programmable_pfet$2_0.g.n4 programmable_telescopic_cascode_0.programmable_pfet$2_0.g 0.0178494
R17486 programmable_telescopic_cascode_0.programmable_pfet$2_0.g.n1 programmable_telescopic_cascode_0.programmable_pfet$2_0.g 0.0178494
R17487 programmable_folded_cascode_0.programmable_nfet$3_0.transmission_gate$21_1.out.t3 programmable_folded_cascode_0.programmable_nfet$3_0.transmission_gate$21_1.out.t5 153.008
R17488 programmable_folded_cascode_0.programmable_nfet$3_0.transmission_gate$21_1.out.t4 programmable_folded_cascode_0.programmable_nfet$3_0.transmission_gate$21_1.out.t6 153.008
R17489 programmable_folded_cascode_0.programmable_nfet$3_0.transmission_gate$21_1.out.n1 programmable_folded_cascode_0.programmable_nfet$3_0.transmission_gate$21_1.out.t3 89.0163
R17490 programmable_folded_cascode_0.programmable_nfet$3_0.transmission_gate$21_1.out.n0 programmable_folded_cascode_0.programmable_nfet$3_0.transmission_gate$21_1.out.t4 89.0092
R17491 programmable_folded_cascode_0.programmable_nfet$3_0.transmission_gate$21_1.out.n0 programmable_folded_cascode_0.programmable_nfet$3_0.transmission_gate$21_1.out.t0 17.8186
R17492 programmable_folded_cascode_0.programmable_nfet$3_0.transmission_gate$21_1.out.n2 programmable_folded_cascode_0.programmable_nfet$3_0.transmission_gate$21_1.out.t2 12.3005
R17493 programmable_folded_cascode_0.programmable_nfet$3_0.transmission_gate$21_1.out programmable_folded_cascode_0.programmable_nfet$3_0.transmission_gate$21_1.out.t1 12.2669
R17494 programmable_folded_cascode_0.programmable_nfet$3_0.transmission_gate$21_1.out.n2 programmable_folded_cascode_0.programmable_nfet$3_0.transmission_gate$21_1.out.n1 5.54687
R17495 programmable_folded_cascode_0.programmable_nfet$3_0.transmission_gate$21_1.out.n1 programmable_folded_cascode_0.programmable_nfet$3_0.transmission_gate$21_1.out.n0 0.367605
R17496 programmable_folded_cascode_0.programmable_nfet$3_0.transmission_gate$21_1.out programmable_folded_cascode_0.programmable_nfet$3_0.transmission_gate$21_1.out.n2 0.2567
R17497 programmable_5tOTA_0.programmable_pfet$4_1.transmission_gate$27_0.out.t3 programmable_5tOTA_0.programmable_pfet$4_1.transmission_gate$27_0.out.t5 750.149
R17498 programmable_5tOTA_0.programmable_pfet$4_1.transmission_gate$27_0.out.t6 programmable_5tOTA_0.programmable_pfet$4_1.transmission_gate$27_0.out.t4 750.149
R17499 programmable_5tOTA_0.programmable_pfet$4_1.transmission_gate$27_0.out.n1 programmable_5tOTA_0.programmable_pfet$4_1.transmission_gate$27_0.out.t6 394.604
R17500 programmable_5tOTA_0.programmable_pfet$4_1.transmission_gate$27_0.out.n0 programmable_5tOTA_0.programmable_pfet$4_1.transmission_gate$27_0.out.t3 390.029
R17501 programmable_5tOTA_0.programmable_pfet$4_1.transmission_gate$27_0.out.n2 programmable_5tOTA_0.programmable_pfet$4_1.transmission_gate$27_0.out.n1 14.7704
R17502 programmable_5tOTA_0.programmable_pfet$4_1.transmission_gate$27_0.out.n0 programmable_5tOTA_0.programmable_pfet$4_1.transmission_gate$27_0.out.t2 13.0317
R17503 programmable_5tOTA_0.programmable_pfet$4_1.transmission_gate$27_0.out.n2 programmable_5tOTA_0.programmable_pfet$4_1.transmission_gate$27_0.out.t1 12.5327
R17504 programmable_5tOTA_0.programmable_pfet$4_1.transmission_gate$27_0.out programmable_5tOTA_0.programmable_pfet$4_1.transmission_gate$27_0.out.t0 12.2669
R17505 programmable_5tOTA_0.programmable_pfet$4_1.transmission_gate$27_0.out.n1 programmable_5tOTA_0.programmable_pfet$4_1.transmission_gate$27_0.out.n0 5.01658
R17506 programmable_5tOTA_0.programmable_pfet$4_1.transmission_gate$27_0.out programmable_5tOTA_0.programmable_pfet$4_1.transmission_gate$27_0.out.n2 0.0245
R17507 programmable_common_source_0.EN1.n5 programmable_common_source_0.EN1.n3 64.6541
R17508 programmable_common_source_0.EN1.n2 programmable_common_source_0.EN1.t3 29.9419
R17509 programmable_common_source_0.EN1 programmable_common_source_0.EN1.t4 25.0275
R17510 programmable_common_source_0.EN1.n4 programmable_common_source_0.EN1.t7 24.9469
R17511 programmable_common_source_0.EN1.n1 programmable_common_source_0.EN1.t5 24.9469
R17512 programmable_common_source_0.EN1.n0 programmable_common_source_0.EN1.t6 24.9469
R17513 programmable_common_source_0.EN1 programmable_common_source_0.EN1.t2 17.2081
R17514 programmable_common_source_0.EN1.n7 programmable_common_source_0.EN1.t0 17.1605
R17515 programmable_common_source_0.EN1.n6 programmable_common_source_0.EN1.t1 16.7833
R17516 programmable_common_source_0.EN1.n5 programmable_common_source_0.EN1.n4 15.5587
R17517 programmable_common_source_0.EN1.n3 programmable_common_source_0.EN1.n0 4.91497
R17518 programmable_common_source_0.EN1.n2 programmable_common_source_0.EN1 0.507342
R17519 programmable_common_source_0.EN1 programmable_common_source_0.EN1.n2 0.473
R17520 programmable_common_source_0.EN1.n7 programmable_common_source_0.EN1.n6 0.386214
R17521 programmable_common_source_0.EN1 programmable_common_source_0.EN1.n7 0.354071
R17522 programmable_common_source_0.EN1.n6 programmable_common_source_0.EN1 0.140321
R17523 programmable_common_source_0.EN1.n4 programmable_common_source_0.EN1 0.0721524
R17524 programmable_common_source_0.EN1 programmable_common_source_0.EN1.n5 0.0455
R17525 programmable_common_source_0.EN1.n3 programmable_common_source_0.EN1 0.023
R17526 programmable_common_source_0.EN1.n1 programmable_common_source_0.EN1 0.00642105
R17527 programmable_common_source_0.EN1 programmable_common_source_0.EN1.n1 0.00168421
R17528 programmable_common_source_0.EN1.n0 programmable_common_source_0.EN1 0.00168421
R17529 programmable_telescopic_cascode_0.programmable_nfet$4_0.transmission_gate$24_1.out.t4 programmable_telescopic_cascode_0.programmable_nfet$4_0.transmission_gate$24_1.out.t5 838.953
R17530 programmable_telescopic_cascode_0.programmable_nfet$4_0.transmission_gate$24_1.out.t7 programmable_telescopic_cascode_0.programmable_nfet$4_0.transmission_gate$24_1.out.t4 838.953
R17531 programmable_telescopic_cascode_0.programmable_nfet$4_0.transmission_gate$24_1.out.t3 programmable_telescopic_cascode_0.programmable_nfet$4_0.transmission_gate$24_1.out.t7 838.953
R17532 programmable_telescopic_cascode_0.programmable_nfet$4_0.transmission_gate$24_1.out.t6 programmable_telescopic_cascode_0.programmable_nfet$4_0.transmission_gate$24_1.out.t3 838.953
R17533 programmable_telescopic_cascode_0.programmable_nfet$4_0.transmission_gate$24_1.out.t8 programmable_telescopic_cascode_0.programmable_nfet$4_0.transmission_gate$24_1.out.t6 838.953
R17534 programmable_telescopic_cascode_0.programmable_nfet$4_0.transmission_gate$24_1.out.n0 programmable_telescopic_cascode_0.programmable_nfet$4_0.transmission_gate$24_1.out.t8 431.889
R17535 programmable_telescopic_cascode_0.programmable_nfet$4_0.transmission_gate$24_1.out.n0 programmable_telescopic_cascode_0.programmable_nfet$4_0.transmission_gate$24_1.out.t1 17.964
R17536 programmable_telescopic_cascode_0.programmable_nfet$4_0.transmission_gate$24_1.out.n1 programmable_telescopic_cascode_0.programmable_nfet$4_0.transmission_gate$24_1.out.t0 12.3005
R17537 programmable_telescopic_cascode_0.programmable_nfet$4_0.transmission_gate$24_1.out programmable_telescopic_cascode_0.programmable_nfet$4_0.transmission_gate$24_1.out.t2 12.2669
R17538 programmable_telescopic_cascode_0.programmable_nfet$4_0.transmission_gate$24_1.out.n1 programmable_telescopic_cascode_0.programmable_nfet$4_0.transmission_gate$24_1.out.n0 5.27657
R17539 programmable_telescopic_cascode_0.programmable_nfet$4_0.transmission_gate$24_1.out programmable_telescopic_cascode_0.programmable_nfet$4_0.transmission_gate$24_1.out.n1 0.256084
R17540 programmable_5tOTA_0.ena_bar<0>.n15 programmable_5tOTA_0.ena_bar<0>.n14 103.069
R17541 programmable_5tOTA_0.ena_bar<0> programmable_5tOTA_0.ena_bar<0>.t10 30.5031
R17542 programmable_5tOTA_0.ena_bar<0>.n12 programmable_5tOTA_0.ena_bar<0>.t12 25.4384
R17543 programmable_5tOTA_0.ena_bar<0>.n10 programmable_5tOTA_0.ena_bar<0>.t6 25.4378
R17544 programmable_5tOTA_0.ena_bar<0> programmable_5tOTA_0.ena_bar<0>.t7 25.0275
R17545 programmable_5tOTA_0.ena_bar<0>.n0 programmable_5tOTA_0.ena_bar<0>.t4 24.9469
R17546 programmable_5tOTA_0.ena_bar<0>.n11 programmable_5tOTA_0.ena_bar<0>.t9 24.9469
R17547 programmable_5tOTA_0.ena_bar<0>.n9 programmable_5tOTA_0.ena_bar<0>.t5 24.9469
R17548 programmable_5tOTA_0.ena_bar<0>.n5 programmable_5tOTA_0.ena_bar<0>.t11 24.9469
R17549 programmable_5tOTA_0.ena_bar<0>.n6 programmable_5tOTA_0.ena_bar<0>.t8 24.9469
R17550 programmable_5tOTA_0.ena_bar<0>.n3 programmable_5tOTA_0.ena_bar<0>.t3 24.9469
R17551 programmable_5tOTA_0.ena_bar<0> programmable_5tOTA_0.ena_bar<0>.t0 17.2081
R17552 programmable_5tOTA_0.ena_bar<0>.n2 programmable_5tOTA_0.ena_bar<0>.t2 17.1605
R17553 programmable_5tOTA_0.ena_bar<0>.n1 programmable_5tOTA_0.ena_bar<0>.t1 16.7833
R17554 programmable_5tOTA_0.ena_bar<0> programmable_5tOTA_0.ena_bar<0>.n0 15.6278
R17555 programmable_5tOTA_0.ena_bar<0>.n4 programmable_5tOTA_0.ena_bar<0> 5.54622
R17556 programmable_5tOTA_0.ena_bar<0>.n12 programmable_5tOTA_0.ena_bar<0> 5.06518
R17557 programmable_5tOTA_0.ena_bar<0>.n10 programmable_5tOTA_0.ena_bar<0> 5.06518
R17558 programmable_5tOTA_0.ena_bar<0> programmable_5tOTA_0.ena_bar<0>.n11 4.84984
R17559 programmable_5tOTA_0.ena_bar<0> programmable_5tOTA_0.ena_bar<0>.n9 4.84984
R17560 programmable_5tOTA_0.ena_bar<0>.n3 programmable_5tOTA_0.ena_bar<0> 4.84152
R17561 programmable_5tOTA_0.ena_bar<0>.n14 programmable_5tOTA_0.ena_bar<0>.n13 4.52418
R17562 programmable_5tOTA_0.ena_bar<0>.n8 programmable_5tOTA_0.ena_bar<0>.n7 4.5005
R17563 programmable_5tOTA_0.ena_bar<0>.n8 programmable_5tOTA_0.ena_bar<0>.n4 3.36366
R17564 programmable_5tOTA_0.ena_bar<0>.n14 programmable_5tOTA_0.ena_bar<0>.n8 2.543
R17565 programmable_5tOTA_0.ena_bar<0>.n4 programmable_5tOTA_0.ena_bar<0> 1.43458
R17566 programmable_5tOTA_0.ena_bar<0>.n13 programmable_5tOTA_0.ena_bar<0>.n10 1.04676
R17567 programmable_5tOTA_0.ena_bar<0>.n7 programmable_5tOTA_0.ena_bar<0> 1.03024
R17568 programmable_5tOTA_0.ena_bar<0>.n13 programmable_5tOTA_0.ena_bar<0>.n12 0.841289
R17569 programmable_5tOTA_0.ena_bar<0>.n7 programmable_5tOTA_0.ena_bar<0> 0.826864
R17570 programmable_5tOTA_0.ena_bar<0>.n2 programmable_5tOTA_0.ena_bar<0>.n1 0.386214
R17571 programmable_5tOTA_0.ena_bar<0>.n1 programmable_5tOTA_0.ena_bar<0> 0.140321
R17572 programmable_5tOTA_0.ena_bar<0>.n15 programmable_5tOTA_0.ena_bar<0>.n2 0.119429
R17573 programmable_5tOTA_0.ena_bar<0> programmable_5tOTA_0.ena_bar<0>.n15 0.0969286
R17574 programmable_5tOTA_0.ena_bar<0>.n0 programmable_5tOTA_0.ena_bar<0> 0.0721524
R17575 programmable_5tOTA_0.ena_bar<0>.n5 programmable_5tOTA_0.ena_bar<0> 0.0262143
R17576 programmable_5tOTA_0.ena_bar<0>.n6 programmable_5tOTA_0.ena_bar<0> 0.0262143
R17577 programmable_5tOTA_0.ena_bar<0>.n11 programmable_5tOTA_0.ena_bar<0> 0.00168421
R17578 programmable_5tOTA_0.ena_bar<0>.n9 programmable_5tOTA_0.ena_bar<0> 0.00168421
R17579 programmable_5tOTA_0.ena_bar<0> programmable_5tOTA_0.ena_bar<0>.n5 0.00166883
R17580 programmable_5tOTA_0.ena_bar<0> programmable_5tOTA_0.ena_bar<0>.n6 0.00166883
R17581 programmable_5tOTA_0.ena_bar<0> programmable_5tOTA_0.ena_bar<0>.n3 0.00165385
R17582 a_58284_41264.n3 a_58284_41264.n2 11.2227
R17583 a_58284_41264.n1 a_58284_41264.n0 7.07373
R17584 a_58284_41264.n2 a_58284_41264.n1 6.69059
R17585 a_58284_41264.n1 a_58284_41264.t4 6.39941
R17586 a_58284_41264.n5 a_58284_41264.t3 5.8143
R17587 a_58284_41264.n4 a_58284_41264.t6 5.22524
R17588 a_58284_41264.t0 a_58284_41264.n5 5.22168
R17589 a_58284_41264.n4 a_58284_41264.n3 5.1799
R17590 a_58284_41264.n5 a_58284_41264.n4 0.594071
R17591 a_58284_41264.n2 a_58284_41264.t7 0.545859
R17592 a_58284_41264.n3 a_58284_41264.t5 0.5405
R17593 a_58284_41264.n0 a_58284_41264.t2 0.0804024
R17594 a_58284_41264.n0 a_58284_41264.t1 0.0804024
R17595 programmable_telescopic_cascode_0.programmable_pfet$3_1.transmission_gate$23_0.out.t8 programmable_telescopic_cascode_0.programmable_pfet$3_1.transmission_gate$23_0.out.t13 604.149
R17596 programmable_telescopic_cascode_0.programmable_pfet$3_1.transmission_gate$23_0.out.t14 programmable_telescopic_cascode_0.programmable_pfet$3_1.transmission_gate$23_0.out.t8 604.149
R17597 programmable_telescopic_cascode_0.programmable_pfet$3_1.transmission_gate$23_0.out.t5 programmable_telescopic_cascode_0.programmable_pfet$3_1.transmission_gate$23_0.out.t14 604.149
R17598 programmable_telescopic_cascode_0.programmable_pfet$3_1.transmission_gate$23_0.out.t7 programmable_telescopic_cascode_0.programmable_pfet$3_1.transmission_gate$23_0.out.t5 604.149
R17599 programmable_telescopic_cascode_0.programmable_pfet$3_1.transmission_gate$23_0.out.t3 programmable_telescopic_cascode_0.programmable_pfet$3_1.transmission_gate$23_0.out.t7 604.149
R17600 programmable_telescopic_cascode_0.programmable_pfet$3_1.transmission_gate$23_0.out.t12 programmable_telescopic_cascode_0.programmable_pfet$3_1.transmission_gate$23_0.out.t4 604.149
R17601 programmable_telescopic_cascode_0.programmable_pfet$3_1.transmission_gate$23_0.out.t6 programmable_telescopic_cascode_0.programmable_pfet$3_1.transmission_gate$23_0.out.t12 604.149
R17602 programmable_telescopic_cascode_0.programmable_pfet$3_1.transmission_gate$23_0.out.t10 programmable_telescopic_cascode_0.programmable_pfet$3_1.transmission_gate$23_0.out.t6 604.149
R17603 programmable_telescopic_cascode_0.programmable_pfet$3_1.transmission_gate$23_0.out.t11 programmable_telescopic_cascode_0.programmable_pfet$3_1.transmission_gate$23_0.out.t10 604.149
R17604 programmable_telescopic_cascode_0.programmable_pfet$3_1.transmission_gate$23_0.out.t9 programmable_telescopic_cascode_0.programmable_pfet$3_1.transmission_gate$23_0.out.t11 604.149
R17605 programmable_telescopic_cascode_0.programmable_pfet$3_1.transmission_gate$23_0.out.n0 programmable_telescopic_cascode_0.programmable_pfet$3_1.transmission_gate$23_0.out.t9 316.365
R17606 programmable_telescopic_cascode_0.programmable_pfet$3_1.transmission_gate$23_0.out.n0 programmable_telescopic_cascode_0.programmable_pfet$3_1.transmission_gate$23_0.out.t3 307.156
R17607 programmable_telescopic_cascode_0.programmable_pfet$3_1.transmission_gate$23_0.out.n1 programmable_telescopic_cascode_0.programmable_pfet$3_1.transmission_gate$23_0.out.t2 22.452
R17608 programmable_telescopic_cascode_0.programmable_pfet$3_1.transmission_gate$23_0.out.n2 programmable_telescopic_cascode_0.programmable_pfet$3_1.transmission_gate$23_0.out.t1 12.5291
R17609 programmable_telescopic_cascode_0.programmable_pfet$3_1.transmission_gate$23_0.out programmable_telescopic_cascode_0.programmable_pfet$3_1.transmission_gate$23_0.out.t0 12.2669
R17610 programmable_telescopic_cascode_0.programmable_pfet$3_1.transmission_gate$23_0.out.n2 programmable_telescopic_cascode_0.programmable_pfet$3_1.transmission_gate$23_0.out.n1 10.0035
R17611 programmable_telescopic_cascode_0.programmable_pfet$3_1.transmission_gate$23_0.out.n1 programmable_telescopic_cascode_0.programmable_pfet$3_1.transmission_gate$23_0.out.n0 0.269316
R17612 programmable_telescopic_cascode_0.programmable_pfet$3_1.transmission_gate$23_0.out programmable_telescopic_cascode_0.programmable_pfet$3_1.transmission_gate$23_0.out.n2 0.0281
R17613 SCAN_OUT SCAN_OUT.t3 25.0251
R17614 SCAN_OUT.n3 SCAN_OUT.t4 24.9469
R17615 SCAN_OUT.n2 SCAN_OUT 20.9555
R17616 SCAN_OUT.n0 SCAN_OUT.t2 17.5462
R17617 SCAN_OUT.n1 SCAN_OUT.t0 16.7838
R17618 SCAN_OUT.n0 SCAN_OUT.t1 16.7833
R17619 SCAN_OUT.n2 SCAN_OUT 10.3553
R17620 SCAN_OUT.n3 SCAN_OUT.n2 5.09802
R17621 SCAN_OUT SCAN_OUT.n1 0.947107
R17622 SCAN_OUT.n1 SCAN_OUT 0.424786
R17623 SCAN_OUT SCAN_OUT.n0 0.140321
R17624 SCAN_OUT SCAN_OUT.n3 0.0751053
R17625 INP_5T.t5 INP_5T.t6 180.602
R17626 INP_5T.t4 INP_5T.t5 180.602
R17627 INP_5T.n3 INP_5T.t4 99.1125
R17628 INP_5T.n16 INP_5T.n15 14.7623
R17629 INP_5T.n22 INP_5T.n3 13.7901
R17630 INP_5T.n22 INP_5T.n21 12.9267
R17631 INP_5T INP_5T.t1 12.5271
R17632 INP_5T INP_5T.t3 12.5271
R17633 INP_5T.n1 INP_5T.t0 12.2345
R17634 INP_5T.n0 INP_5T.t2 12.2279
R17635 INP_5T.n2 INP_5T.n0 4.71086
R17636 INP_5T INP_5T.n1 4.68917
R17637 INP_5T.n17 INP_5T.n16 4.56012
R17638 INP_5T.n15 INP_5T.n14 4.50104
R17639 INP_5T.n5 INP_5T.n4 4.50065
R17640 INP_5T.n12 INP_5T.n9 4.50065
R17641 INP_5T.n3 INP_5T.n2 4.5005
R17642 INP_5T.n21 INP_5T.n20 4.5005
R17643 INP_5T.n19 INP_5T.n18 4.5005
R17644 INP_5T.n17 INP_5T.n5 4.5005
R17645 INP_5T.n10 INP_5T.n8 4.5005
R17646 INP_5T.n7 INP_5T.n6 4.5005
R17647 INP_5T.n12 INP_5T.n11 4.5005
R17648 INP_5T.n14 INP_5T.n13 4.5005
R17649 INP_5T INP_5T.n22 1.08879
R17650 INP_5T.n9 INP_5T 0.0848976
R17651 INP_5T.n21 INP_5T.n4 0.0715828
R17652 INP_5T.n18 INP_5T.n4 0.0687166
R17653 INP_5T.n18 INP_5T.n17 0.0624108
R17654 INP_5T.n13 INP_5T.n8 0.0335
R17655 INP_5T.n0 INP_5T 0.0221867
R17656 INP_5T.n14 INP_5T.n7 0.0211024
R17657 INP_5T.n11 INP_5T.n10 0.0203795
R17658 INP_5T.n1 INP_5T 0.0156807
R17659 INP_5T.n2 INP_5T 0.0113434
R17660 INP_5T.n20 INP_5T.n5 0.0098
R17661 INP_5T.n19 INP_5T.n16 0.0035
R17662 INP_5T.n10 INP_5T.n9 0.00104217
R17663 INP_5T.n11 INP_5T.n7 0.00104217
R17664 INP_5T.n20 INP_5T.n19 0.00095
R17665 INP_5T.n15 INP_5T.n6 0.00065
R17666 INP_5T.n8 INP_5T.n6 0.00065
R17667 INP_5T.n13 INP_5T.n12 0.00065
R17668 programmable_telescopic_cascode_0.programmable_pfet$2_0.transmission_gate$22_0.out.t9 programmable_telescopic_cascode_0.programmable_pfet$2_0.transmission_gate$22_0.out.t6 706.348
R17669 programmable_telescopic_cascode_0.programmable_pfet$2_0.transmission_gate$22_0.out.t10 programmable_telescopic_cascode_0.programmable_pfet$2_0.transmission_gate$22_0.out.t9 706.348
R17670 programmable_telescopic_cascode_0.programmable_pfet$2_0.transmission_gate$22_0.out.t4 programmable_telescopic_cascode_0.programmable_pfet$2_0.transmission_gate$22_0.out.t10 706.348
R17671 programmable_telescopic_cascode_0.programmable_pfet$2_0.transmission_gate$22_0.out.t8 programmable_telescopic_cascode_0.programmable_pfet$2_0.transmission_gate$22_0.out.t4 706.348
R17672 programmable_telescopic_cascode_0.programmable_pfet$2_0.transmission_gate$22_0.out.t5 programmable_telescopic_cascode_0.programmable_pfet$2_0.transmission_gate$22_0.out.t12 706.348
R17673 programmable_telescopic_cascode_0.programmable_pfet$2_0.transmission_gate$22_0.out.t7 programmable_telescopic_cascode_0.programmable_pfet$2_0.transmission_gate$22_0.out.t5 706.348
R17674 programmable_telescopic_cascode_0.programmable_pfet$2_0.transmission_gate$22_0.out.t11 programmable_telescopic_cascode_0.programmable_pfet$2_0.transmission_gate$22_0.out.t7 706.348
R17675 programmable_telescopic_cascode_0.programmable_pfet$2_0.transmission_gate$22_0.out.t3 programmable_telescopic_cascode_0.programmable_pfet$2_0.transmission_gate$22_0.out.t11 706.348
R17676 programmable_telescopic_cascode_0.programmable_pfet$2_0.transmission_gate$22_0.out.n0 programmable_telescopic_cascode_0.programmable_pfet$2_0.transmission_gate$22_0.out.t3 367.495
R17677 programmable_telescopic_cascode_0.programmable_pfet$2_0.transmission_gate$22_0.out.n0 programmable_telescopic_cascode_0.programmable_pfet$2_0.transmission_gate$22_0.out.t8 358.255
R17678 programmable_telescopic_cascode_0.programmable_pfet$2_0.transmission_gate$22_0.out.n1 programmable_telescopic_cascode_0.programmable_pfet$2_0.transmission_gate$22_0.out.t2 22.4639
R17679 programmable_telescopic_cascode_0.programmable_pfet$2_0.transmission_gate$22_0.out.n2 programmable_telescopic_cascode_0.programmable_pfet$2_0.transmission_gate$22_0.out.t1 12.5303
R17680 programmable_telescopic_cascode_0.programmable_pfet$2_0.transmission_gate$22_0.out programmable_telescopic_cascode_0.programmable_pfet$2_0.transmission_gate$22_0.out.t0 12.2669
R17681 programmable_telescopic_cascode_0.programmable_pfet$2_0.transmission_gate$22_0.out.n2 programmable_telescopic_cascode_0.programmable_pfet$2_0.transmission_gate$22_0.out.n1 10.0023
R17682 programmable_telescopic_cascode_0.programmable_pfet$2_0.transmission_gate$22_0.out.n1 programmable_telescopic_cascode_0.programmable_pfet$2_0.transmission_gate$22_0.out.n0 0.167474
R17683 programmable_telescopic_cascode_0.programmable_pfet$2_0.transmission_gate$22_0.out programmable_telescopic_cascode_0.programmable_pfet$2_0.transmission_gate$22_0.out.n2 0.0269
R17684 programmable_folded_cascode_0.programmable_pfet$1_0.transmission_gate$17_0.out.t6 programmable_folded_cascode_0.programmable_pfet$1_0.transmission_gate$17_0.out.t3 452.308
R17685 programmable_folded_cascode_0.programmable_pfet$1_0.transmission_gate$17_0.out.t4 programmable_folded_cascode_0.programmable_pfet$1_0.transmission_gate$17_0.out.t6 452.308
R17686 programmable_folded_cascode_0.programmable_pfet$1_0.transmission_gate$17_0.out.t7 programmable_folded_cascode_0.programmable_pfet$1_0.transmission_gate$17_0.out.t5 452.308
R17687 programmable_folded_cascode_0.programmable_pfet$1_0.transmission_gate$17_0.out.t5 programmable_folded_cascode_0.programmable_pfet$1_0.transmission_gate$17_0.out.t4 452.238
R17688 programmable_folded_cascode_0.programmable_pfet$1_0.transmission_gate$17_0.out.n0 programmable_folded_cascode_0.programmable_pfet$1_0.transmission_gate$17_0.out.t7 231.762
R17689 programmable_folded_cascode_0.programmable_pfet$1_0.transmission_gate$17_0.out.n0 programmable_folded_cascode_0.programmable_pfet$1_0.transmission_gate$17_0.out.t2 22.6519
R17690 programmable_folded_cascode_0.programmable_pfet$1_0.transmission_gate$17_0.out.n1 programmable_folded_cascode_0.programmable_pfet$1_0.transmission_gate$17_0.out.t1 12.5243
R17691 programmable_folded_cascode_0.programmable_pfet$1_0.transmission_gate$17_0.out programmable_folded_cascode_0.programmable_pfet$1_0.transmission_gate$17_0.out.t0 12.2669
R17692 programmable_folded_cascode_0.programmable_pfet$1_0.transmission_gate$17_0.out.n1 programmable_folded_cascode_0.programmable_pfet$1_0.transmission_gate$17_0.out.n0 10.9105
R17693 programmable_folded_cascode_0.programmable_pfet$1_0.transmission_gate$17_0.out programmable_folded_cascode_0.programmable_pfet$1_0.transmission_gate$17_0.out.n1 0.0329
R17694 INP_TELESCOPIC.n3 INP_TELESCOPIC.t4 234.008
R17695 INP_TELESCOPIC.n30 INP_TELESCOPIC.n29 15.2683
R17696 INP_TELESCOPIC.n1 INP_TELESCOPIC.t0 12.5195
R17697 INP_TELESCOPIC.n0 INP_TELESCOPIC.t3 12.5185
R17698 INP_TELESCOPIC INP_TELESCOPIC.t2 12.2496
R17699 INP_TELESCOPIC INP_TELESCOPIC.t1 12.2496
R17700 INP_TELESCOPIC.n27 INP_TELESCOPIC.n15 8.8823
R17701 INP_TELESCOPIC.n30 INP_TELESCOPIC.n3 8.04366
R17702 INP_TELESCOPIC INP_TELESCOPIC.n2 5.00142
R17703 INP_TELESCOPIC.n2 INP_TELESCOPIC.n0 4.799
R17704 INP_TELESCOPIC.n2 INP_TELESCOPIC.n1 4.7675
R17705 INP_TELESCOPIC.n18 INP_TELESCOPIC.n16 4.51471
R17706 INP_TELESCOPIC.n15 INP_TELESCOPIC.n14 4.50104
R17707 INP_TELESCOPIC.n12 INP_TELESCOPIC.n9 4.50073
R17708 INP_TELESCOPIC.n25 INP_TELESCOPIC.n17 4.50064
R17709 INP_TELESCOPIC.n29 INP_TELESCOPIC.n28 4.5005
R17710 INP_TELESCOPIC.n23 INP_TELESCOPIC.n4 4.5005
R17711 INP_TELESCOPIC.n19 INP_TELESCOPIC.n18 4.5005
R17712 INP_TELESCOPIC.n20 INP_TELESCOPIC.n5 4.5005
R17713 INP_TELESCOPIC.n22 INP_TELESCOPIC.n21 4.5005
R17714 INP_TELESCOPIC.n27 INP_TELESCOPIC.n26 4.5005
R17715 INP_TELESCOPIC.n25 INP_TELESCOPIC.n24 4.5005
R17716 INP_TELESCOPIC.n10 INP_TELESCOPIC.n8 4.5005
R17717 INP_TELESCOPIC.n7 INP_TELESCOPIC.n6 4.5005
R17718 INP_TELESCOPIC.n12 INP_TELESCOPIC.n11 4.5005
R17719 INP_TELESCOPIC.n14 INP_TELESCOPIC.n13 4.5005
R17720 INP_TELESCOPIC.n3 INP_TELESCOPIC 0.259842
R17721 INP_TELESCOPIC.n9 INP_TELESCOPIC 0.0530904
R17722 INP_TELESCOPIC.n13 INP_TELESCOPIC.n8 0.0501241
R17723 INP_TELESCOPIC.n24 INP_TELESCOPIC.n5 0.0372669
R17724 INP_TELESCOPIC.n22 INP_TELESCOPIC.n17 0.0280188
R17725 INP_TELESCOPIC.n14 INP_TELESCOPIC.n7 0.0211024
R17726 INP_TELESCOPIC.n11 INP_TELESCOPIC.n10 0.0203795
R17727 INP_TELESCOPIC.n20 INP_TELESCOPIC.n19 0.0174462
R17728 INP_TELESCOPIC.n26 INP_TELESCOPIC.n16 0.0167342
R17729 INP_TELESCOPIC.n23 INP_TELESCOPIC.n22 0.0147105
R17730 INP_TELESCOPIC.n28 INP_TELESCOPIC.n5 0.0147105
R17731 INP_TELESCOPIC.n0 INP_TELESCOPIC 0.0091747
R17732 INP_TELESCOPIC.n1 INP_TELESCOPIC 0.00809036
R17733 INP_TELESCOPIC INP_TELESCOPIC.n30 0.00405263
R17734 INP_TELESCOPIC.n18 INP_TELESCOPIC.n17 0.00117669
R17735 INP_TELESCOPIC.n24 INP_TELESCOPIC.n23 0.00117669
R17736 INP_TELESCOPIC.n28 INP_TELESCOPIC.n27 0.00117669
R17737 INP_TELESCOPIC.n29 INP_TELESCOPIC.n4 0.00106962
R17738 INP_TELESCOPIC.n21 INP_TELESCOPIC.n20 0.00106962
R17739 INP_TELESCOPIC.n26 INP_TELESCOPIC.n25 0.00106962
R17740 INP_TELESCOPIC.n10 INP_TELESCOPIC.n9 0.00104217
R17741 INP_TELESCOPIC.n11 INP_TELESCOPIC.n7 0.00104217
R17742 INP_TELESCOPIC.n15 INP_TELESCOPIC.n6 0.000725564
R17743 INP_TELESCOPIC.n8 INP_TELESCOPIC.n6 0.000725564
R17744 INP_TELESCOPIC.n13 INP_TELESCOPIC.n12 0.000725564
R17745 INP_TELESCOPIC.n19 INP_TELESCOPIC.n4 0.000642405
R17746 INP_TELESCOPIC.n21 INP_TELESCOPIC.n16 0.000642405
R17747 SCAN_IN SCAN_IN.t2 30.4906
R17748 SCAN_IN SCAN_IN.t0 25.0251
R17749 SCAN_IN.n2 SCAN_IN.t3 25.0227
R17750 SCAN_IN.n0 SCAN_IN.t1 24.9469
R17751 SCAN_IN.n1 SCAN_IN 6.83036
R17752 SCAN_IN.n1 SCAN_IN.n0 5.60427
R17753 SCAN_IN SCAN_IN.n2 5.12246
R17754 SCAN_IN SCAN_IN.n1 0.46175
R17755 SCAN_IN.n0 SCAN_IN 0.0751053
R17756 SCAN_IN.n2 SCAN_IN 0.00878947
C0 scan_chain_0.D_ff1_8.D_latch1$1_1.NAND2$2_0.A a_25797_79808# 0.00428f
C1 transmission_gate$2$1_4.out VDD 5.38972f
C2 a_24313_79067# transmission_gate$2$1_7.ena 0
C3 programmable_common_source_0.EN1 a_62818_79808# 0.0043f
C4 programmable_5tOTA_0.ena_bar<0> a_60456_79808# 0
C5 programmable_common_source_0.EN0 a_56600_79067# 0
C6 programmable_folded_cascode_0.EN1 transmission_gate$2$1_7.ena 0.08725f
C7 transmission_gate$2$1_3.out a_45053_79067# 0.0203f
C8 programmable_telescopic_cascode_0.programmable_nfet$5_0.transmission_gate$25_1.out programmable_telescopic_cascode_0.programmable_nfet$6_0.d 0.41713f
C9 programmable_telescopic_cascode_0.EN0 programmable_telescopic_cascode_0.programmable_nfet$4_1.transmission_gate$24_1.out 0.0434f
C10 transmission_gate$2$1_5.out programmable_telescopic_cascode_0.programmable_nfet$5_1.transmission_gate$25_1.out 0.62605f
C11 programmable_common_source_0.EN0 scan_chain_0.D_ff1_4.D_latch1$1_1.inv1$3_0.Y 0.31833f
C12 a_16612_79808# scan_chain_0.D_ff1_7.D_latch1$1_0.D 0
C13 VDD INP_5T 29.4801f
C14 transmission_gate$2$1_2.out a_58972_79067# 0
C15 programmable_folded_cascode_0.programmable_nfet$1_0.g VDD 18.1006f
C16 programmable_telescopic_cascode_0.programmable_pfet$3_1.d OUT_TELESCOPIC 55.258f
C17 scan_chain_0.D_ff1_7.inv1$4_0.Y programmable_telescopic_cascode_0.programmable_pfet$3_1.transmission_gate$23_1.out 0
C18 transmission_gate$2$1_7.out a_6548_79067# 0.02983f
C19 a_20467_79067# a_21950_79067# 0.00361f
C20 programmable_telescopic_cascode_0.programmable_nfet$4_0.s programmable_folded_cascode_0.OUT 0.16191f
C21 programmable_5tOTA_0.ena_bar<0> scan_chain_0.D_ff1_0.D_latch1$1_1.NAND2$2_2.B 0.04205f
C22 VDD IN_CS 16.2845f
C23 programmable_5tOTA_0.ena_bar<0> programmable_5tOTA_0.programmable_pfet$4_0.transmission_gate$27_1.out 0.00694f
C24 programmable_telescopic_cascode_0.programmable_nfet$4_1.transmission_gate$24_1.out INN_TELESCOPIC 0.01884f
C25 scan_chain_0.D_ff1_2.inv1$4_0.Y VDD 0.91784f
C26 scan_chain_0.D_ff1_6.D_latch1$1_0.NAND2$2_2.B transmission_gate$2$1_7.ena 0
C27 scan_chain_0.D_ff1_2.D_latch1$1_1.NAND2$2_0.A VDD 0.76162f
C28 transmission_gate$2$1_3.out a_39715_79808# 0.00787f
C29 scan_chain_0.D_ff1_8.D_latch1$1_1.Q_bar CLK 0.00483f
C30 a_1210_79067# CLK 0.00476f
C31 transmission_gate$2$1_2.out scan_chain_0.D_ff1_3.D_latch1$1_1.NAND2$2_2.B 0.00216f
C32 a_51271_79067# a_52754_79067# 0.00361f
C33 a_55117_79067# VDD 0.00984f
C34 programmable_5tOTA_0.ena_bar<1> a_56601_79808# 0.01415f
C35 a_41199_79808# scan_chain_0.D_ff1_2.D_latch1$1_1.Q_bar 0.01093f
C36 a_24313_79808# VDD 0.01643f
C37 programmable_folded_cascode_0.programmable_nfet$3_0.g INP_5T 0.0555f
C38 programmable_folded_cascode_0.EN1 programmable_folded_cascode_0.programmable_nfet_0.transmission_gate$18_1.out 0.05069f
C39 programmable_5tOTA_0.ena_bar<0> scan_chain_0.D_ff1_4.D_latch1$1_1.inv1$3_0.Y 0.03316f
C40 scan_chain_0.D_ff1_2.D_latch1$1_0.NAND2$2_0.A scan_chain_0.D_ff1_2.D_latch1$1_0.inv1$3_0.Y 0
C41 programmable_5tOTA_0.programmable_pfet$4_0.g VDD 42.466f
C42 transmission_gate$2$1_6.out programmable_folded_cascode_0.programmable_pfet$1_1.transmission_gate$17_1.out 1.05984f
C43 programmable_common_source_0.EN0 IN_CS 0.1266f
C44 programmable_telescopic_cascode_0.programmable_pfet$3_0.d VDD 0.19916p
C45 scan_chain_0.D_ff1_6.inv1$4_0.Y transmission_gate$2$1_7.ena 0.00353f
C46 scan_chain_0.D_ff1_5.D_latch1$1_0.inv1$3_0.Y transmission_gate$2$1_7.ena 0
C47 transmission_gate$2$1_5.out programmable_telescopic_cascode_0.programmable_nfet$6_0.transmission_gate$26_1.out 0.61553f
C48 programmable_5tOTA_0.ena_bar<1> a_64301_79067# 0
C49 a_68156_79067# SCAN_OUT 0.0296f
C50 scan_chain_0.D_ff1_3.D_latch1$1_0.NAND2$2_0.A a_52754_79067# 0
C51 scan_chain_0.D_ff1_3.inv1$4_0.Y scan_chain_0.D_ff1_3.D_latch1$1_0.NAND2$2_2.B 0.40095f
C52 transmission_gate$2$1_7.out programmable_telescopic_cascode_0.programmable_nfet$4_0.transmission_gate$24_0.out 0.02118f
C53 programmable_telescopic_cascode_0.programmable_nfet$5_1.d INN_FOLDED 0.15799f
C54 a_48899_79067# PROG_ENA 0
C55 scan_chain_0.D_ff1_3.D_latch1$1_0.D a_48899_79067# 0.02982f
C56 a_62818_79067# CLK 0.00479f
C57 programmable_folded_cascode_0.programmable_pfet$1_1.transmission_gate$17_1.out programmable_folded_cascode_0.programmable_nfet_1.transmission_gate$18_0.out 0.04579f
C58 programmable_telescopic_cascode_0.programmable_pfet$2_0.transmission_gate$22_1.out INN_FOLDED 0.02583f
C59 programmable_telescopic_cascode_0.programmable_pfet$2_1.transmission_gate$22_0.out programmable_telescopic_cascode_0.programmable_pfet$2_0.transmission_gate$22_1.out 0.02153f
C60 VDD PROG_ENA 4.99725f
C61 scan_chain_0.D_ff1_3.D_latch1$1_0.D VDD 1.54258f
C62 programmable_telescopic_cascode_0.EN1 scan_chain_0.D_ff1_1.inv1$4_0.Y 0
C63 programmable_5tOTA_0.programmable_pfet$4_1.transmission_gate$27_0.out VDD 4.04998f
C64 programmable_folded_cascode_0.EN1 INP_FOLDED 0.00785f
C65 programmable_telescopic_cascode_0.EN1 scan_chain_0.D_ff1_1.D_latch1$1_1.NAND2$2_0.A 0
C66 scan_chain_0.D_ff1_2.D_latch1$1_1.Q_bar scan_chain_0.D_ff1_2.D_latch1$1_1.NAND2$2_2.B 0.13783f
C67 programmable_folded_cascode_0.EN0 programmable_folded_cascode_0.programmable_pfet_0.transmission_gate$16_1.out 0.08186f
C68 transmission_gate$2$1_6.out programmable_telescopic_cascode_0.programmable_pfet$2_0.transmission_gate$22_0.out 0.01014f
C69 scan_chain_0.D_ff1_5.D_latch1$1_0.D a_5065_79067# 0
C70 programmable_5tOTA_0.programmable_nfet$7_1.transmission_gate$28_0.out INN_5T 0
C71 programmable_common_source_0.EN0 a_55117_79067# 0
C72 scan_chain_0.D_ff1_2.D_latch1$1_0.NAND2$2_2.B VDD 1.04703f
C73 transmission_gate$2$1_3.out a_43570_79067# 0.02046f
C74 transmission_gate$2$1_3.out scan_chain_0.D_ff1_0.D_latch1$1_0.NAND2$2_0.A 0.00107f
C75 scan_chain_0.D_ff1_6.D_latch1$1_0.inv1$3_0.Y a_10394_79067# 0
C76 scan_chain_0.D_ff1_7.inv1$4_0.Y CLK 0.32366f
C77 scan_chain_0.D_ff1_7.D_latch1$1_1.NAND2$2_0.A CLK 0.22611f
C78 scan_chain_0.D_ff1_1.D_latch1$1_0.NAND2$2_0.A scan_chain_0.D_ff1_1.D_latch1$1_0.NAND2$2_2.B 0.01576f
C79 programmable_folded_cascode_0.OUT programmable_folded_cascode_0.programmable_nfet_0.transmission_gate$18_0.out 0.02497f
C80 transmission_gate$2$1_5.out programmable_telescopic_cascode_0.programmable_pfet$3_0.transmission_gate$23_0.out 0.04076f
C81 scan_chain_0.D_ff1_1.D_latch1$1_1.NAND2$2_0.A a_33497_79067# 0
C82 programmable_common_source_0.EN0 VDD 5.85918f
C83 scan_chain_0.D_ff1_1.D_latch1$1_0.D scan_chain_0.D_ff1_1.D_latch1$1_1.NAND2$2_2.B 0.01594f
C84 programmable_folded_cascode_0.EN0 transmission_gate$2$1_4.out 0.70738f
C85 scan_chain_0.D_ff1_4.D_latch1$1_0.NAND2$2_0.A SCAN_OUT 0.01794f
C86 scan_chain_0.D_ff1_3.D_latch1$1_0.NAND2$2_2.B CLK 0.00592f
C87 transmission_gate$2$1_3.out programmable_5tOTA_0.programmable_pfet$4_1.transmission_gate$27_1.out 1.02363f
C88 scan_chain_0.D_ff1_0.D_latch1$1_1.Q_bar VDD 0.89034f
C89 a_43570_79808# VDD 0.00189f
C90 transmission_gate$2$1_6.out programmable_folded_cascode_0.programmable_nfet$1_1.transmission_gate$19_1.out 0.35984f
C91 programmable_folded_cascode_0.EN1 a_16612_79067# 0
C92 programmable_common_source_0.EN0 PROG_ENA 0.19874f
C93 transmission_gate$2$1_6.out scan_chain_0.D_ff1_7.D_latch1$1_1.NAND2$2_2.B 0.00299f
C94 scan_chain_0.D_ff1_2.D_latch1$1_0.inv1$3_0.Y a_41198_79067# 0
C95 scan_chain_0.D_ff1_3.D_latch1$1_1.NAND2$2_0.A scan_chain_0.D_ff1_3.D_latch1$1_1.Q_bar 0.02095f
C96 scan_chain_0.D_ff1_8.D_latch1$1_0.D scan_chain_0.D_ff1_8.D_latch1$1_0.inv1$3_0.Y 0.29948f
C97 scan_chain_0.D_ff1_1.D_latch1$1_0.inv1$3_0.Y VDD 0.38506f
C98 programmable_common_source_0.EN0 scan_chain_0.D_ff1_0.Q_bar 0.00279f
C99 scan_chain_0.D_ff1_1.D_latch1$1_1.Q_bar a_35869_79067# 0
C100 programmable_telescopic_cascode_0.programmable_nfet$4_0.g programmable_telescopic_cascode_0.programmable_nfet$5_1.d 3.99335f
C101 programmable_folded_cascode_0.EN0 INP_5T 0.58878f
C102 transmission_gate$2$1_7.out programmable_telescopic_cascode_0.programmable_nfet$5_0.transmission_gate$25_0.out 0.0237f
C103 programmable_folded_cascode_0.EN0 programmable_folded_cascode_0.programmable_nfet$1_0.g 0.06587f
C104 programmable_5tOTA_0.programmable_nfet$7_1.transmission_gate$28_1.out programmable_5tOTA_0.programmable_nfet$7_1.transmission_gate$28_0.out 0.00448f
C105 scan_chain_0.D_ff1_6.D_latch1$1_0.NAND2$2_0.A scan_chain_0.D_ff1_6.D_latch1$1_0.inv1$3_0.Y 0
C106 programmable_folded_cascode_0.programmable_nfet_1.transmission_gate$18_1.out programmable_folded_cascode_0.programmable_nfet$1_1.transmission_gate$19_0.out 0.06918f
C107 programmable_telescopic_cascode_0.EN1 scan_chain_0.D_ff1_2.D_latch1$1_0.D 0
C108 transmission_gate$2$1_2.out programmable_5tOTA_0.programmable_nfet$7_1.transmission_gate$28_0.out 0.22071f
C109 transmission_gate$2$1_2.out scan_chain_0.D_ff1_0.inv1$4_0.Y 0.00229f
C110 programmable_telescopic_cascode_0.programmable_pfet$2_0.transmission_gate$22_0.out programmable_telescopic_cascode_0.programmable_nfet$4_1.transmission_gate$24_1.out 0.10808f
C111 programmable_telescopic_cascode_0.programmable_pfet$2_0.g programmable_telescopic_cascode_0.programmable_nfet$4_0.transmission_gate$24_1.out 0.01951f
C112 a_25797_79808# CLK 0
C113 transmission_gate$2$1_2.out scan_chain_0.D_ff1_0.D_latch1$1_1.NAND2$2_0.A 0.0131f
C114 programmable_common_source_0.EN0 programmable_common_source_0.EN0 4.60273f
C115 programmable_folded_cascode_0.EN1 programmable_folded_cascode_0.programmable_nfet$3_0.transmission_gate$21_1.out 0.05728f
C116 programmable_folded_cascode_0.programmable_nfet$2_0.g programmable_folded_cascode_0.programmable_nfet$1_0.g 3.7694f
C117 scan_chain_0.D_ff1_2.D_latch1$1_0.inv1$3_0.Y CLK 0.00358f
C118 programmable_folded_cascode_0.programmable_pfet_0.g programmable_folded_cascode_0.programmable_pfet_0.transmission_gate$16_0.out 0.58282f
C119 programmable_folded_cascode_0.programmable_nfet$2_0.g INP_5T 0.05378f
C120 programmable_5tOTA_0.ena_bar<0> a_48899_79067# 0.0119f
C121 scan_chain_0.D_ff1_8.D_latch1$1_1.Q_bar scan_chain_0.D_ff1_8.D_latch1$1_0.NAND2$2_2.B 0.00216f
C122 programmable_folded_cascode_0.programmable_pfet$1_0.g programmable_folded_cascode_0.programmable_nfet$1_0.g 2.79311f
C123 programmable_common_source_0.EN0 scan_chain_0.D_ff1_0.D_latch1$1_1.Q_bar 0
C124 programmable_5tOTA_0.ena_bar<0> VDD 7.00986f
C125 scan_chain_0.D_ff1_7.D_latch1$1_0.NAND2$2_0.A programmable_telescopic_cascode_0.EN0 0.02095f
C126 programmable_folded_cascode_0.programmable_pfet$1_0.g INP_5T 0.14312f
C127 scan_chain_0.D_ff1_6.D_latch1$1_1.Q_bar scan_chain_0.D_ff1_6.D_latch1$1_1.NAND2$2_2.B 0.13783f
C128 a_66673_79067# SCAN_OUT 0
C129 programmable_telescopic_cascode_0.programmable_nfet$5_0.transmission_gate$25_0.out programmable_telescopic_cascode_0.programmable_nfet$6_0.transmission_gate$26_0.out 0
C130 programmable_5tOTA_0.ena_bar<1> a_62818_79067# 0
C131 scan_chain_0.D_ff1_3.D_latch1$1_0.NAND2$2_0.A a_51271_79067# 0.02432f
C132 scan_chain_0.D_ff1_3.D_latch1$1_1.Q_bar CLK 0.00483f
C133 a_47416_79067# PROG_ENA 0
C134 transmission_gate$2$1_7.out programmable_telescopic_cascode_0.programmable_pfet$3_0.transmission_gate$23_1.out 0.00764f
C135 programmable_common_source_0.EN1 scan_chain_0.D_ff1_0.D_latch1$1_0.NAND2$2_2.B 0
C136 a_47416_79808# VDD 0.00189f
C137 programmable_5tOTA_0.ena_bar<0> scan_chain_0.D_ff1_0.Q_bar 0.02281f
C138 programmable_telescopic_cascode_0.EN0 VDD 5.87889f
C139 programmable_folded_cascode_0.EN0 programmable_telescopic_cascode_0.programmable_pfet$3_0.d 0.03725f
C140 transmission_gate$2$1_7.out programmable_telescopic_cascode_0.programmable_pfet$3_1.d 0.08849f
C141 a_60455_79067# transmission_gate$2$1_7.ena 0
C142 programmable_common_source_0.EN0 scan_chain_0.D_ff1_0.D_latch1$1_0.D 0.00305f
C143 programmable_folded_cascode_0.programmable_nfet$1_1.transmission_gate$19_1.out programmable_folded_cascode_0.programmable_nfet$2_1.transmission_gate$20_0.out 0.06405f
C144 scan_chain_0.D_ff1_4.D_latch1$1_0.inv1$3_0.Y SCAN_OUT 0.01316f
C145 programmable_5tOTA_0.ena_bar<0> programmable_common_source_0.EN0 0.09451f
C146 transmission_gate$2$1_2.out OUT_CS 0.1312f
C147 programmable_folded_cascode_0.EN0 PROG_ENA 0.08264f
C148 programmable_5tOTA_0.ena_bar<1> scan_chain_0.D_ff1_3.D_latch1$1_0.NAND2$2_2.B 0
C149 VDD INN_TELESCOPIC 17.1357f
C150 scan_chain_0.D_ff1_1.D_latch1$1_1.NAND2$2_0.A a_32014_79067# 0.02432f
C151 scan_chain_0.D_ff1_1.D_latch1$1_0.NAND2$2_2.B PROG_ENA 0.00233f
C152 programmable_folded_cascode_0.programmable_pfet_0.g programmable_folded_cascode_0.OUT 0.15739f
C153 transmission_gate$2$1_5.out programmable_telescopic_cascode_0.programmable_pfet$3_0.g 1.19262f
C154 scan_chain_0.D_ff1_0.D_latch1$1_0.D scan_chain_0.D_ff1_0.D_latch1$1_1.Q_bar 1.69947f
C155 scan_chain_0.D_ff1_1.D_latch1$1_0.D transmission_gate$2$1_7.ena 0
C156 a_52755_79808# PROG_ENA 0
C157 a_64302_79808# VDD 0.00336f
C158 scan_chain_0.D_ff1_3.D_latch1$1_1.NAND2$2_0.A a_48900_79808# 0.00428f
C159 scan_chain_0.D_ff1_8.D_latch1$1_1.NAND2$2_0.A scan_chain_0.D_ff1_8.D_latch1$1_1.NAND2$2_2.B 0.01576f
C160 transmission_gate$2$1_6.out INP_TELESCOPIC 0.01067f
C161 programmable_common_source_0.EN0 programmable_common_source_0.programmable_nfet$9_0.transmission_gate$31_1.out 0.22962f
C162 a_29651_79067# VDD 0.01449f
C163 programmable_common_source_0.EN0 a_68157_79808# 0
C164 scan_chain_0.D_ff1_5.D_latch1$1_0.inv1$3_0.Y scan_chain_0.D_ff1_5.D_latch1$1_0.NAND2$2_2.B 0.44289f
C165 a_10395_79808# scan_chain_0.D_ff1_6.D_latch1$1_1.Q_bar 0.01093f
C166 scan_chain_0.D_ff1_7.inv1$4_0.Y scan_chain_0.D_ff1_7.D_latch1$1_0.inv1$3_0.Y 0.00878f
C167 IBIAS INP_TELESCOPIC 0.32989f
C168 transmission_gate$2$1_4.out programmable_telescopic_cascode_0.programmable_nfet$6_0.d 0.01001f
C169 transmission_gate$2$1_2.out a_66673_79808# 0
C170 programmable_telescopic_cascode_0.programmable_pfet$3_0.g programmable_telescopic_cascode_0.programmable_nfet$5_1.transmission_gate$25_1.out 0
C171 programmable_common_source_0.EN0 a_52755_79808# 0.16273f
C172 transmission_gate$2$1_3.out transmission_gate$2$1_7.ena 0.01311f
C173 scan_chain_0.D_ff1_7.D_latch1$1_1.Q_bar transmission_gate$2$1_7.ena 0
C174 scan_chain_0.D_ff1_8.D_latch1$1_0.inv1$3_0.Y PROG_ENA 0.00134f
C175 a_37352_79067# CLK 0
C176 programmable_5tOTA_0.ena_bar<0> a_47416_79067# 0.0119f
C177 programmable_5tOTA_0.ena_bar<0> scan_chain_0.D_ff1_0.D_latch1$1_0.D 0.04933f
C178 transmission_gate$2$1_7.ena programmable_telescopic_cascode_0.programmable_pfet$2_1.transmission_gate$22_0.out 0
C179 a_37353_79808# VDD 0.02273f
C180 scan_chain_0.D_ff1_8.inv1$4_0.Y programmable_telescopic_cascode_0.programmable_pfet$2_1.transmission_gate$22_1.out 0
C181 programmable_telescopic_cascode_0.programmable_nfet$4_1.transmission_gate$24_0.out CLK 0
C182 scan_chain_0.D_ff1_7.D_latch1$1_0.NAND2$2_0.A a_21951_79808# 0.00428f
C183 programmable_5tOTA_0.ena_bar<1> scan_chain_0.D_ff1_3.D_latch1$1_1.Q_bar 0.03071f
C184 a_48900_79808# CLK 0
C185 scan_chain_0.D_ff1_1.D_latch1$1_0.inv1$3_0.Y scan_chain_0.D_ff1_1.D_latch1$1_0.NAND2$2_2.B 0.44289f
C186 programmable_telescopic_cascode_0.EN1 programmable_telescopic_cascode_0.programmable_nfet$5_1.d 0
C187 a_47416_79808# a_47416_79067# 0
C188 a_55117_79808# scan_chain_0.D_ff1_4.D_latch1$1_0.D 0
C189 programmable_telescopic_cascode_0.programmable_pfet$2_1.transmission_gate$22_1.out programmable_telescopic_cascode_0.programmable_pfet$3_1.d 3.23139f
C190 programmable_common_source_0.EN1 a_64301_79067# 0
C191 scan_chain_0.D_ff1_0.D_latch1$1_0.NAND2$2_0.A scan_chain_0.D_ff1_0.inv1$4_0.Y 0.22611f
C192 scan_chain_0.D_ff1_7.D_latch1$1_1.Q_bar a_18095_79067# 0.16279f
C193 transmission_gate$2$1_7.out programmable_telescopic_cascode_0.programmable_pfet$3_1.transmission_gate$23_1.out 0.00903f
C194 scan_chain_0.D_ff1_5.inv1$4_0.Y PROG_ENA 0.44521f
C195 programmable_telescopic_cascode_0.EN1 programmable_telescopic_cascode_0.programmable_pfet$2_0.transmission_gate$22_1.out 0.00662f
C196 scan_chain_0.D_ff1_5.D_latch1$1_1.NAND2$2_0.A PROG_ENA 0.00118f
C197 transmission_gate$2$1_4.out programmable_telescopic_cascode_0.programmable_nfet$4_0.transmission_gate$24_1.out 0.05398f
C198 programmable_5tOTA_0.ena_bar<0> a_68157_79808# 0
C199 programmable_common_source_0.EN1 scan_chain_0.D_ff1_0.D_latch1$1_1.inv1$3_0.Y 0.31248f
C200 a_21951_79808# VDD 0.00879f
C201 programmable_5tOTA_0.ena_bar<0> scan_chain_0.D_ff1_1.D_latch1$1_0.NAND2$2_2.B 0.14028f
C202 programmable_folded_cascode_0.programmable_pfet$1_1.transmission_gate$17_1.out VDD 2.41506f
C203 programmable_5tOTA_0.ena_bar<0> a_52755_79808# 0
C204 a_58972_79067# transmission_gate$2$1_7.ena 0
C205 scan_chain_0.D_ff1_0.D_latch1$1_0.inv1$3_0.Y a_66673_79067# 0.00457f
C206 a_6549_79808# PROG_ENA 0
C207 programmable_telescopic_cascode_0.programmable_nfet$4_0.transmission_gate$24_1.out INP_5T 0.02415f
C208 programmable_folded_cascode_0.programmable_nfet_0.transmission_gate$18_1.out INN_FOLDED 0.2312f
C209 programmable_folded_cascode_0.EN0 programmable_telescopic_cascode_0.EN0 0.0563f
C210 transmission_gate$2$1_7.ena programmable_telescopic_cascode_0.programmable_nfet$4_0.g 0
C211 scan_chain_0.D_ff1_0.D_latch1$1_0.D a_64302_79808# 0.16273f
C212 programmable_telescopic_cascode_0.programmable_nfet$4_0.transmission_gate$24_0.out programmable_folded_cascode_0.OUT 0.04251f
C213 programmable_telescopic_cascode_0.EN0 scan_chain_0.D_ff1_1.D_latch1$1_0.NAND2$2_2.B 0
C214 programmable_telescopic_cascode_0.programmable_nfet$5_1.d programmable_telescopic_cascode_0.programmable_nfet$4_0.s 0.66529f
C215 transmission_gate$2$1_6.out programmable_folded_cascode_0.programmable_nfet$3_0.transmission_gate$21_0.out 0.00652f
C216 scan_chain_0.D_ff1_5.D_latch1$1_0.D CLK 0.00906f
C217 scan_chain_0.D_ff1_5.D_latch1$1_1.NAND2$2_2.B a_2693_79067# 0.00415f
C218 a_28168_79067# VDD 0.02455f
C219 programmable_telescopic_cascode_0.programmable_pfet$2_0.transmission_gate$22_0.out VDD 3.53904f
C220 scan_chain_0.D_ff1_3.D_latch1$1_1.NAND2$2_2.B transmission_gate$2$1_7.ena 0
C221 transmission_gate$2$1_5.out a_24313_79067# 0
C222 programmable_folded_cascode_0.EN0 INN_TELESCOPIC 0.03012f
C223 programmable_telescopic_cascode_0.EN1 scan_chain_0.D_ff1_1.D_latch1$1_1.NAND2$2_2.B 0.00233f
C224 programmable_folded_cascode_0.EN1 transmission_gate$2$1_5.out 0
C225 transmission_gate$2$1_3.out a_68156_79067# 0.02046f
C226 scan_chain_0.D_ff1_4.inv1$4_0.Y scan_chain_0.D_ff1_4.D_latch1$1_0.NAND2$2_2.B 0.40095f
C227 transmission_gate$2$1_4.out programmable_telescopic_cascode_0.programmable_nfet$5_0.transmission_gate$25_1.out 0.05252f
C228 scan_chain_0.D_ff1_4.D_latch1$1_0.NAND2$2_0.A a_60455_79067# 0
C229 a_21950_79067# PROG_ENA 0
C230 a_35869_79067# CLK 0.00111f
C231 programmable_telescopic_cascode_0.programmable_pfet$3_0.g programmable_telescopic_cascode_0.programmable_pfet$3_0.transmission_gate$23_0.out 0.25976f
C232 transmission_gate$2$1_7.out CLK 0.11156f
C233 scan_chain_0.D_ff1_4.D_latch1$1_0.D a_56600_79067# 0.02982f
C234 programmable_5tOTA_0.ena_bar<1> a_48900_79808# 0.01415f
C235 programmable_telescopic_cascode_0.EN0 scan_chain_0.D_ff1_8.D_latch1$1_0.inv1$3_0.Y 0
C236 scan_chain_0.D_ff1_1.D_latch1$1_1.NAND2$2_2.B a_33497_79067# 0.00415f
C237 programmable_folded_cascode_0.programmable_nfet$1_1.transmission_gate$19_1.out VDD 0.23181f
C238 a_18096_79808# a_18095_79067# 0
C239 scan_chain_0.D_ff1_7.D_latch1$1_1.NAND2$2_2.B VDD 1.11711f
C240 programmable_folded_cascode_0.programmable_nfet_1.transmission_gate$18_1.out INP_FOLDED 0.2116f
C241 scan_chain_0.D_ff1_0.D_latch1$1_0.NAND2$2_0.A a_66673_79808# 0.23035f
C242 programmable_common_source_0.EN1 a_62818_79067# 0
C243 programmable_folded_cascode_0.EN1 programmable_telescopic_cascode_0.programmable_nfet$5_1.transmission_gate$25_1.out 0.0137f
C244 scan_chain_0.D_ff1_2.D_latch1$1_1.inv1$3_0.Y transmission_gate$2$1_7.ena 0
C245 programmable_telescopic_cascode_0.programmable_nfet$4_0.transmission_gate$24_1.out PROG_ENA 0
C246 transmission_gate$2$1_4.out programmable_telescopic_cascode_0.programmable_pfet$3_1.transmission_gate$23_0.out 1.10067f
C247 scan_chain_0.D_ff1_0.D_latch1$1_1.NAND2$2_2.B a_64301_79067# 0.00415f
C248 scan_chain_0.D_ff1_8.D_latch1$1_1.NAND2$2_2.B CLK 0.40703f
C249 transmission_gate$2$1_3.out scan_chain_0.D_ff1_4.D_latch1$1_0.NAND2$2_0.A 0.00107f
C250 programmable_telescopic_cascode_0.programmable_nfet$4_0.g INP_FOLDED 0.26445f
C251 scan_chain_0.D_ff1_6.D_latch1$1_1.inv1$3_0.Y VDD 0.43863f
C252 a_62818_79808# a_64302_79808# 0.00361f
C253 programmable_telescopic_cascode_0.programmable_pfet$3_1.transmission_gate$23_0.out INP_5T 0.06326f
C254 transmission_gate$2$1_6.out scan_chain_0.D_ff1_7.D_latch1$1_1.NAND2$2_0.A 0.44675f
C255 programmable_5tOTA_0.programmable_nfet$8_0.transmission_gate$29_1.out INN_5T 0
C256 transmission_gate$2$1_6.out programmable_folded_cascode_0.programmable_nfet$2_0.transmission_gate$20_0.out 0.00672f
C257 programmable_telescopic_cascode_0.programmable_pfet$3_0.transmission_gate$23_1.out programmable_folded_cascode_0.OUT 0.02613f
C258 a_1210_79808# CLK 0.00415f
C259 programmable_folded_cascode_0.EN0 programmable_folded_cascode_0.programmable_pfet$1_1.transmission_gate$17_1.out 0.02104f
C260 scan_chain_0.D_ff1_4.D_latch1$1_1.Q_bar VDD 0.88625f
C261 scan_chain_0.D_ff1_7.D_latch1$1_1.inv1$3_0.Y CLK 0.02415f
C262 scan_chain_0.D_ff1_5.D_latch1$1_1.NAND2$2_2.B a_1210_79067# 0.16593f
C263 programmable_telescopic_cascode_0.programmable_pfet$2_1.transmission_gate$22_1.out CLK 0
C264 scan_chain_0.D_ff1_1.inv1$4_0.Y programmable_telescopic_cascode_0.programmable_nfet$4_0.transmission_gate$24_0.out 0
C265 scan_chain_0.D_ff1_5.D_latch1$1_1.Q_bar scan_chain_0.D_ff1_5.D_latch1$1_0.NAND2$2_0.A 0
C266 programmable_folded_cascode_0.programmable_pfet_1.transmission_gate$16_0.out INP_5T 0.06038f
C267 transmission_gate$2$1_6.out programmable_folded_cascode_0.programmable_pfet$1_0.transmission_gate$17_0.out 0.00847f
C268 programmable_folded_cascode_0.EN1 programmable_telescopic_cascode_0.programmable_nfet$6_0.transmission_gate$26_1.out 0.0274f
C269 scan_chain_0.D_ff1_0.D_latch1$1_0.NAND2$2_2.B VDD 1.06186f
C270 transmission_gate$2$1_3.out a_66673_79067# 0.02046f
C271 programmable_common_source_0.EN1 IN_CS 0.12539f
C272 programmable_telescopic_cascode_0.programmable_nfet$5_0.transmission_gate$25_1.out PROG_ENA 0
C273 transmission_gate$2$1_3.out programmable_5tOTA_0.programmable_nfet$7_0.transmission_gate$28_1.out 0
C274 scan_chain_0.D_ff1_4.D_latch1$1_0.NAND2$2_0.A a_58972_79067# 0.02432f
C275 a_20467_79067# PROG_ENA 0
C276 scan_chain_0.D_ff1_3.D_latch1$1_0.NAND2$2_2.B IBIAS 0.02483f
C277 programmable_telescopic_cascode_0.programmable_pfet$3_1.d programmable_folded_cascode_0.OUT 0.29981f
C278 transmission_gate$2$1_2.out scan_chain_0.D_ff1_4.inv1$4_0.Y 0.00229f
C279 programmable_telescopic_cascode_0.EN0 programmable_telescopic_cascode_0.programmable_nfet$6_0.d 0
C280 transmission_gate$2$1_4.out programmable_telescopic_cascode_0.programmable_pfet$2_0.g 0.28201f
C281 transmission_gate$2$1_2.out scan_chain_0.D_ff1_4.D_latch1$1_1.NAND2$2_0.A 0.0131f
C282 programmable_telescopic_cascode_0.EN1 transmission_gate$2$1_7.ena 1.23508f
C283 programmable_folded_cascode_0.programmable_pfet$1_0.g programmable_folded_cascode_0.programmable_pfet$1_1.transmission_gate$17_1.out 0.45084f
C284 programmable_folded_cascode_0.EN0 programmable_telescopic_cascode_0.programmable_pfet$2_0.transmission_gate$22_0.out 0.05175f
C285 programmable_telescopic_cascode_0.EN0 a_21950_79067# 0.16279f
C286 scan_chain_0.D_ff1_1.D_latch1$1_1.NAND2$2_2.B a_32014_79067# 0.16593f
C287 scan_chain_0.D_ff1_6.D_latch1$1_1.Q_bar PROG_ENA 0.00175f
C288 scan_chain_0.D_ff1_0.Q_bar scan_chain_0.D_ff1_0.D_latch1$1_0.NAND2$2_2.B 0.13783f
C289 programmable_common_source_0.EN0 scan_chain_0.D_ff1_4.D_latch1$1_1.Q_bar 0
C290 VDD INP_TELESCOPIC 14.0044f
C291 programmable_telescopic_cascode_0.programmable_nfet$6_0.d INN_TELESCOPIC 5.62808f
C292 scan_chain_0.D_ff1_5.D_latch1$1_1.inv1$3_0.Y CLK 0.02057f
C293 programmable_telescopic_cascode_0.programmable_pfet$3_1.transmission_gate$23_0.out programmable_telescopic_cascode_0.programmable_pfet$3_0.d 0.0014f
C294 transmission_gate$2$1_2.out programmable_5tOTA_0.programmable_nfet$8_0.transmission_gate$29_1.out 0.3385f
C295 a_33497_79067# transmission_gate$2$1_7.ena 0
C296 programmable_common_source_0.EN0 scan_chain_0.D_ff1_0.D_latch1$1_0.NAND2$2_2.B 0
C297 programmable_folded_cascode_0.EN1 programmable_telescopic_cascode_0.programmable_pfet$3_0.transmission_gate$23_0.out 0.0274f
C298 scan_chain_0.D_ff1_4.D_latch1$1_0.D PROG_ENA 0.00152f
C299 programmable_telescopic_cascode_0.programmable_pfet$2_0.g INP_5T 0.10974f
C300 transmission_gate$2$1_3.out scan_chain_0.D_ff1_4.D_latch1$1_0.inv1$3_0.Y 0.01532f
C301 programmable_telescopic_cascode_0.programmable_pfet$3_1.transmission_gate$23_0.out PROG_ENA 0
C302 scan_chain_0.D_ff1_6.D_latch1$1_1.NAND2$2_2.B PROG_ENA 0.00233f
C303 programmable_folded_cascode_0.EN0 programmable_folded_cascode_0.programmable_nfet$1_1.transmission_gate$19_1.out 0
C304 transmission_gate$2$1_6.out OUT_TELESCOPIC 0.05364f
C305 programmable_telescopic_cascode_0.EN0 programmable_telescopic_cascode_0.programmable_nfet$4_0.transmission_gate$24_1.out 0.0431f
C306 programmable_folded_cascode_0.programmable_pfet_0.g programmable_folded_cascode_0.programmable_pfet$1_1.transmission_gate$17_0.out 0.03264f
C307 scan_chain_0.D_ff1_0.D_latch1$1_1.NAND2$2_2.B a_62818_79067# 0.16593f
C308 scan_chain_0.D_ff1_1.D_latch1$1_1.NAND2$2_0.A scan_chain_0.D_ff1_1.D_latch1$1_1.Q_bar 0.02095f
C309 scan_chain_0.D_ff1_8.D_latch1$1_0.inv1$3_0.Y a_28168_79067# 0.00457f
C310 scan_chain_0.D_ff1_3.D_latch1$1_1.Q_bar IBIAS 0.00359f
C311 programmable_folded_cascode_0.programmable_nfet$2_0.g programmable_folded_cascode_0.programmable_nfet$1_1.transmission_gate$19_1.out 0.33853f
C312 programmable_common_source_0.EN0 scan_chain_0.D_ff1_4.D_latch1$1_0.D 0.00785f
C313 programmable_telescopic_cascode_0.programmable_nfet$4_0.transmission_gate$24_1.out INN_TELESCOPIC 0.01884f
C314 a_2693_79067# VDD 0.01845f
C315 programmable_common_source_0.EN1 PROG_ENA 0.08167f
C316 programmable_folded_cascode_0.programmable_pfet$1_0.g programmable_folded_cascode_0.programmable_nfet$1_1.transmission_gate$19_1.out 0.21602f
C317 programmable_telescopic_cascode_0.programmable_pfet$3_1.transmission_gate$23_1.out programmable_folded_cascode_0.OUT 0.02613f
C318 a_56601_79808# VDD 0.0019f
C319 a_10394_79067# CLK 0
C320 scan_chain_0.D_ff1_0.inv1$4_0.Y a_68156_79067# 0
C321 scan_chain_0.D_ff1_0.D_latch1$1_0.D scan_chain_0.D_ff1_0.D_latch1$1_0.NAND2$2_2.B 0.00115f
C322 programmable_folded_cascode_0.EN0 scan_chain_0.D_ff1_6.D_latch1$1_1.inv1$3_0.Y 0
C323 scan_chain_0.D_ff1_4.D_latch1$1_0.inv1$3_0.Y a_58972_79067# 0.00457f
C324 programmable_telescopic_cascode_0.programmable_pfet$2_0.g programmable_telescopic_cascode_0.programmable_pfet$3_0.d 4.22679f
C325 programmable_common_source_0.EN0 programmable_common_source_0.EN1 12.5585f
C326 a_64301_79067# VDD 0.01321f
C327 programmable_telescopic_cascode_0.programmable_nfet$4_1.transmission_gate$24_1.out OUT_TELESCOPIC 3.30847f
C328 transmission_gate$2$1_2.out a_58972_79808# 0
C329 a_55117_79808# a_55117_79067# 0
C330 programmable_common_source_0.EN1 scan_chain_0.D_ff1_0.D_latch1$1_1.Q_bar 0
C331 programmable_telescopic_cascode_0.programmable_pfet$2_0.g PROG_ENA 0
C332 programmable_5tOTA_0.programmable_nfet$8_0.transmission_gate$29_0.out INP_5T 0
C333 programmable_telescopic_cascode_0.EN0 programmable_telescopic_cascode_0.programmable_nfet$5_0.transmission_gate$25_1.out 0.04307f
C334 programmable_5tOTA_0.programmable_pfet$4_0.transmission_gate$27_0.out INN_5T 0
C335 programmable_5tOTA_0.ena_bar<0> scan_chain_0.D_ff1_4.D_latch1$1_0.D 0.05077f
C336 a_21951_79808# a_21950_79067# 0
C337 a_10395_79808# PROG_ENA 0
C338 scan_chain_0.D_ff1_7.D_latch1$1_0.D scan_chain_0.D_ff1_7.D_latch1$1_1.Q_bar 1.69947f
C339 a_32014_79067# transmission_gate$2$1_7.ena 0
C340 programmable_telescopic_cascode_0.programmable_nfet$5_0.transmission_gate$25_1.out INN_TELESCOPIC 0
C341 programmable_folded_cascode_0.programmable_nfet$3_0.transmission_gate$21_0.out VDD 0.32304f
C342 SCAN_IN CLK 0.01117f
C343 programmable_folded_cascode_0.EN1 programmable_telescopic_cascode_0.programmable_pfet$3_0.g 0.20864f
C344 programmable_common_source_0.EN0 a_64301_79067# 0
C345 transmission_gate$2$1_6.out programmable_telescopic_cascode_0.programmable_nfet$4_1.transmission_gate$24_0.out 0.00738f
C346 transmission_gate$2$1_3.out a_52754_79067# 0.02046f
C347 programmable_5tOTA_0.programmable_nfet$7_0.transmission_gate$28_0.out INN_5T 0.2563f
C348 transmission_gate$2$1_3.out scan_chain_0.D_ff1_2.D_latch1$1_1.Q_bar 0.01268f
C349 programmable_5tOTA_0.ena_bar<0> programmable_common_source_0.EN1 0.07822f
C350 programmable_common_source_0.EN0 scan_chain_0.D_ff1_0.D_latch1$1_1.inv1$3_0.Y 0.00158f
C351 programmable_folded_cascode_0.programmable_pfet_0.transmission_gate$16_1.out programmable_folded_cascode_0.programmable_nfet$1_0.g 0.00114f
C352 programmable_telescopic_cascode_0.programmable_nfet$4_0.s INP_FOLDED 0.38719f
C353 programmable_folded_cascode_0.EN1 programmable_folded_cascode_0.programmable_pfet_1.transmission_gate$16_1.out 0.11915f
C354 programmable_telescopic_cascode_0.EN0 programmable_telescopic_cascode_0.programmable_pfet$3_1.transmission_gate$23_0.out 0.00226f
C355 programmable_folded_cascode_0.programmable_pfet_0.transmission_gate$16_1.out INP_5T 0.12076f
C356 transmission_gate$2$1_5.out programmable_telescopic_cascode_0.programmable_pfet$2_1.transmission_gate$22_0.out 0.02075f
C357 a_48900_79808# IBIAS 0
C358 programmable_folded_cascode_0.EN0 INP_TELESCOPIC 0.02962f
C359 a_24313_79067# a_25796_79067# 0.00361f
C360 transmission_gate$2$1_2.out programmable_5tOTA_0.programmable_pfet$4_0.transmission_gate$27_0.out 0.72469f
C361 programmable_5tOTA_0.programmable_pfet$4_0.g programmable_5tOTA_0.programmable_nfet$8_0.transmission_gate$29_0.out 0
C362 scan_chain_0.D_ff1_1.D_latch1$1_1.NAND2$2_0.A a_33498_79808# 0.00428f
C363 programmable_common_source_0.EN0 a_55117_79808# 0.0043f
C364 scan_chain_0.D_ff1_8.D_latch1$1_1.Q_bar VDD 0.89232f
C365 a_1210_79067# VDD 0.01561f
C366 scan_chain_0.D_ff1_7.D_latch1$1_0.NAND2$2_2.B transmission_gate$2$1_7.ena 0
C367 programmable_5tOTA_0.programmable_nfet$7_0.transmission_gate$28_0.out OUT_5T 0.64184f
C368 programmable_telescopic_cascode_0.programmable_pfet$3_1.transmission_gate$23_0.out INN_TELESCOPIC 0.05062f
C369 programmable_folded_cascode_0.programmable_nfet$3_0.transmission_gate$21_0.out programmable_folded_cascode_0.programmable_nfet$3_0.g 0.20435f
C370 programmable_telescopic_cascode_0.programmable_nfet$4_0.transmission_gate$24_0.out programmable_telescopic_cascode_0.programmable_nfet$5_1.d 0.05287f
C371 scan_chain_0.D_ff1_7.D_latch1$1_0.NAND2$2_0.A scan_chain_0.D_ff1_7.inv1$4_0.Y 0.22611f
C372 scan_chain_0.D_ff1_0.inv1$4_0.Y a_66673_79067# 0.00477f
C373 a_55117_79067# a_56600_79067# 0.00361f
C374 a_8911_79067# CLK 0.00479f
C375 transmission_gate$2$1_2.out programmable_5tOTA_0.programmable_nfet$7_0.transmission_gate$28_0.out 0.1657f
C376 programmable_telescopic_cascode_0.programmable_nfet$4_1.transmission_gate$24_1.out programmable_telescopic_cascode_0.programmable_nfet$4_1.transmission_gate$24_0.out 0.0044f
C377 transmission_gate$2$1_2.out scan_chain_0.D_ff1_4.D_latch1$1_1.NAND2$2_2.B 0
C378 scan_chain_0.D_ff1_0.D_latch1$1_0.D a_64301_79067# 0.02982f
C379 a_24313_79808# scan_chain_0.D_ff1_8.D_latch1$1_0.D 0
C380 a_62818_79067# VDD 0.02094f
C381 programmable_5tOTA_0.ena_bar<0> scan_chain_0.D_ff1_0.D_latch1$1_1.inv1$3_0.Y 0.03106f
C382 programmable_folded_cascode_0.EN1 programmable_folded_cascode_0.programmable_nfet$2_0.transmission_gate$20_1.out 0.05845f
C383 transmission_gate$2$1_6.out programmable_telescopic_cascode_0.programmable_nfet$5_1.transmission_gate$25_0.out 0.01836f
C384 programmable_folded_cascode_0.programmable_nfet$1_0.g INP_5T 0.02926f
C385 programmable_common_source_0.EN1 a_64302_79808# 0
C386 programmable_folded_cascode_0.programmable_nfet_0.transmission_gate$18_0.out programmable_folded_cascode_0.programmable_nfet_0.transmission_gate$18_1.out 0.00458f
C387 programmable_folded_cascode_0.EN1 programmable_folded_cascode_0.programmable_pfet$1_0.transmission_gate$17_1.out 0.007f
C388 scan_chain_0.D_ff1_6.D_latch1$1_0.inv1$3_0.Y transmission_gate$2$1_7.ena 0
C389 scan_chain_0.D_ff1_7.inv1$4_0.Y VDD 0.98632f
C390 a_56600_79067# PROG_ENA 0
C391 scan_chain_0.D_ff1_7.D_latch1$1_1.NAND2$2_0.A VDD 0.78456f
C392 programmable_telescopic_cascode_0.EN0 programmable_telescopic_cascode_0.programmable_pfet$2_0.g 0.01867f
C393 scan_chain_0.D_ff1_7.D_latch1$1_0.D a_18096_79808# 0.16273f
C394 transmission_gate$2$1_5.out programmable_telescopic_cascode_0.programmable_nfet$4_0.g 0.2663f
C395 scan_chain_0.D_ff1_8.D_latch1$1_0.D PROG_ENA 0.00152f
C396 programmable_folded_cascode_0.programmable_nfet$2_0.transmission_gate$20_0.out VDD 0.1752f
C397 transmission_gate$2$1_2.out programmable_common_source_0.programmable_pfet$5_0.transmission_gate$30_1.out 0.00984f
C398 transmission_gate$2$1_4.out programmable_telescopic_cascode_0.programmable_pfet$3_0.d 0.27095f
C399 programmable_folded_cascode_0.programmable_pfet$1_0.transmission_gate$17_0.out VDD 1.6622f
C400 transmission_gate$2$1_7.out transmission_gate$2$1_6.out 8.9777f
C401 scan_chain_0.D_ff1_2.D_latch1$1_0.D scan_chain_0.D_ff1_2.D_latch1$1_0.NAND2$2_0.A 0.44673f
C402 transmission_gate$2$1_2.out scan_chain_0.D_ff1_3.D_latch1$1_1.inv1$3_0.Y 0.31417f
C403 scan_chain_0.D_ff1_3.D_latch1$1_0.NAND2$2_2.B VDD 1.04703f
C404 scan_chain_0.D_ff1_7.D_latch1$1_1.inv1$3_0.Y a_14249_79067# 0
C405 programmable_telescopic_cascode_0.programmable_pfet$2_0.g INN_TELESCOPIC 0.08376f
C406 programmable_common_source_0.EN0 a_62818_79067# 0
C407 transmission_gate$2$1_3.out a_51271_79067# 0.02046f
C408 transmission_gate$2$1_7.out IBIAS 0.04727f
C409 transmission_gate$2$1_3.out a_41199_79808# 0.00357f
C410 programmable_common_source_0.EN0 a_56600_79067# 0
C411 transmission_gate$2$1_4.out PROG_ENA 0.15901f
C412 programmable_5tOTA_0.programmable_pfet$4_0.g INP_5T 3.08882f
C413 transmission_gate$2$1_7.out programmable_folded_cascode_0.programmable_nfet_1.transmission_gate$18_0.out 0.37271f
C414 scan_chain_0.D_ff1_3.inv1$4_0.Y scan_chain_0.D_ff1_3.D_latch1$1_0.inv1$3_0.Y 0.00878f
C415 programmable_telescopic_cascode_0.programmable_nfet$4_0.g programmable_telescopic_cascode_0.programmable_nfet$5_1.transmission_gate$25_1.out 0
C416 programmable_telescopic_cascode_0.programmable_pfet$3_0.d INP_5T 0.52263f
C417 programmable_folded_cascode_0.EN0 programmable_folded_cascode_0.programmable_nfet$3_0.transmission_gate$21_0.out 0.05086f
C418 transmission_gate$2$1_3.out scan_chain_0.D_ff1_3.D_latch1$1_0.NAND2$2_0.A 0.00107f
C419 scan_chain_0.D_ff1_2.D_latch1$1_0.NAND2$2_0.A transmission_gate$2$1_2.out 0.41823f
C420 scan_chain_0.D_ff1_4.D_latch1$1_0.NAND2$2_2.B CLK 0.00592f
C421 transmission_gate$2$1_6.out programmable_telescopic_cascode_0.programmable_nfet$6_0.transmission_gate$26_0.out 0.03264f
C422 scan_chain_0.D_ff1_5.D_latch1$1_0.NAND2$2_0.A scan_chain_0.D_ff1_5.D_latch1$1_0.NAND2$2_2.B 0.01576f
C423 programmable_5tOTA_0.ena_bar<0> programmable_5tOTA_0.programmable_nfet$8_0.transmission_gate$29_0.out 0.02472f
C424 a_25797_79808# VDD 0.00461f
C425 programmable_folded_cascode_0.programmable_nfet$3_0.transmission_gate$21_0.out programmable_folded_cascode_0.programmable_nfet$2_0.g 0
C426 scan_chain_0.D_ff1_5.D_latch1$1_1.NAND2$2_0.A a_2693_79067# 0
C427 scan_chain_0.D_ff1_5.D_latch1$1_0.D scan_chain_0.D_ff1_5.D_latch1$1_1.NAND2$2_2.B 0.01594f
C428 scan_chain_0.D_ff1_3.D_latch1$1_1.inv1$3_0.Y a_45053_79067# 0
C429 scan_chain_0.D_ff1_1.inv1$4_0.Y CLK 0.33263f
C430 scan_chain_0.D_ff1_2.D_latch1$1_0.inv1$3_0.Y VDD 0.37869f
C431 programmable_telescopic_cascode_0.programmable_nfet$6_0.transmission_gate$26_0.out IBIAS 0.66959f
C432 programmable_5tOTA_0.programmable_pfet$4_1.transmission_gate$27_0.out INP_5T 0.06098f
C433 programmable_common_source_0.EN0 scan_chain_0.D_ff1_3.D_latch1$1_0.NAND2$2_2.B 0.139f
C434 transmission_gate$2$1_3.out scan_chain_0.D_ff1_2.D_latch1$1_1.NAND2$2_2.B 0.01104f
C435 scan_chain_0.D_ff1_1.D_latch1$1_1.NAND2$2_0.A CLK 0.22611f
C436 scan_chain_0.D_ff1_3.D_latch1$1_1.Q_bar a_48899_79067# 0.16279f
C437 scan_chain_0.D_ff1_7.D_latch1$1_0.NAND2$2_0.A a_20467_79808# 0.23035f
C438 a_66673_79808# a_66673_79067# 0
C439 scan_chain_0.D_ff1_1.D_latch1$1_0.NAND2$2_0.A scan_chain_0.D_ff1_1.D_latch1$1_0.inv1$3_0.Y 0
C440 scan_chain_0.D_ff1_2.inv1$4_0.Y PROG_ENA 0.44521f
C441 transmission_gate$2$1_7.out programmable_telescopic_cascode_0.programmable_nfet$4_1.transmission_gate$24_1.out 0.01219f
C442 VDD OUT_TELESCOPIC 43.2075f
C443 programmable_telescopic_cascode_0.programmable_nfet$6_0.d INP_TELESCOPIC 5.70454f
C444 scan_chain_0.D_ff1_3.D_latch1$1_1.Q_bar VDD 0.88625f
C445 scan_chain_0.D_ff1_4.inv1$4_0.Y transmission_gate$2$1_7.ena 0.00353f
C446 scan_chain_0.D_ff1_2.inv1$4_0.Y scan_chain_0.D_ff1_2.D_latch1$1_0.NAND2$2_2.B 0.40095f
C447 programmable_5tOTA_0.ena_bar<0> a_56600_79067# 0.0119f
C448 programmable_telescopic_cascode_0.programmable_pfet$3_0.transmission_gate$23_0.out INN_FOLDED 0.05052f
C449 scan_chain_0.D_ff1_5.D_latch1$1_1.Q_bar a_5065_79067# 0
C450 scan_chain_0.D_ff1_3.D_latch1$1_0.inv1$3_0.Y CLK 0.00358f
C451 scan_chain_0.D_ff1_2.D_latch1$1_0.NAND2$2_0.A a_45053_79067# 0
C452 transmission_gate$2$1_7.out a_8911_79808# 0.0043f
C453 scan_chain_0.D_ff1_2.D_latch1$1_0.D a_41198_79067# 0.02982f
C454 programmable_folded_cascode_0.EN1 scan_chain_0.D_ff1_6.D_latch1$1_0.NAND2$2_2.B 0.13919f
C455 transmission_gate$2$1_6.out programmable_telescopic_cascode_0.programmable_pfet$2_1.transmission_gate$22_1.out 0.00517f
C456 programmable_common_source_0.EN0 IN_CS 0.28689f
C457 transmission_gate$2$1_2.out scan_chain_0.D_ff1_3.inv1$4_0.Y 0.00229f
C458 a_6548_79067# transmission_gate$2$1_7.ena 0
C459 transmission_gate$2$1_6.out scan_chain_0.D_ff1_7.D_latch1$1_1.inv1$3_0.Y 0.31398f
C460 a_20467_79808# VDD 0.0071f
C461 a_55117_79067# PROG_ENA 0
C462 transmission_gate$2$1_2.out scan_chain_0.D_ff1_3.D_latch1$1_1.NAND2$2_0.A 0.45993f
C463 scan_chain_0.D_ff1_1.D_latch1$1_0.NAND2$2_0.A programmable_5tOTA_0.ena_bar<0> 0.02095f
C464 transmission_gate$2$1_7.out programmable_folded_cascode_0.programmable_nfet$2_1.transmission_gate$20_0.out 0.36504f
C465 programmable_telescopic_cascode_0.programmable_pfet$2_0.transmission_gate$22_1.out programmable_telescopic_cascode_0.programmable_pfet$3_1.d 0.00121f
C466 programmable_5tOTA_0.programmable_pfet$4_0.g programmable_5tOTA_0.programmable_pfet$4_1.transmission_gate$27_0.out 0.22463f
C467 scan_chain_0.D_ff1_1.D_latch1$1_1.Q_bar scan_chain_0.D_ff1_1.D_latch1$1_1.NAND2$2_2.B 0.13783f
C468 a_16612_79808# a_18096_79808# 0.00361f
C469 a_43570_79808# scan_chain_0.D_ff1_2.inv1$4_0.Y 0.00415f
C470 scan_chain_0.D_ff1_2.D_latch1$1_0.D CLK 0.00906f
C471 programmable_telescopic_cascode_0.EN0 scan_chain_0.D_ff1_8.D_latch1$1_0.D 0
C472 transmission_gate$2$1_3.out programmable_common_source_0.programmable_pfet$5_0.transmission_gate$30_0.out 0.01569f
C473 scan_chain_0.D_ff1_8.D_latch1$1_1.Q_bar scan_chain_0.D_ff1_8.D_latch1$1_0.inv1$3_0.Y 0.00416f
C474 programmable_common_source_0.EN0 a_55117_79067# 0
C475 scan_chain_0.D_ff1_6.inv1$4_0.Y programmable_folded_cascode_0.EN1 0.00236f
C476 scan_chain_0.D_ff1_3.D_latch1$1_0.D PROG_ENA 0.00152f
C477 scan_chain_0.D_ff1_8.D_latch1$1_0.NAND2$2_0.A programmable_telescopic_cascode_0.EN1 0.02095f
C478 programmable_folded_cascode_0.programmable_pfet_0.g INP_FOLDED 0.21024f
C479 programmable_telescopic_cascode_0.EN1 scan_chain_0.D_ff1_2.D_latch1$1_1.Q_bar 0
C480 scan_chain_0.D_ff1_0.D_latch1$1_0.inv1$3_0.Y SCAN_OUT 0.02414f
C481 programmable_5tOTA_0.ena_bar<1> scan_chain_0.D_ff1_4.D_latch1$1_0.NAND2$2_2.B 0
C482 programmable_folded_cascode_0.EN0 programmable_folded_cascode_0.programmable_nfet$2_0.transmission_gate$20_0.out 0.05082f
C483 programmable_5tOTA_0.ena_bar<0> INP_5T 0.18259f
C484 programmable_telescopic_cascode_0.EN0 transmission_gate$2$1_4.out 0.07084f
C485 transmission_gate$2$1_5.out programmable_telescopic_cascode_0.EN1 0.06302f
C486 scan_chain_0.D_ff1_2.D_latch1$1_0.NAND2$2_2.B PROG_ENA 0.00233f
C487 programmable_folded_cascode_0.EN0 programmable_folded_cascode_0.programmable_pfet$1_0.transmission_gate$17_0.out 0.00685f
C488 transmission_gate$2$1_2.out CLK 0.05218f
C489 transmission_gate$2$1_7.ena programmable_telescopic_cascode_0.programmable_nfet$4_0.transmission_gate$24_0.out 0
C490 programmable_telescopic_cascode_0.programmable_pfet$2_0.g programmable_telescopic_cascode_0.programmable_pfet$2_0.transmission_gate$22_0.out 0.26666f
C491 programmable_5tOTA_0.ena_bar<0> IN_CS 0.10568f
C492 programmable_folded_cascode_0.programmable_nfet$2_0.transmission_gate$20_0.out programmable_folded_cascode_0.programmable_nfet$2_0.g 0.19856f
C493 programmable_5tOTA_0.ena_bar<0> scan_chain_0.D_ff1_2.inv1$4_0.Y 0.03865f
C494 a_14250_79808# programmable_folded_cascode_0.EN1 0.01093f
C495 programmable_5tOTA_0.ena_bar<0> scan_chain_0.D_ff1_2.D_latch1$1_1.NAND2$2_0.A 0
C496 scan_chain_0.D_ff1_5.D_latch1$1_1.NAND2$2_0.A a_1210_79067# 0.02432f
C497 programmable_common_source_0.EN0 PROG_ENA 0.22438f
C498 scan_chain_0.D_ff1_6.D_latch1$1_0.NAND2$2_0.A a_14249_79067# 0
C499 a_35869_79808# CLK 0.00107f
C500 a_37352_79067# VDD 0.04159f
C501 scan_chain_0.D_ff1_6.inv1$4_0.Y scan_chain_0.D_ff1_6.D_latch1$1_0.NAND2$2_2.B 0.40095f
C502 scan_chain_0.D_ff1_6.D_latch1$1_1.inv1$3_0.Y scan_chain_0.D_ff1_6.D_latch1$1_1.NAND2$2_2.B 0.44307f
C503 transmission_gate$2$1_4.out INN_TELESCOPIC 0.06126f
C504 scan_chain_0.D_ff1_6.D_latch1$1_0.D a_10394_79067# 0.02982f
C505 programmable_telescopic_cascode_0.programmable_nfet$4_1.transmission_gate$24_0.out VDD 0.87068f
C506 scan_chain_0.D_ff1_4.D_latch1$1_0.D scan_chain_0.D_ff1_4.D_latch1$1_1.Q_bar 1.69947f
C507 a_48900_79808# a_48899_79067# 0
C508 programmable_5tOTA_0.ena_bar<1> scan_chain_0.D_ff1_3.D_latch1$1_0.inv1$3_0.Y 0
C509 programmable_folded_cascode_0.programmable_pfet$1_0.transmission_gate$17_0.out programmable_folded_cascode_0.programmable_pfet$1_0.g 0.23386f
C510 a_62818_79808# a_62818_79067# 0
C511 a_48900_79808# VDD 0.0019f
C512 programmable_telescopic_cascode_0.EN1 programmable_telescopic_cascode_0.programmable_nfet$5_1.transmission_gate$25_1.out 0.00123f
C513 programmable_telescopic_cascode_0.programmable_nfet$5_0.transmission_gate$25_1.out INP_TELESCOPIC 0.18985f
C514 programmable_telescopic_cascode_0.programmable_pfet$3_0.g INN_FOLDED 0.43726f
C515 programmable_5tOTA_0.ena_bar<0> a_55117_79067# 0.0119f
C516 programmable_telescopic_cascode_0.programmable_pfet$3_0.g programmable_telescopic_cascode_0.programmable_pfet$2_1.transmission_gate$22_0.out 0.04921f
C517 scan_chain_0.D_ff1_1.D_latch1$1_0.inv1$3_0.Y PROG_ENA 0.00134f
C518 scan_chain_0.D_ff1_2.D_latch1$1_0.NAND2$2_0.A a_43570_79067# 0.02432f
C519 transmission_gate$2$1_4.out a_29651_79067# 0.02983f
C520 a_45053_79067# CLK 0
C521 programmable_5tOTA_0.ena_bar<0> programmable_5tOTA_0.programmable_pfet$4_0.g 3.18049f
C522 a_5065_79067# transmission_gate$2$1_7.ena 0
C523 transmission_gate$2$1_5.out programmable_telescopic_cascode_0.programmable_nfet$4_0.s 0.02806f
C524 programmable_5tOTA_0.ena_bar<1> INN_5T 0.15562f
C525 scan_chain_0.D_ff1_2.D_latch1$1_1.inv1$3_0.Y scan_chain_0.D_ff1_2.D_latch1$1_1.NAND2$2_2.B 0.44307f
C526 scan_chain_0.D_ff1_8.D_latch1$1_1.NAND2$2_0.A scan_chain_0.D_ff1_8.D_latch1$1_1.inv1$3_0.Y 0
C527 scan_chain_0.D_ff1_1.D_latch1$1_0.NAND2$2_0.A a_37353_79808# 0.00428f
C528 programmable_common_source_0.EN0 scan_chain_0.D_ff1_0.D_latch1$1_1.Q_bar 0
C529 transmission_gate$2$1_2.out a_51271_79808# 0
C530 programmable_folded_cascode_0.EN0 OUT_TELESCOPIC 0.03975f
C531 programmable_folded_cascode_0.programmable_pfet_1.transmission_gate$16_1.out INN_FOLDED 0.09973f
C532 scan_chain_0.D_ff1_5.D_latch1$1_1.inv1$3_0.Y scan_chain_0.D_ff1_5.D_latch1$1_1.NAND2$2_2.B 0.44307f
C533 scan_chain_0.D_ff1_6.D_latch1$1_0.D scan_chain_0.D_ff1_6.D_latch1$1_0.NAND2$2_0.A 0.44673f
C534 transmission_gate$2$1_6.out programmable_folded_cascode_0.programmable_pfet_0.transmission_gate$16_0.out 0.10136f
C535 programmable_common_source_0.EN1 scan_chain_0.D_ff1_0.D_latch1$1_0.NAND2$2_2.B 0
C536 transmission_gate$2$1_7.ena programmable_telescopic_cascode_0.programmable_nfet$5_0.transmission_gate$25_0.out 0
C537 programmable_5tOTA_0.ena_bar<0> PROG_ENA 0.11697f
C538 programmable_5tOTA_0.ena_bar<0> scan_chain_0.D_ff1_3.D_latch1$1_0.D 0.05091f
C539 programmable_5tOTA_0.ena_bar<0> programmable_5tOTA_0.programmable_pfet$4_1.transmission_gate$27_0.out 0.00132f
C540 a_39715_79808# CLK 0.00415f
C541 scan_chain_0.D_ff1_1.D_latch1$1_1.Q_bar transmission_gate$2$1_7.ena 0
C542 programmable_5tOTA_0.ena_bar<1> OUT_5T 0.02657f
C543 programmable_folded_cascode_0.programmable_pfet_0.transmission_gate$16_0.out IBIAS 0
C544 a_47416_79808# scan_chain_0.D_ff1_3.D_latch1$1_0.D 0
C545 scan_chain_0.D_ff1_6.inv1$4_0.Y a_14250_79808# 0
C546 programmable_5tOTA_0.ena_bar<0> scan_chain_0.D_ff1_2.D_latch1$1_0.NAND2$2_2.B 0.04157f
C547 programmable_telescopic_cascode_0.EN0 programmable_telescopic_cascode_0.programmable_pfet$3_0.d 0
C548 scan_chain_0.D_ff1_8.D_latch1$1_0.NAND2$2_0.A a_29652_79808# 0.00428f
C549 programmable_telescopic_cascode_0.programmable_nfet$5_1.transmission_gate$25_0.out VDD 0.21778f
C550 programmable_telescopic_cascode_0.programmable_nfet$5_1.transmission_gate$25_1.out programmable_telescopic_cascode_0.programmable_nfet$4_0.s 0.02779f
C551 a_60455_79067# SCAN_OUT 0
C552 scan_chain_0.D_ff1_4.D_latch1$1_0.NAND2$2_0.A scan_chain_0.D_ff1_4.inv1$4_0.Y 0.22611f
C553 programmable_5tOTA_0.ena_bar<1> programmable_5tOTA_0.programmable_nfet$7_1.transmission_gate$28_1.out 0.39791f
C554 scan_chain_0.D_ff1_5.D_latch1$1_0.D VDD 1.57506f
C555 scan_chain_0.D_ff1_6.D_latch1$1_0.NAND2$2_0.A transmission_gate$2$1_6.out 0.41823f
C556 programmable_telescopic_cascode_0.EN0 PROG_ENA 0.06341f
C557 programmable_telescopic_cascode_0.programmable_nfet$4_0.transmission_gate$24_0.out INP_FOLDED 0.06218f
C558 programmable_5tOTA_0.ena_bar<0> programmable_common_source_0.EN0 1.53561f
C559 transmission_gate$2$1_2.out programmable_5tOTA_0.ena_bar<1> 16.7515f
C560 programmable_telescopic_cascode_0.EN1 programmable_telescopic_cascode_0.programmable_nfet$6_0.transmission_gate$26_1.out 0.00131f
C561 programmable_telescopic_cascode_0.programmable_pfet$3_0.d INN_TELESCOPIC 0.38577f
C562 programmable_telescopic_cascode_0.programmable_pfet$3_0.g programmable_telescopic_cascode_0.programmable_nfet$4_0.g 8.8066f
C563 programmable_5tOTA_0.ena_bar<0> scan_chain_0.D_ff1_0.D_latch1$1_1.Q_bar 0.02423f
C564 transmission_gate$2$1_7.ena programmable_telescopic_cascode_0.programmable_pfet$3_0.transmission_gate$23_1.out 0
C565 scan_chain_0.D_ff1_8.D_latch1$1_0.D a_28168_79067# 0
C566 PROG_ENA INN_TELESCOPIC 0
C567 transmission_gate$2$1_6.out programmable_folded_cascode_0.programmable_nfet$1_0.transmission_gate$19_0.out 0.00498f
C568 a_35869_79067# VDD 0.01074f
C569 scan_chain_0.D_ff1_6.D_latch1$1_0.NAND2$2_0.A a_12766_79067# 0.02432f
C570 scan_chain_0.D_ff1_8.inv1$4_0.Y transmission_gate$2$1_7.ena 0.00353f
C571 programmable_folded_cascode_0.programmable_pfet$1_0.transmission_gate$17_1.out INN_FOLDED 0.05044f
C572 scan_chain_0.D_ff1_5.D_latch1$1_0.NAND2$2_2.B a_6548_79067# 0.00415f
C573 transmission_gate$2$1_7.out VDD 24.1206f
C574 transmission_gate$2$1_6.out programmable_folded_cascode_0.OUT 0.11352f
C575 scan_chain_0.D_ff1_4.D_latch1$1_1.NAND2$2_2.B transmission_gate$2$1_7.ena 0
C576 scan_chain_0.D_ff1_7.inv1$4_0.Y a_21950_79067# 0
C577 programmable_telescopic_cascode_0.EN1 scan_chain_0.D_ff1_2.D_latch1$1_1.NAND2$2_2.B 0
C578 scan_chain_0.D_ff1_4.D_latch1$1_0.D a_56601_79808# 0.16273f
C579 programmable_5tOTA_0.ena_bar<1> a_45053_79067# 0.16645f
C580 scan_chain_0.D_ff1_7.D_latch1$1_0.D scan_chain_0.D_ff1_7.D_latch1$1_0.NAND2$2_2.B 0.00115f
C581 programmable_folded_cascode_0.programmable_nfet$1_0.g programmable_folded_cascode_0.programmable_pfet$1_1.transmission_gate$17_1.out 4.25425f
C582 a_29651_79067# PROG_ENA 0
C583 a_43570_79067# CLK 0
C584 transmission_gate$2$1_3.out SCAN_OUT 0.11431f
C585 programmable_telescopic_cascode_0.EN1 programmable_telescopic_cascode_0.programmable_pfet$3_0.transmission_gate$23_0.out 0.01333f
C586 transmission_gate$2$1_4.out programmable_telescopic_cascode_0.programmable_pfet$2_0.transmission_gate$22_0.out 1.03579f
C587 programmable_folded_cascode_0.OUT programmable_folded_cascode_0.programmable_nfet_1.transmission_gate$18_0.out 0.02683f
C588 a_39715_79808# a_39715_79067# 0
C589 programmable_telescopic_cascode_0.EN0 scan_chain_0.D_ff1_1.D_latch1$1_0.inv1$3_0.Y 0
C590 programmable_telescopic_cascode_0.programmable_nfet$6_0.transmission_gate$26_1.out programmable_telescopic_cascode_0.programmable_nfet$4_0.s 0.00183f
C591 scan_chain_0.D_ff1_1.D_latch1$1_0.NAND2$2_2.B a_37352_79067# 0.00415f
C592 programmable_telescopic_cascode_0.programmable_nfet$6_0.transmission_gate$26_0.out VDD 0.31022f
C593 programmable_folded_cascode_0.EN0 programmable_telescopic_cascode_0.programmable_nfet$4_1.transmission_gate$24_0.out 0.0543f
C594 a_12766_79808# scan_chain_0.D_ff1_6.inv1$4_0.Y 0.00415f
C595 programmable_common_source_0.EN0 a_64302_79808# 0
C596 scan_chain_0.D_ff1_8.D_latch1$1_1.NAND2$2_2.B VDD 1.14949f
C597 transmission_gate$2$1_5.out scan_chain_0.D_ff1_7.D_latch1$1_0.NAND2$2_2.B 0.01633f
C598 scan_chain_0.D_ff1_5.D_latch1$1_1.NAND2$2_2.B SCAN_IN 0.00117f
C599 a_37353_79808# PROG_ENA 0
C600 scan_chain_0.D_ff1_3.D_latch1$1_1.inv1$3_0.Y transmission_gate$2$1_7.ena 0
C601 programmable_telescopic_cascode_0.programmable_pfet$2_0.transmission_gate$22_0.out INP_5T 0.06038f
C602 transmission_gate$2$1_7.out programmable_folded_cascode_0.programmable_nfet$3_0.g 0.13244f
C603 programmable_common_source_0.EN1 a_64301_79067# 0
C604 a_64302_79808# scan_chain_0.D_ff1_0.D_latch1$1_1.Q_bar 0.01093f
C605 programmable_telescopic_cascode_0.EN1 scan_chain_0.D_ff1_1.D_latch1$1_1.inv1$3_0.Y 0
C606 programmable_folded_cascode_0.EN1 INN_FOLDED 0.36285f
C607 programmable_folded_cascode_0.EN1 programmable_telescopic_cascode_0.programmable_pfet$2_1.transmission_gate$22_0.out 0.0274f
C608 scan_chain_0.D_ff1_1.D_latch1$1_1.NAND2$2_2.B CLK 0.40703f
C609 programmable_telescopic_cascode_0.EN0 programmable_5tOTA_0.ena_bar<0> 0
C610 programmable_telescopic_cascode_0.programmable_nfet$4_1.transmission_gate$24_1.out programmable_folded_cascode_0.OUT 0.02125f
C611 scan_chain_0.D_ff1_4.inv1$4_0.Y scan_chain_0.D_ff1_4.D_latch1$1_0.inv1$3_0.Y 0.00878f
C612 scan_chain_0.D_ff1_5.D_latch1$1_1.Q_bar CLK 0.00483f
C613 a_12766_79808# a_14250_79808# 0.00361f
C614 scan_chain_0.D_ff1_4.D_latch1$1_0.NAND2$2_0.A a_58972_79808# 0.23035f
C615 a_1210_79808# VDD 0.00765f
C616 programmable_telescopic_cascode_0.programmable_pfet$2_1.transmission_gate$22_1.out VDD 1.6655f
C617 a_58972_79067# SCAN_OUT 0.0067f
C618 scan_chain_0.D_ff1_7.D_latch1$1_1.inv1$3_0.Y VDD 0.3828f
C619 programmable_folded_cascode_0.programmable_nfet$1_0.g programmable_folded_cascode_0.programmable_nfet$1_1.transmission_gate$19_1.out 0.50705f
C620 transmission_gate$2$1_2.out a_45054_79808# 0.16273f
C621 a_21951_79808# PROG_ENA 0
C622 programmable_folded_cascode_0.EN1 programmable_folded_cascode_0.programmable_nfet_1.transmission_gate$18_1.out 0.05055f
C623 programmable_common_source_0.EN1 scan_chain_0.D_ff1_4.D_latch1$1_0.NAND2$2_2.B 0.139f
C624 programmable_5tOTA_0.ena_bar<0> a_64302_79808# 0
C625 scan_chain_0.D_ff1_4.D_latch1$1_1.Q_bar a_56600_79067# 0.16279f
C626 transmission_gate$2$1_7.ena programmable_telescopic_cascode_0.programmable_pfet$3_1.transmission_gate$23_1.out 0.00544f
C627 programmable_folded_cascode_0.EN0 programmable_telescopic_cascode_0.programmable_nfet$5_1.transmission_gate$25_0.out 0.05399f
C628 scan_chain_0.D_ff1_5.D_latch1$1_0.NAND2$2_2.B a_5065_79067# 0.12535f
C629 scan_chain_0.D_ff1_8.D_latch1$1_1.inv1$3_0.Y CLK 0.02415f
C630 a_8911_79808# a_8911_79067# 0
C631 programmable_telescopic_cascode_0.programmable_pfet$2_0.transmission_gate$22_0.out programmable_telescopic_cascode_0.programmable_pfet$3_0.d 6.4918f
C632 programmable_common_source_0.programmable_pfet$5_0.transmission_gate$30_0.out OUT_CS 5.82514f
C633 a_55117_79808# a_56601_79808# 0.00361f
C634 programmable_telescopic_cascode_0.EN0 INN_TELESCOPIC 0.01012f
C635 programmable_5tOTA_0.ena_bar<1> scan_chain_0.D_ff1_0.D_latch1$1_0.NAND2$2_0.A 0.06699f
C636 scan_chain_0.D_ff1_7.inv1$4_0.Y a_20467_79067# 0.00477f
C637 a_45054_79808# a_45053_79067# 0
C638 programmable_telescopic_cascode_0.programmable_nfet$4_0.transmission_gate$24_1.out OUT_TELESCOPIC 0.03159f
C639 programmable_folded_cascode_0.EN1 programmable_telescopic_cascode_0.programmable_nfet$4_0.g 0.03803f
C640 scan_chain_0.D_ff1_5.D_latch1$1_1.inv1$3_0.Y VDD 0.3832f
C641 a_28168_79067# PROG_ENA 0
C642 programmable_telescopic_cascode_0.programmable_pfet$2_0.transmission_gate$22_0.out PROG_ENA 0
C643 programmable_telescopic_cascode_0.EN1 programmable_telescopic_cascode_0.programmable_pfet$3_0.g 0.02208f
C644 a_37353_79808# programmable_5tOTA_0.ena_bar<0> 0.01093f
C645 scan_chain_0.D_ff1_3.inv1$4_0.Y transmission_gate$2$1_7.ena 0.00353f
C646 transmission_gate$2$1_7.out programmable_folded_cascode_0.EN0 24.2578f
C647 programmable_5tOTA_0.ena_bar<1> programmable_5tOTA_0.programmable_pfet$4_1.transmission_gate$27_1.out 0
C648 scan_chain_0.D_ff1_1.D_latch1$1_0.NAND2$2_2.B a_35869_79067# 0.12535f
C649 transmission_gate$2$1_7.out programmable_folded_cascode_0.programmable_nfet$2_0.g 0.18279f
C650 programmable_folded_cascode_0.EN1 programmable_folded_cascode_0.programmable_nfet$2_1.transmission_gate$20_1.out 0.0583f
C651 a_41198_79067# transmission_gate$2$1_7.ena 0
C652 programmable_common_source_0.EN1 a_62818_79067# 0
C653 transmission_gate$2$1_7.out programmable_folded_cascode_0.programmable_pfet$1_0.g 0.16297f
C654 transmission_gate$2$1_3.out scan_chain_0.D_ff1_0.D_latch1$1_0.inv1$3_0.Y 0.01532f
C655 scan_chain_0.D_ff1_3.D_latch1$1_0.inv1$3_0.Y IBIAS 0.01837f
C656 programmable_folded_cascode_0.EN0 programmable_telescopic_cascode_0.programmable_nfet$6_0.transmission_gate$26_0.out 0.06883f
C657 scan_chain_0.D_ff1_7.D_latch1$1_1.NAND2$2_2.B PROG_ENA 0.00233f
C658 a_2694_79808# CLK 0
C659 transmission_gate$2$1_4.out INP_TELESCOPIC 0.06126f
C660 transmission_gate$2$1_7.ena CLK 0.20197f
C661 IBIAS INN_5T 0.16358f
C662 scan_chain_0.D_ff1_1.D_latch1$1_1.inv1$3_0.Y a_32014_79067# 0.00457f
C663 scan_chain_0.D_ff1_5.D_latch1$1_0.D scan_chain_0.D_ff1_5.inv1$4_0.Y 0.01122f
C664 a_10394_79067# VDD 0.01529f
C665 scan_chain_0.D_ff1_5.D_latch1$1_1.NAND2$2_0.A scan_chain_0.D_ff1_5.D_latch1$1_0.D 0.41823f
C666 programmable_telescopic_cascode_0.programmable_pfet$3_0.g programmable_telescopic_cascode_0.programmable_nfet$4_0.s 69.2625f
C667 a_21951_79808# programmable_telescopic_cascode_0.EN0 0.01093f
C668 transmission_gate$2$1_2.out programmable_common_source_0.EN1 0.00366f
C669 INP_TELESCOPIC INP_5T 1.06491f
C670 programmable_folded_cascode_0.programmable_pfet_0.transmission_gate$16_0.out VDD 11.4519f
C671 a_56601_79808# a_56600_79067# 0
C672 scan_chain_0.D_ff1_6.D_latch1$1_1.inv1$3_0.Y PROG_ENA 0.00134f
C673 programmable_5tOTA_0.programmable_nfet$7_0.transmission_gate$28_1.out programmable_5tOTA_0.programmable_nfet$7_0.transmission_gate$28_0.out 0.00448f
C674 IBIAS OUT_5T 0.58735f
C675 scan_chain_0.D_ff1_5.inv1$4_0.Y transmission_gate$2$1_7.out 0.01281f
C676 a_18095_79067# CLK 0
C677 programmable_folded_cascode_0.EN0 programmable_telescopic_cascode_0.programmable_pfet$2_1.transmission_gate$22_1.out 0.04092f
C678 scan_chain_0.D_ff1_0.D_latch1$1_1.inv1$3_0.Y a_62818_79067# 0.00457f
C679 programmable_telescopic_cascode_0.programmable_nfet$4_1.transmission_gate$24_0.out programmable_telescopic_cascode_0.programmable_nfet$4_0.transmission_gate$24_1.out 0.3766f
C680 scan_chain_0.D_ff1_0.inv1$4_0.Y SCAN_OUT 0.01416f
C681 a_20467_79808# a_20467_79067# 0
C682 scan_chain_0.D_ff1_6.D_latch1$1_0.NAND2$2_0.A VDD 0.77335f
C683 scan_chain_0.D_ff1_4.D_latch1$1_1.Q_bar PROG_ENA 0.00175f
C684 programmable_folded_cascode_0.EN1 programmable_folded_cascode_0.programmable_nfet$1_0.transmission_gate$19_1.out 0.05069f
C685 transmission_gate$2$1_2.out IBIAS 0.28864f
C686 VDD SCAN_IN 0.58265f
C687 transmission_gate$2$1_7.out a_6549_79808# 0.16273f
C688 programmable_telescopic_cascode_0.programmable_nfet$5_1.transmission_gate$25_0.out programmable_telescopic_cascode_0.programmable_nfet$6_0.d 0.81902f
C689 programmable_telescopic_cascode_0.EN0 programmable_telescopic_cascode_0.programmable_pfet$2_0.transmission_gate$22_0.out 0.0564f
C690 programmable_folded_cascode_0.programmable_nfet$1_0.transmission_gate$19_0.out VDD 0.13852f
C691 transmission_gate$2$1_5.out programmable_telescopic_cascode_0.programmable_nfet$4_0.transmission_gate$24_0.out 0.33866f
C692 a_39715_79067# transmission_gate$2$1_7.ena 0
C693 programmable_common_source_0.EN0 scan_chain_0.D_ff1_4.D_latch1$1_1.Q_bar 0.01341f
C694 programmable_folded_cascode_0.OUT VDD 27.8065f
C695 transmission_gate$2$1_3.out a_60455_79067# 0.02046f
C696 programmable_telescopic_cascode_0.programmable_pfet$2_0.transmission_gate$22_0.out INN_TELESCOPIC 0.0471f
C697 PROG_ENA INP_TELESCOPIC 0
C698 programmable_common_source_0.EN0 scan_chain_0.D_ff1_0.D_latch1$1_0.NAND2$2_2.B 0.00199f
C699 transmission_gate$2$1_7.out programmable_telescopic_cascode_0.programmable_nfet$6_0.d 0.15388f
C700 programmable_5tOTA_0.ena_bar<1> transmission_gate$2$1_7.ena 0
C701 programmable_5tOTA_0.programmable_pfet$4_0.transmission_gate$27_1.out INN_5T 0
C702 SCAN_OUT OUT_CS 0.03297f
C703 programmable_telescopic_cascode_0.programmable_nfet$4_0.transmission_gate$24_0.out programmable_telescopic_cascode_0.programmable_nfet$5_1.transmission_gate$25_1.out 0.34428f
C704 a_28168_79067# a_29651_79067# 0.00361f
C705 scan_chain_0.D_ff1_5.D_latch1$1_0.D a_5065_79808# 0.0043f
C706 scan_chain_0.D_ff1_0.D_latch1$1_1.Q_bar scan_chain_0.D_ff1_0.D_latch1$1_0.NAND2$2_2.B 0.00216f
C707 scan_chain_0.D_ff1_8.D_latch1$1_0.D scan_chain_0.D_ff1_8.D_latch1$1_1.Q_bar 1.69947f
C708 a_8911_79067# VDD 0.01897f
C709 scan_chain_0.D_ff1_5.D_latch1$1_1.NAND2$2_0.A a_1210_79808# 0.23035f
C710 scan_chain_0.D_ff1_8.D_latch1$1_0.NAND2$2_2.B transmission_gate$2$1_7.ena 0
C711 programmable_telescopic_cascode_0.programmable_pfet$2_0.g OUT_TELESCOPIC 4.52449f
C712 transmission_gate$2$1_2.out a_60456_79808# 0
C713 programmable_folded_cascode_0.programmable_nfet$3_0.transmission_gate$21_0.out INP_5T 0.08368f
C714 transmission_gate$2$1_6.out programmable_folded_cascode_0.programmable_pfet$1_1.transmission_gate$17_0.out 0.00218f
C715 programmable_5tOTA_0.ena_bar<0> scan_chain_0.D_ff1_4.D_latch1$1_1.Q_bar 0.02576f
C716 programmable_telescopic_cascode_0.programmable_nfet$6_0.transmission_gate$26_0.out programmable_telescopic_cascode_0.programmable_nfet$6_0.d 2.62237f
C717 a_2693_79067# PROG_ENA 0
C718 a_58972_79067# a_60455_79067# 0.00361f
C719 transmission_gate$2$1_5.out programmable_telescopic_cascode_0.programmable_nfet$5_0.transmission_gate$25_0.out 0.3816f
C720 a_5065_79808# transmission_gate$2$1_7.out 0
C721 transmission_gate$2$1_7.out programmable_telescopic_cascode_0.programmable_nfet$4_0.transmission_gate$24_1.out 0.01425f
C722 a_16612_79067# CLK 0.00479f
C723 a_66673_79808# SCAN_OUT 0
C724 transmission_gate$2$1_2.out scan_chain_0.D_ff1_0.D_latch1$1_1.NAND2$2_2.B 0
C725 programmable_folded_cascode_0.EN1 programmable_telescopic_cascode_0.programmable_nfet$4_0.s 0.15046f
C726 transmission_gate$2$1_2.out programmable_5tOTA_0.programmable_pfet$4_0.transmission_gate$27_1.out 0.67712f
C727 programmable_5tOTA_0.ena_bar<0> scan_chain_0.D_ff1_0.D_latch1$1_0.NAND2$2_2.B 0.0392f
C728 programmable_telescopic_cascode_0.programmable_pfet$2_1.transmission_gate$22_0.out INN_FOLDED 0.05166f
C729 transmission_gate$2$1_6.out programmable_telescopic_cascode_0.programmable_nfet$5_1.d 0.0717f
C730 a_56601_79808# PROG_ENA 0
C731 programmable_folded_cascode_0.EN0 programmable_folded_cascode_0.programmable_pfet_0.transmission_gate$16_0.out 0.0687f
C732 scan_chain_0.D_ff1_5.D_latch1$1_1.NAND2$2_0.A scan_chain_0.D_ff1_5.D_latch1$1_1.inv1$3_0.Y 0
C733 scan_chain_0.D_ff1_7.D_latch1$1_0.inv1$3_0.Y transmission_gate$2$1_7.ena 0
C734 transmission_gate$2$1_6.out programmable_telescopic_cascode_0.programmable_pfet$2_0.transmission_gate$22_1.out 0.00504f
C735 programmable_telescopic_cascode_0.programmable_nfet$5_1.transmission_gate$25_0.out programmable_telescopic_cascode_0.programmable_nfet$5_0.transmission_gate$25_1.out 0.35063f
C736 programmable_folded_cascode_0.programmable_pfet$1_0.transmission_gate$17_1.out programmable_folded_cascode_0.programmable_nfet_0.transmission_gate$18_0.out 0.04606f
C737 scan_chain_0.D_ff1_8.D_latch1$1_0.NAND2$2_0.A scan_chain_0.D_ff1_8.inv1$4_0.Y 0.22611f
C738 scan_chain_0.D_ff1_0.inv1$4_0.Y scan_chain_0.D_ff1_0.D_latch1$1_0.inv1$3_0.Y 0.00926f
C739 scan_chain_0.D_ff1_5.D_latch1$1_0.NAND2$2_2.B CLK 0.00592f
C740 transmission_gate$2$1_5.out programmable_telescopic_cascode_0.programmable_pfet$3_0.transmission_gate$23_1.out 0.92922f
C741 a_32014_79808# scan_chain_0.D_ff1_1.D_latch1$1_0.D 0
C742 programmable_common_source_0.EN0 a_56601_79808# 0
C743 transmission_gate$2$1_2.out scan_chain_0.D_ff1_4.D_latch1$1_1.inv1$3_0.Y 0
C744 programmable_folded_cascode_0.programmable_pfet_0.transmission_gate$16_1.out programmable_folded_cascode_0.programmable_pfet$1_0.transmission_gate$17_0.out 0.00223f
C745 scan_chain_0.D_ff1_4.D_latch1$1_0.NAND2$2_2.B VDD 1.06594f
C746 transmission_gate$2$1_3.out a_58972_79067# 0.02046f
C747 transmission_gate$2$1_5.out scan_chain_0.D_ff1_8.D_latch1$1_1.NAND2$2_0.A 0.44675f
C748 scan_chain_0.D_ff1_7.D_latch1$1_0.inv1$3_0.Y a_18095_79067# 0
C749 transmission_gate$2$1_6.out programmable_folded_cascode_0.programmable_nfet$1_1.transmission_gate$19_0.out 0
C750 programmable_common_source_0.EN0 a_64301_79067# 0
C751 scan_chain_0.D_ff1_1.inv1$4_0.Y VDD 0.95855f
C752 transmission_gate$2$1_7.out programmable_telescopic_cascode_0.programmable_nfet$5_0.transmission_gate$25_1.out 0.01591f
C753 transmission_gate$2$1_5.out programmable_telescopic_cascode_0.programmable_pfet$3_1.d 0.37594f
C754 programmable_5tOTA_0.ena_bar<1> a_68156_79067# 0
C755 programmable_telescopic_cascode_0.programmable_nfet$4_1.transmission_gate$24_1.out programmable_telescopic_cascode_0.programmable_nfet$5_1.d 3.29502f
C756 programmable_telescopic_cascode_0.EN0 INP_TELESCOPIC 0.01012f
C757 programmable_folded_cascode_0.EN0 programmable_folded_cascode_0.programmable_nfet$1_0.transmission_gate$19_0.out 0.05068f
C758 scan_chain_0.D_ff1_1.D_latch1$1_1.NAND2$2_0.A VDD 0.77487f
C759 programmable_5tOTA_0.programmable_pfet$4_1.transmission_gate$27_1.out IBIAS 0.00482f
C760 scan_chain_0.D_ff1_8.D_latch1$1_0.D a_25797_79808# 0.16273f
C761 scan_chain_0.D_ff1_0.D_latch1$1_1.Q_bar a_64301_79067# 0.16279f
C762 programmable_folded_cascode_0.EN0 programmable_folded_cascode_0.OUT 0.37292f
C763 programmable_telescopic_cascode_0.programmable_pfet$2_0.g programmable_telescopic_cascode_0.programmable_nfet$4_1.transmission_gate$24_0.out 0.04017f
C764 programmable_telescopic_cascode_0.programmable_nfet$4_0.g INN_FOLDED 0.07836f
C765 scan_chain_0.D_ff1_3.D_latch1$1_0.inv1$3_0.Y a_48899_79067# 0
C766 programmable_folded_cascode_0.programmable_nfet$2_0.transmission_gate$20_0.out INP_5T 0.08445f
C767 programmable_folded_cascode_0.programmable_nfet$2_0.transmission_gate$20_0.out programmable_folded_cascode_0.programmable_nfet$1_0.g 0
C768 programmable_folded_cascode_0.EN1 programmable_folded_cascode_0.programmable_nfet_0.transmission_gate$18_0.out 0
C769 programmable_folded_cascode_0.programmable_pfet_0.g programmable_folded_cascode_0.programmable_pfet_1.transmission_gate$16_1.out 0.68f
C770 scan_chain_0.D_ff1_3.D_latch1$1_0.inv1$3_0.Y VDD 0.37869f
C771 programmable_common_source_0.EN0 scan_chain_0.D_ff1_4.D_latch1$1_0.NAND2$2_2.B 0
C772 transmission_gate$2$1_3.out scan_chain_0.D_ff1_3.D_latch1$1_1.NAND2$2_2.B 0.00915f
C773 scan_chain_0.D_ff1_8.D_latch1$1_1.Q_bar PROG_ENA 0.00175f
C774 programmable_folded_cascode_0.programmable_pfet$1_0.transmission_gate$17_0.out INP_5T 0.054f
C775 programmable_folded_cascode_0.OUT programmable_folded_cascode_0.programmable_nfet$2_0.g 0.07715f
C776 programmable_telescopic_cascode_0.programmable_nfet$5_0.transmission_gate$25_0.out programmable_telescopic_cascode_0.programmable_nfet$6_0.transmission_gate$26_1.out 0.34869f
C777 programmable_5tOTA_0.ena_bar<0> a_56601_79808# 0
C778 a_1210_79067# PROG_ENA 0.00112f
C779 VDD INN_5T 10.4537f
C780 a_18096_79808# scan_chain_0.D_ff1_7.D_latch1$1_1.Q_bar 0.01093f
C781 programmable_folded_cascode_0.programmable_pfet$1_0.g programmable_folded_cascode_0.OUT 2.31349f
C782 programmable_folded_cascode_0.EN0 a_8911_79067# 0
C783 programmable_5tOTA_0.ena_bar<0> a_64301_79067# 0.0119f
C784 transmission_gate$2$1_7.out programmable_telescopic_cascode_0.programmable_pfet$3_1.transmission_gate$23_0.out 0.01434f
C785 transmission_gate$2$1_7.out scan_chain_0.D_ff1_6.D_latch1$1_1.NAND2$2_2.B 0.00248f
C786 scan_chain_0.D_ff1_4.D_latch1$1_0.inv1$3_0.Y CLK 0.00358f
C787 programmable_5tOTA_0.ena_bar<1> scan_chain_0.D_ff1_4.D_latch1$1_0.NAND2$2_0.A 0.06699f
C788 scan_chain_0.D_ff1_2.D_latch1$1_1.Q_bar scan_chain_0.D_ff1_2.D_latch1$1_0.NAND2$2_0.A 0
C789 scan_chain_0.D_ff1_2.D_latch1$1_0.D VDD 1.54258f
C790 scan_chain_0.D_ff1_5.D_latch1$1_0.NAND2$2_0.A scan_chain_0.D_ff1_5.D_latch1$1_0.inv1$3_0.Y 0
C791 a_14249_79067# transmission_gate$2$1_7.ena 0
C792 transmission_gate$2$1_4.out OUT_TELESCOPIC 0.11598f
C793 scan_chain_0.D_ff1_5.D_latch1$1_1.NAND2$2_0.A SCAN_IN 0.46456f
C794 transmission_gate$2$1_7.out programmable_folded_cascode_0.programmable_pfet_1.transmission_gate$16_0.out 1.64689f
C795 scan_chain_0.D_ff1_8.D_latch1$1_0.NAND2$2_0.A a_28168_79808# 0.23035f
C796 VDD OUT_5T 37.49f
C797 transmission_gate$2$1_3.out scan_chain_0.D_ff1_2.D_latch1$1_1.inv1$3_0.Y 0.32602f
C798 transmission_gate$2$1_5.out programmable_telescopic_cascode_0.programmable_pfet$3_1.transmission_gate$23_1.out 0.99685f
C799 transmission_gate$2$1_2.out a_48899_79067# 0
C800 scan_chain_0.D_ff1_7.inv1$4_0.Y PROG_ENA 0.44521f
C801 programmable_5tOTA_0.programmable_nfet$7_1.transmission_gate$28_1.out VDD 0.35388f
C802 OUT_TELESCOPIC INP_5T 0.50758f
C803 scan_chain_0.D_ff1_5.D_latch1$1_1.Q_bar scan_chain_0.D_ff1_5.D_latch1$1_1.NAND2$2_2.B 0.13783f
C804 transmission_gate$2$1_2.out VDD 14.3316f
C805 scan_chain_0.D_ff1_2.inv1$4_0.Y scan_chain_0.D_ff1_2.D_latch1$1_0.inv1$3_0.Y 0.00878f
C806 programmable_common_source_0.EN0 a_62818_79067# 0
C807 a_35869_79808# VDD 0.00283f
C808 programmable_5tOTA_0.ena_bar<1> programmable_5tOTA_0.programmable_nfet$7_0.transmission_gate$28_1.out 0.02451f
C809 scan_chain_0.D_ff1_6.D_latch1$1_0.D transmission_gate$2$1_7.ena 0
C810 scan_chain_0.D_ff1_3.inv1$4_0.Y a_52754_79067# 0
C811 programmable_5tOTA_0.ena_bar<1> a_66673_79067# 0
C812 a_24313_79808# a_25797_79808# 0.00361f
C813 scan_chain_0.D_ff1_3.D_latch1$1_0.NAND2$2_2.B PROG_ENA 0.00233f
C814 scan_chain_0.D_ff1_3.D_latch1$1_0.D scan_chain_0.D_ff1_3.D_latch1$1_0.NAND2$2_2.B 0.00115f
C815 a_64302_79808# a_64301_79067# 0
C816 programmable_common_source_0.EN1 transmission_gate$2$1_7.ena 0.01617f
C817 transmission_gate$2$1_7.out programmable_telescopic_cascode_0.programmable_pfet$2_0.g 0.16881f
C818 transmission_gate$2$1_2.out scan_chain_0.D_ff1_0.Q_bar 0.00581f
C819 programmable_telescopic_cascode_0.EN1 scan_chain_0.D_ff1_1.D_latch1$1_0.D 0
C820 programmable_telescopic_cascode_0.programmable_pfet$3_0.g programmable_telescopic_cascode_0.programmable_nfet$4_0.transmission_gate$24_0.out 6.22457f
C821 scan_chain_0.D_ff1_2.D_latch1$1_1.Q_bar a_41198_79067# 0.16279f
C822 transmission_gate$2$1_3.out programmable_5tOTA_0.programmable_nfet$7_1.transmission_gate$28_0.out 0.45299f
C823 programmable_telescopic_cascode_0.programmable_pfet$3_0.transmission_gate$23_1.out programmable_telescopic_cascode_0.programmable_pfet$3_0.transmission_gate$23_0.out 0.00238f
C824 transmission_gate$2$1_3.out scan_chain_0.D_ff1_0.inv1$4_0.Y 0.00956f
C825 scan_chain_0.D_ff1_6.D_latch1$1_0.inv1$3_0.Y scan_chain_0.D_ff1_6.D_latch1$1_0.NAND2$2_2.B 0.44289f
C826 a_45053_79067# VDD 0.01219f
C827 transmission_gate$2$1_6.out transmission_gate$2$1_7.ena 0.09999f
C828 transmission_gate$2$1_2.out programmable_common_source_0.EN0 0.00371f
C829 transmission_gate$2$1_3.out scan_chain_0.D_ff1_0.D_latch1$1_1.NAND2$2_0.A 0.00107f
C830 scan_chain_0.D_ff1_7.D_latch1$1_0.D CLK 0.00906f
C831 a_25797_79808# PROG_ENA 0
C832 programmable_common_source_0.EN0 scan_chain_0.D_ff1_3.D_latch1$1_0.NAND2$2_2.B 0.01636f
C833 scan_chain_0.D_ff1_1.inv1$4_0.Y scan_chain_0.D_ff1_1.D_latch1$1_0.NAND2$2_2.B 0.40095f
C834 scan_chain_0.D_ff1_1.D_latch1$1_0.NAND2$2_0.A a_37352_79067# 0
C835 programmable_folded_cascode_0.EN1 programmable_folded_cascode_0.programmable_pfet_0.g 1.88133f
C836 programmable_5tOTA_0.ena_bar<1> scan_chain_0.D_ff1_4.D_latch1$1_0.inv1$3_0.Y 0
C837 scan_chain_0.D_ff1_1.D_latch1$1_0.D a_33497_79067# 0.02982f
C838 programmable_telescopic_cascode_0.programmable_pfet$3_0.transmission_gate$23_0.out programmable_telescopic_cascode_0.programmable_pfet$3_1.d 0.05616f
C839 transmission_gate$2$1_7.ena IBIAS 1.16688f
C840 scan_chain_0.D_ff1_2.D_latch1$1_0.inv1$3_0.Y PROG_ENA 0.00134f
C841 programmable_telescopic_cascode_0.EN1 transmission_gate$2$1_3.out 0
C842 programmable_telescopic_cascode_0.programmable_pfet$3_0.d OUT_TELESCOPIC 1.30438f
C843 a_52754_79067# CLK 0
C844 scan_chain_0.D_ff1_2.D_latch1$1_1.Q_bar CLK 0.00483f
C845 programmable_5tOTA_0.ena_bar<0> a_62818_79067# 0.0119f
C846 scan_chain_0.D_ff1_4.inv1$4_0.Y SCAN_OUT 0.01465f
C847 programmable_telescopic_cascode_0.EN1 programmable_telescopic_cascode_0.programmable_pfet$2_1.transmission_gate$22_0.out 0.01324f
C848 transmission_gate$2$1_4.out programmable_telescopic_cascode_0.programmable_nfet$4_1.transmission_gate$24_0.out 0.15358f
C849 transmission_gate$2$1_5.out CLK 0.09643f
C850 scan_chain_0.D_ff1_2.D_latch1$1_0.inv1$3_0.Y scan_chain_0.D_ff1_2.D_latch1$1_0.NAND2$2_2.B 0.44289f
C851 scan_chain_0.D_ff1_3.D_latch1$1_0.D scan_chain_0.D_ff1_3.D_latch1$1_1.Q_bar 1.69947f
C852 a_39715_79808# VDD 0.00189f
C853 a_12766_79067# transmission_gate$2$1_7.ena 0
C854 scan_chain_0.D_ff1_3.D_latch1$1_1.Q_bar PROG_ENA 0.00175f
C855 scan_chain_0.D_ff1_6.inv1$4_0.Y scan_chain_0.D_ff1_6.D_latch1$1_0.inv1$3_0.Y 0.00878f
C856 programmable_folded_cascode_0.programmable_pfet$1_1.transmission_gate$17_0.out VDD 1.66158f
C857 transmission_gate$2$1_2.out a_47416_79067# 0.00198f
C858 transmission_gate$2$1_2.out scan_chain_0.D_ff1_0.D_latch1$1_0.D 0.02594f
C859 programmable_telescopic_cascode_0.programmable_nfet$4_1.transmission_gate$24_0.out INP_5T 0.0483f
C860 transmission_gate$2$1_3.out OUT_CS 0.11194f
C861 transmission_gate$2$1_7.ena programmable_telescopic_cascode_0.programmable_nfet$4_1.transmission_gate$24_1.out 0
C862 programmable_telescopic_cascode_0.programmable_pfet$2_1.transmission_gate$22_1.out programmable_telescopic_cascode_0.programmable_pfet$2_0.g 0.21836f
C863 programmable_5tOTA_0.ena_bar<0> scan_chain_0.D_ff1_3.D_latch1$1_0.NAND2$2_2.B 0.04157f
C864 programmable_telescopic_cascode_0.programmable_nfet$4_0.transmission_gate$24_1.out programmable_folded_cascode_0.OUT 0.02125f
C865 scan_chain_0.D_ff1_7.inv1$4_0.Y programmable_telescopic_cascode_0.EN0 0.00207f
C866 programmable_telescopic_cascode_0.programmable_nfet$5_1.d VDD 3.08116f
C867 scan_chain_0.D_ff1_6.D_latch1$1_1.Q_bar a_10394_79067# 0.16279f
C868 scan_chain_0.D_ff1_5.D_latch1$1_1.NAND2$2_2.B transmission_gate$2$1_7.ena 0
C869 transmission_gate$2$1_6.out programmable_folded_cascode_0.programmable_nfet_0.transmission_gate$18_1.out 0.44212f
C870 scan_chain_0.D_ff1_3.inv1$4_0.Y a_51271_79067# 0.00477f
C871 programmable_telescopic_cascode_0.programmable_pfet$2_0.transmission_gate$22_1.out VDD 1.92433f
C872 programmable_telescopic_cascode_0.programmable_nfet$4_0.s INN_FOLDED 0.15799f
C873 transmission_gate$2$1_2.out a_68157_79808# 0
C874 programmable_common_source_0.programmable_pfet$5_0.transmission_gate$30_1.out programmable_common_source_0.programmable_pfet$5_0.transmission_gate$30_0.out 0.00138f
C875 programmable_common_source_0.EN1 a_68156_79067# 0
C876 programmable_telescopic_cascode_0.EN1 programmable_telescopic_cascode_0.programmable_nfet$4_0.g 0.01795f
C877 transmission_gate$2$1_4.out programmable_telescopic_cascode_0.programmable_nfet$5_1.transmission_gate$25_0.out 0.1502f
C878 scan_chain_0.D_ff1_0.D_latch1$1_0.NAND2$2_0.A VDD 0.77786f
C879 programmable_telescopic_cascode_0.programmable_pfet$3_0.g programmable_telescopic_cascode_0.programmable_pfet$3_0.transmission_gate$23_1.out 0.253f
C880 transmission_gate$2$1_6.out INP_FOLDED 0.06434f
C881 a_41199_79808# a_41198_79067# 0
C882 scan_chain_0.D_ff1_3.D_latch1$1_0.NAND2$2_0.A scan_chain_0.D_ff1_3.inv1$4_0.Y 0.22611f
C883 transmission_gate$2$1_3.out a_66673_79808# 0
C884 a_43570_79067# VDD 0.0098f
C885 transmission_gate$2$1_2.out a_52755_79808# 0
C886 programmable_5tOTA_0.ena_bar<0> scan_chain_0.D_ff1_2.D_latch1$1_0.inv1$3_0.Y 0.0308f
C887 scan_chain_0.D_ff1_6.D_latch1$1_1.NAND2$2_2.B a_10394_79067# 0.00415f
C888 transmission_gate$2$1_7.out programmable_folded_cascode_0.programmable_pfet_0.transmission_gate$16_1.out 0.08987f
C889 a_16612_79808# CLK 0.00415f
C890 scan_chain_0.D_ff1_1.D_latch1$1_0.NAND2$2_0.A a_35869_79067# 0.02432f
C891 programmable_folded_cascode_0.programmable_nfet$1_1.transmission_gate$19_0.out VDD 0.13372f
C892 scan_chain_0.D_ff1_6.D_latch1$1_1.Q_bar scan_chain_0.D_ff1_6.D_latch1$1_0.NAND2$2_0.A 0
C893 programmable_5tOTA_0.ena_bar<0> scan_chain_0.D_ff1_3.D_latch1$1_1.Q_bar 0.02576f
C894 programmable_5tOTA_0.ena_bar<1> a_52754_79067# 0
C895 programmable_folded_cascode_0.programmable_nfet_1.transmission_gate$18_0.out INP_FOLDED 0.21465f
C896 scan_chain_0.D_ff1_0.D_latch1$1_0.NAND2$2_0.A scan_chain_0.D_ff1_0.Q_bar 0.02095f
C897 a_37352_79067# PROG_ENA 0
C898 programmable_folded_cascode_0.EN1 programmable_telescopic_cascode_0.programmable_nfet$4_0.transmission_gate$24_0.out 0.02192f
C899 programmable_5tOTA_0.programmable_pfet$4_1.transmission_gate$27_1.out VDD 2.52826f
C900 programmable_telescopic_cascode_0.programmable_pfet$3_0.g programmable_telescopic_cascode_0.programmable_pfet$3_1.d 4.5389f
C901 a_51271_79067# CLK 0
C902 a_58972_79808# SCAN_OUT 0.00926f
C903 a_41199_79808# CLK 0
C904 transmission_gate$2$1_7.out transmission_gate$2$1_4.out 0.12519f
C905 programmable_telescopic_cascode_0.programmable_nfet$4_1.transmission_gate$24_0.out PROG_ENA 0
C906 scan_chain_0.D_ff1_8.D_latch1$1_0.NAND2$2_0.A scan_chain_0.D_ff1_8.D_latch1$1_0.NAND2$2_2.B 0.01576f
C907 a_48900_79808# PROG_ENA 0
C908 scan_chain_0.D_ff1_3.D_latch1$1_0.D a_48900_79808# 0.16273f
C909 scan_chain_0.D_ff1_8.D_latch1$1_0.D scan_chain_0.D_ff1_8.D_latch1$1_1.NAND2$2_2.B 0.01594f
C910 transmission_gate$2$1_6.out a_16612_79067# 0
C911 programmable_telescopic_cascode_0.programmable_nfet$6_0.transmission_gate$26_1.out CLK 0
C912 scan_chain_0.D_ff1_8.D_latch1$1_1.NAND2$2_0.A a_25796_79067# 0
C913 scan_chain_0.D_ff1_2.D_latch1$1_1.NAND2$2_2.B a_41198_79067# 0.00415f
C914 scan_chain_0.D_ff1_1.D_latch1$1_1.NAND2$2_2.B VDD 1.09261f
C915 scan_chain_0.D_ff1_4.D_latch1$1_0.NAND2$2_0.A programmable_common_source_0.EN1 0.02095f
C916 scan_chain_0.D_ff1_5.D_latch1$1_1.Q_bar VDD 0.89878f
C917 programmable_telescopic_cascode_0.programmable_nfet$4_0.g programmable_telescopic_cascode_0.programmable_nfet$4_0.s 4.09981f
C918 scan_chain_0.D_ff1_4.D_latch1$1_1.inv1$3_0.Y transmission_gate$2$1_7.ena 0
C919 transmission_gate$2$1_7.out programmable_folded_cascode_0.programmable_nfet$1_0.g 0.20208f
C920 programmable_telescopic_cascode_0.EN0 OUT_TELESCOPIC 0
C921 programmable_telescopic_cascode_0.programmable_nfet$4_1.transmission_gate$24_1.out INP_FOLDED 0.04665f
C922 programmable_telescopic_cascode_0.EN1 scan_chain_0.D_ff1_2.D_latch1$1_1.inv1$3_0.Y 0
C923 transmission_gate$2$1_7.out INP_5T 0.66391f
C924 transmission_gate$2$1_2.out a_62818_79808# 0
C925 scan_chain_0.D_ff1_7.D_latch1$1_0.D scan_chain_0.D_ff1_7.D_latch1$1_0.inv1$3_0.Y 0.29948f
C926 transmission_gate$2$1_4.out programmable_telescopic_cascode_0.programmable_nfet$6_0.transmission_gate$26_0.out 0.09211f
C927 programmable_folded_cascode_0.programmable_nfet_0.transmission_gate$18_0.out INN_FOLDED 0.20292f
C928 scan_chain_0.D_ff1_8.D_latch1$1_1.Q_bar a_28168_79067# 0
C929 scan_chain_0.D_ff1_2.D_latch1$1_1.NAND2$2_2.B CLK 0.40703f
C930 INN_TELESCOPIC OUT_TELESCOPIC 0.37529f
C931 programmable_telescopic_cascode_0.programmable_pfet$3_1.transmission_gate$23_0.out programmable_folded_cascode_0.OUT 0.05226f
C932 scan_chain_0.D_ff1_7.inv1$4_0.Y a_21951_79808# 0
C933 transmission_gate$2$1_6.out programmable_folded_cascode_0.programmable_nfet$3_0.transmission_gate$21_1.out 0.41032f
C934 programmable_telescopic_cascode_0.programmable_pfet$3_0.transmission_gate$23_0.out CLK 0
C935 a_51271_79808# a_51271_79067# 0
C936 a_10395_79808# a_10394_79067# 0
C937 programmable_folded_cascode_0.EN0 programmable_folded_cascode_0.programmable_pfet$1_1.transmission_gate$17_0.out 0.00672f
C938 programmable_folded_cascode_0.programmable_nfet$3_0.transmission_gate$21_1.out IBIAS 0.17476f
C939 a_56601_79808# scan_chain_0.D_ff1_4.D_latch1$1_1.Q_bar 0.01093f
C940 scan_chain_0.D_ff1_1.inv1$4_0.Y programmable_telescopic_cascode_0.programmable_nfet$4_0.transmission_gate$24_1.out 0
C941 scan_chain_0.D_ff1_8.D_latch1$1_1.inv1$3_0.Y VDD 0.38905f
C942 programmable_folded_cascode_0.EN1 programmable_telescopic_cascode_0.programmable_nfet$5_0.transmission_gate$25_0.out 0.0274f
C943 programmable_common_source_0.EN1 a_66673_79067# 0
C944 scan_chain_0.D_ff1_7.D_latch1$1_1.Q_bar scan_chain_0.D_ff1_7.D_latch1$1_0.NAND2$2_2.B 0.00216f
C945 programmable_telescopic_cascode_0.programmable_nfet$5_1.transmission_gate$25_0.out PROG_ENA 0
C946 scan_chain_0.D_ff1_0.D_latch1$1_0.D scan_chain_0.D_ff1_0.D_latch1$1_0.NAND2$2_0.A 0.44673f
C947 scan_chain_0.D_ff1_5.D_latch1$1_0.D PROG_ENA 0.00152f
C948 programmable_folded_cascode_0.programmable_pfet_1.transmission_gate$16_0.out programmable_folded_cascode_0.OUT 0.0528f
C949 scan_chain_0.D_ff1_2.inv1$4_0.Y programmable_telescopic_cascode_0.programmable_nfet$6_0.transmission_gate$26_0.out 0
C950 scan_chain_0.D_ff1_3.D_latch1$1_0.NAND2$2_0.A a_51271_79808# 0.23035f
C951 transmission_gate$2$1_4.out programmable_telescopic_cascode_0.programmable_pfet$2_1.transmission_gate$22_1.out 0.10627f
C952 programmable_telescopic_cascode_0.programmable_pfet$3_1.transmission_gate$23_1.out programmable_telescopic_cascode_0.programmable_pfet$3_0.g 0.22768f
C953 programmable_folded_cascode_0.EN0 programmable_telescopic_cascode_0.programmable_nfet$5_1.d 0.0459f
C954 scan_chain_0.D_ff1_1.D_latch1$1_1.inv1$3_0.Y CLK 0.02415f
C955 scan_chain_0.D_ff1_6.D_latch1$1_1.NAND2$2_2.B a_8911_79067# 0.16593f
C956 programmable_5tOTA_0.ena_bar<0> a_37352_79067# 0.16279f
C957 programmable_folded_cascode_0.programmable_pfet$1_0.g programmable_folded_cascode_0.programmable_pfet$1_1.transmission_gate$17_0.out 0.23412f
C958 programmable_folded_cascode_0.EN0 programmable_telescopic_cascode_0.programmable_pfet$2_0.transmission_gate$22_1.out 0.04097f
C959 transmission_gate$2$1_7.out programmable_telescopic_cascode_0.programmable_pfet$3_0.d 0.0906f
C960 a_32014_79808# a_32014_79067# 0
C961 programmable_5tOTA_0.ena_bar<0> a_48900_79808# 0
C962 programmable_5tOTA_0.ena_bar<1> a_51271_79067# 0
C963 a_35869_79067# PROG_ENA 0
C964 scan_chain_0.D_ff1_0.D_latch1$1_0.NAND2$2_0.A a_68157_79808# 0.00428f
C965 transmission_gate$2$1_7.out PROG_ENA 0.18197f
C966 programmable_telescopic_cascode_0.programmable_pfet$2_1.transmission_gate$22_1.out INP_5T 0.03019f
C967 programmable_folded_cascode_0.EN1 programmable_telescopic_cascode_0.programmable_pfet$3_0.transmission_gate$23_1.out 0.0137f
C968 programmable_telescopic_cascode_0.programmable_pfet$2_0.g programmable_folded_cascode_0.OUT 0.09819f
C969 programmable_5tOTA_0.ena_bar<1> scan_chain_0.D_ff1_3.D_latch1$1_0.NAND2$2_0.A 0.06699f
C970 a_47416_79808# a_48900_79808# 0.00361f
C971 scan_chain_0.D_ff1_2.D_latch1$1_1.NAND2$2_2.B a_39715_79067# 0.16593f
C972 scan_chain_0.D_ff1_8.D_latch1$1_1.NAND2$2_0.A a_24313_79067# 0.02432f
C973 programmable_folded_cascode_0.EN0 programmable_folded_cascode_0.programmable_nfet$1_1.transmission_gate$19_0.out 0.05062f
C974 scan_chain_0.D_ff1_4.D_latch1$1_0.NAND2$2_0.A a_60456_79808# 0.00428f
C975 programmable_telescopic_cascode_0.EN0 programmable_telescopic_cascode_0.programmable_nfet$4_1.transmission_gate$24_0.out 0.0018f
C976 a_2694_79808# VDD 0.00815f
C977 scan_chain_0.D_ff1_5.D_latch1$1_0.inv1$3_0.Y a_5065_79067# 0.00457f
C978 programmable_common_source_0.programmable_pfet$5_0.transmission_gate$30_1.out SCAN_OUT 0.00324f
C979 a_48899_79067# transmission_gate$2$1_7.ena 0
C980 programmable_folded_cascode_0.EN1 programmable_telescopic_cascode_0.programmable_pfet$3_1.d 0.16878f
C981 programmable_telescopic_cascode_0.programmable_nfet$6_0.transmission_gate$26_0.out PROG_ENA 0
C982 programmable_folded_cascode_0.programmable_nfet$2_0.g programmable_folded_cascode_0.programmable_nfet$1_1.transmission_gate$19_0.out 0.13705f
C983 scan_chain_0.D_ff1_7.D_latch1$1_1.NAND2$2_0.A scan_chain_0.D_ff1_7.D_latch1$1_1.NAND2$2_2.B 0.01576f
C984 transmission_gate$2$1_7.ena VDD 0.94132f
C985 programmable_telescopic_cascode_0.programmable_nfet$4_1.transmission_gate$24_0.out INN_TELESCOPIC 0.03768f
C986 scan_chain_0.D_ff1_4.inv1$4_0.Y a_60455_79067# 0
C987 scan_chain_0.D_ff1_4.D_latch1$1_0.D scan_chain_0.D_ff1_4.D_latch1$1_0.NAND2$2_2.B 0.00115f
C988 scan_chain_0.D_ff1_8.D_latch1$1_1.NAND2$2_2.B PROG_ENA 0.00233f
C989 programmable_folded_cascode_0.programmable_pfet$1_0.g programmable_folded_cascode_0.programmable_nfet$1_1.transmission_gate$19_0.out 0.19797f
C990 a_20467_79808# a_21951_79808# 0.00361f
C991 programmable_folded_cascode_0.programmable_pfet_0.g INN_FOLDED 0.11084f
C992 scan_chain_0.D_ff1_1.D_latch1$1_0.inv1$3_0.Y a_35869_79067# 0.00457f
C993 programmable_telescopic_cascode_0.EN1 programmable_telescopic_cascode_0.programmable_nfet$4_0.s 0
C994 a_18095_79067# VDD 0.03961f
C995 programmable_telescopic_cascode_0.programmable_pfet$2_1.transmission_gate$22_1.out programmable_telescopic_cascode_0.programmable_pfet$3_0.d 0.13421f
C996 a_66673_79808# scan_chain_0.D_ff1_0.inv1$4_0.Y 0.00415f
C997 programmable_common_source_0.EN1 scan_chain_0.D_ff1_4.D_latch1$1_0.NAND2$2_2.B 0.01632f
C998 programmable_telescopic_cascode_0.programmable_pfet$2_0.transmission_gate$22_0.out OUT_TELESCOPIC 0.1379f
C999 a_1210_79808# PROG_ENA 0
C1000 programmable_common_source_0.EN0 transmission_gate$2$1_7.ena 0.09905f
C1001 programmable_folded_cascode_0.programmable_pfet_0.transmission_gate$16_0.out programmable_folded_cascode_0.programmable_pfet_0.transmission_gate$16_1.out 0.00138f
C1002 scan_chain_0.D_ff1_7.D_latch1$1_1.inv1$3_0.Y PROG_ENA 0.00134f
C1003 programmable_telescopic_cascode_0.programmable_pfet$2_1.transmission_gate$22_1.out PROG_ENA 0
C1004 programmable_telescopic_cascode_0.EN0 programmable_telescopic_cascode_0.programmable_nfet$5_1.transmission_gate$25_0.out 0.00185f
C1005 a_37353_79808# a_37352_79067# 0
C1006 a_25796_79067# CLK 0
C1007 programmable_folded_cascode_0.programmable_pfet_0.g programmable_folded_cascode_0.programmable_nfet_1.transmission_gate$18_1.out 0.06515f
C1008 transmission_gate$2$1_3.out scan_chain_0.D_ff1_4.inv1$4_0.Y 0.00956f
C1009 programmable_5tOTA_0.ena_bar<1> programmable_common_source_0.programmable_pfet$5_0.transmission_gate$30_0.out 0.01822f
C1010 transmission_gate$2$1_3.out scan_chain_0.D_ff1_4.D_latch1$1_1.NAND2$2_0.A 0.00107f
C1011 programmable_folded_cascode_0.programmable_nfet_0.transmission_gate$18_1.out VDD 0.26499f
C1012 programmable_telescopic_cascode_0.programmable_nfet$5_1.transmission_gate$25_0.out INN_TELESCOPIC 0.21184f
C1013 transmission_gate$2$1_3.out programmable_5tOTA_0.programmable_nfet$8_0.transmission_gate$29_1.out 0
C1014 programmable_folded_cascode_0.EN1 programmable_telescopic_cascode_0.programmable_pfet$3_1.transmission_gate$23_1.out 0.0137f
C1015 a_29652_79808# programmable_telescopic_cascode_0.EN1 0.01093f
C1016 transmission_gate$2$1_7.out programmable_telescopic_cascode_0.EN0 0.0019f
C1017 programmable_telescopic_cascode_0.programmable_nfet$5_1.d programmable_telescopic_cascode_0.programmable_nfet$6_0.d 5.53783f
C1018 a_1210_79067# a_2693_79067# 0.00361f
C1019 scan_chain_0.D_ff1_5.D_latch1$1_1.inv1$3_0.Y PROG_ENA 0.00848f
C1020 a_47416_79067# transmission_gate$2$1_7.ena 0
C1021 programmable_folded_cascode_0.programmable_pfet_0.transmission_gate$16_0.out INP_5T 0.06038f
C1022 VDD INP_FOLDED 11.3484f
C1023 programmable_telescopic_cascode_0.EN1 a_32014_79067# 0
C1024 scan_chain_0.D_ff1_5.D_latch1$1_1.NAND2$2_0.A scan_chain_0.D_ff1_5.D_latch1$1_1.Q_bar 0.02095f
C1025 transmission_gate$2$1_7.out INN_TELESCOPIC 0.01166f
C1026 programmable_folded_cascode_0.programmable_pfet_0.transmission_gate$16_1.out programmable_folded_cascode_0.OUT 0.10463f
C1027 a_68156_79067# VDD 0.01497f
C1028 transmission_gate$2$1_6.out transmission_gate$2$1_5.out 0.04801f
C1029 scan_chain_0.D_ff1_4.inv1$4_0.Y a_58972_79067# 0.00477f
C1030 a_52754_79067# IBIAS 0
C1031 transmission_gate$2$1_2.out scan_chain_0.D_ff1_4.D_latch1$1_0.D 0.02594f
C1032 programmable_telescopic_cascode_0.EN0 programmable_telescopic_cascode_0.programmable_nfet$6_0.transmission_gate$26_0.out 0
C1033 transmission_gate$2$1_5.out IBIAS 0.06826f
C1034 programmable_telescopic_cascode_0.programmable_nfet$4_0.transmission_gate$24_1.out programmable_telescopic_cascode_0.programmable_nfet$5_1.d 0.02755f
C1035 programmable_telescopic_cascode_0.EN0 scan_chain_0.D_ff1_8.D_latch1$1_1.NAND2$2_2.B 0.0022f
C1036 a_32014_79067# a_33497_79067# 0.00361f
C1037 scan_chain_0.D_ff1_0.Q_bar a_68156_79067# 0.16279f
C1038 programmable_folded_cascode_0.EN0 transmission_gate$2$1_7.ena 0.08458f
C1039 CLK SCAN_OUT 0.01397f
C1040 a_16612_79067# VDD 0.01142f
C1041 programmable_telescopic_cascode_0.programmable_nfet$4_0.transmission_gate$24_0.out INN_FOLDED 0.04893f
C1042 scan_chain_0.D_ff1_1.D_latch1$1_0.NAND2$2_2.B transmission_gate$2$1_7.ena 0
C1043 programmable_folded_cascode_0.programmable_nfet$1_0.transmission_gate$19_0.out INP_5T 0.04722f
C1044 transmission_gate$2$1_6.out programmable_telescopic_cascode_0.programmable_nfet$5_1.transmission_gate$25_1.out 0.01127f
C1045 programmable_folded_cascode_0.programmable_nfet$1_0.transmission_gate$19_0.out programmable_folded_cascode_0.programmable_nfet$1_0.g 0.19682f
C1046 programmable_common_source_0.EN0 a_68156_79067# 0
C1047 transmission_gate$2$1_2.out programmable_common_source_0.EN1 0.02663f
C1048 a_10394_79067# PROG_ENA 0
C1049 programmable_folded_cascode_0.OUT programmable_folded_cascode_0.programmable_nfet$1_0.g 0.57326f
C1050 a_62818_79067# a_64301_79067# 0.00361f
C1051 programmable_folded_cascode_0.OUT INP_5T 0.94514f
C1052 a_24313_79067# CLK 0.00479f
C1053 scan_chain_0.D_ff1_4.D_latch1$1_0.NAND2$2_0.A VDD 0.78146f
C1054 programmable_folded_cascode_0.EN1 CLK 0.07532f
C1055 transmission_gate$2$1_5.out programmable_telescopic_cascode_0.programmable_nfet$4_1.transmission_gate$24_1.out 0.72365f
C1056 programmable_telescopic_cascode_0.EN0 programmable_telescopic_cascode_0.programmable_pfet$2_1.transmission_gate$22_1.out 0.00879f
C1057 transmission_gate$2$1_3.out a_58972_79808# 0
C1058 programmable_folded_cascode_0.programmable_nfet$3_0.transmission_gate$21_1.out VDD 0.36034f
C1059 scan_chain_0.D_ff1_1.D_latch1$1_0.D scan_chain_0.D_ff1_1.D_latch1$1_1.Q_bar 1.69947f
C1060 scan_chain_0.D_ff1_5.D_latch1$1_0.NAND2$2_2.B VDD 1.11386f
C1061 transmission_gate$2$1_6.out a_16612_79808# 0.0043f
C1062 INP_TELESCOPIC OUT_TELESCOPIC 0
C1063 programmable_telescopic_cascode_0.programmable_pfet$2_1.transmission_gate$22_1.out INN_TELESCOPIC 0.02355f
C1064 scan_chain_0.D_ff1_8.D_latch1$1_0.inv1$3_0.Y transmission_gate$2$1_7.ena 0
C1065 programmable_common_source_0.programmable_nfet$9_0.transmission_gate$31_0.out OUT_CS 0.72649f
C1066 scan_chain_0.D_ff1_6.D_latch1$1_0.NAND2$2_2.B CLK 0.00592f
C1067 programmable_folded_cascode_0.EN0 programmable_folded_cascode_0.programmable_nfet_0.transmission_gate$18_1.out 0
C1068 programmable_telescopic_cascode_0.programmable_nfet$4_0.g programmable_telescopic_cascode_0.programmable_nfet$4_0.transmission_gate$24_0.out 0.27503f
C1069 transmission_gate$2$1_7.out programmable_folded_cascode_0.programmable_pfet$1_1.transmission_gate$17_1.out 0.00346f
C1070 transmission_gate$2$1_2.out scan_chain_0.D_ff1_0.D_latch1$1_1.inv1$3_0.Y 0
C1071 SCAN_IN PROG_ENA 0.01807f
C1072 scan_chain_0.D_ff1_5.D_latch1$1_1.NAND2$2_0.A a_2694_79808# 0.00428f
C1073 a_66673_79067# VDD 0.01457f
C1074 programmable_5tOTA_0.programmable_nfet$7_0.transmission_gate$28_1.out VDD 0.35399f
C1075 scan_chain_0.D_ff1_5.inv1$4_0.Y transmission_gate$2$1_7.ena 0.00353f
C1076 scan_chain_0.D_ff1_8.D_latch1$1_1.inv1$3_0.Y a_21950_79067# 0
C1077 transmission_gate$2$1_6.out programmable_telescopic_cascode_0.programmable_nfet$6_0.transmission_gate$26_1.out 0.01777f
C1078 a_58972_79808# a_58972_79067# 0
C1079 a_51271_79067# IBIAS 0.00568f
C1080 programmable_telescopic_cascode_0.programmable_pfet$3_0.d programmable_folded_cascode_0.OUT 0.32431f
C1081 transmission_gate$2$1_3.out programmable_5tOTA_0.programmable_pfet$4_0.transmission_gate$27_0.out 0.00263f
C1082 transmission_gate$2$1_2.out a_55117_79808# 0
C1083 programmable_folded_cascode_0.programmable_nfet$3_0.g programmable_folded_cascode_0.programmable_nfet$3_0.transmission_gate$21_1.out 0.20445f
C1084 programmable_5tOTA_0.programmable_nfet$8_0.transmission_gate$29_0.out INN_5T 0
C1085 programmable_telescopic_cascode_0.programmable_nfet$6_0.transmission_gate$26_1.out IBIAS 0.19494f
C1086 programmable_5tOTA_0.ena_bar<1> SCAN_OUT 0.13828f
C1087 a_68157_79808# a_68156_79067# 0
C1088 programmable_folded_cascode_0.EN0 INP_FOLDED 0.00797f
C1089 scan_chain_0.D_ff1_1.D_latch1$1_0.NAND2$2_0.A scan_chain_0.D_ff1_1.inv1$4_0.Y 0.22611f
C1090 scan_chain_0.D_ff1_3.D_latch1$1_0.NAND2$2_0.A IBIAS 0.01767f
C1091 transmission_gate$2$1_7.out programmable_telescopic_cascode_0.programmable_pfet$2_0.transmission_gate$22_0.out 0.01545f
C1092 scan_chain_0.D_ff1_6.inv1$4_0.Y CLK 0.32366f
C1093 scan_chain_0.D_ff1_5.D_latch1$1_0.inv1$3_0.Y CLK 0.00358f
C1094 scan_chain_0.D_ff1_4.D_latch1$1_1.inv1$3_0.Y a_52754_79067# 0
C1095 transmission_gate$2$1_3.out programmable_5tOTA_0.programmable_nfet$7_0.transmission_gate$28_0.out 0.29075f
C1096 scan_chain_0.D_ff1_6.D_latch1$1_1.NAND2$2_0.A CLK 0.22611f
C1097 programmable_telescopic_cascode_0.programmable_pfet$3_0.transmission_gate$23_1.out INN_FOLDED 0.02526f
C1098 scan_chain_0.D_ff1_4.D_latch1$1_0.inv1$3_0.Y VDD 0.37889f
C1099 programmable_common_source_0.EN0 a_66673_79067# 0
C1100 transmission_gate$2$1_3.out scan_chain_0.D_ff1_4.D_latch1$1_1.NAND2$2_2.B 0.00915f
C1101 programmable_5tOTA_0.programmable_nfet$8_0.transmission_gate$29_0.out OUT_5T 0.16641f
C1102 scan_chain_0.D_ff1_8.inv1$4_0.Y programmable_telescopic_cascode_0.programmable_pfet$2_1.transmission_gate$22_0.out 0
C1103 transmission_gate$2$1_4.out scan_chain_0.D_ff1_1.D_latch1$1_1.NAND2$2_0.A 0.44675f
C1104 transmission_gate$2$1_6.out programmable_telescopic_cascode_0.programmable_pfet$3_0.transmission_gate$23_0.out 0.01016f
C1105 programmable_folded_cascode_0.programmable_pfet$1_0.g INP_FOLDED 0.08772f
C1106 a_8911_79067# PROG_ENA 0
C1107 a_14250_79808# CLK 0
C1108 programmable_telescopic_cascode_0.programmable_pfet$2_1.transmission_gate$22_0.out programmable_telescopic_cascode_0.programmable_pfet$3_1.d 6.48805f
C1109 programmable_telescopic_cascode_0.programmable_pfet$3_1.d INN_FOLDED 0.39181f
C1110 transmission_gate$2$1_7.out programmable_folded_cascode_0.programmable_nfet$1_1.transmission_gate$19_1.out 0.00226f
C1111 transmission_gate$2$1_2.out programmable_5tOTA_0.programmable_nfet$8_0.transmission_gate$29_0.out 0
C1112 scan_chain_0.D_ff1_1.D_latch1$1_0.D a_33498_79808# 0.16273f
C1113 programmable_common_source_0.EN1 programmable_common_source_0.programmable_pfet$5_0.transmission_gate$30_0.out 0.08446f
C1114 a_21950_79067# transmission_gate$2$1_7.ena 0
C1115 transmission_gate$2$1_3.out programmable_common_source_0.programmable_pfet$5_0.transmission_gate$30_1.out 0.00785f
C1116 transmission_gate$2$1_3.out scan_chain_0.D_ff1_3.D_latch1$1_1.inv1$3_0.Y 0.01528f
C1117 programmable_common_source_0.EN0 scan_chain_0.D_ff1_4.D_latch1$1_0.inv1$3_0.Y 0
C1118 programmable_folded_cascode_0.EN0 programmable_folded_cascode_0.programmable_nfet$3_0.transmission_gate$21_1.out 0
C1119 programmable_telescopic_cascode_0.programmable_pfet$2_0.g programmable_telescopic_cascode_0.programmable_nfet$5_1.d 0.22975f
C1120 scan_chain_0.D_ff1_7.D_latch1$1_0.D scan_chain_0.D_ff1_7.D_latch1$1_0.NAND2$2_0.A 0.44673f
C1121 transmission_gate$2$1_2.out a_56600_79067# 0
C1122 a_25797_79808# scan_chain_0.D_ff1_8.D_latch1$1_1.Q_bar 0.01093f
C1123 scan_chain_0.D_ff1_0.D_latch1$1_0.D a_66673_79067# 0
C1124 programmable_folded_cascode_0.EN0 scan_chain_0.D_ff1_5.D_latch1$1_0.NAND2$2_2.B 0.13947f
C1125 programmable_telescopic_cascode_0.programmable_pfet$2_0.g programmable_telescopic_cascode_0.programmable_pfet$2_0.transmission_gate$22_1.out 0.26842f
C1126 INP_5T INN_5T 4.0225f
C1127 transmission_gate$2$1_7.out scan_chain_0.D_ff1_6.D_latch1$1_1.inv1$3_0.Y 0.31234f
C1128 transmission_gate$2$1_7.ena programmable_telescopic_cascode_0.programmable_nfet$4_0.transmission_gate$24_1.out 0
C1129 programmable_common_source_0.programmable_pfet$5_0.transmission_gate$30_0.out IBIAS 0.14217f
C1130 transmission_gate$2$1_3.out scan_chain_0.D_ff1_2.D_latch1$1_0.NAND2$2_0.A 0.01786f
C1131 scan_chain_0.D_ff1_7.D_latch1$1_0.NAND2$2_0.A transmission_gate$2$1_5.out 0.41823f
C1132 scan_chain_0.D_ff1_4.D_latch1$1_0.NAND2$2_2.B PROG_ENA 0.00233f
C1133 scan_chain_0.D_ff1_7.D_latch1$1_0.D VDD 1.60052f
C1134 scan_chain_0.D_ff1_1.D_latch1$1_0.NAND2$2_0.A a_35869_79808# 0.23035f
C1135 programmable_telescopic_cascode_0.programmable_nfet$5_1.transmission_gate$25_0.out INP_TELESCOPIC 0
C1136 programmable_telescopic_cascode_0.EN1 programmable_telescopic_cascode_0.programmable_nfet$4_0.transmission_gate$24_0.out 0.04318f
C1137 scan_chain_0.D_ff1_1.inv1$4_0.Y PROG_ENA 0.44521f
C1138 scan_chain_0.D_ff1_8.D_latch1$1_0.NAND2$2_0.A VDD 0.79345f
C1139 INP_5T OUT_5T 0.32235f
C1140 scan_chain_0.D_ff1_2.D_latch1$1_0.D scan_chain_0.D_ff1_2.inv1$4_0.Y 0.01122f
C1141 a_52754_79067# VDD 0.01219f
C1142 scan_chain_0.D_ff1_2.D_latch1$1_1.Q_bar VDD 0.88625f
C1143 scan_chain_0.D_ff1_7.D_latch1$1_1.inv1$3_0.Y scan_chain_0.D_ff1_7.D_latch1$1_1.NAND2$2_2.B 0.44307f
C1144 programmable_telescopic_cascode_0.programmable_pfet$3_1.transmission_gate$23_1.out INN_FOLDED 0.02526f
C1145 scan_chain_0.D_ff1_2.D_latch1$1_1.NAND2$2_0.A scan_chain_0.D_ff1_2.D_latch1$1_0.D 0.41823f
C1146 transmission_gate$2$1_5.out VDD 5.52571f
C1147 transmission_gate$2$1_2.out INP_5T 0.23957f
C1148 programmable_5tOTA_0.programmable_nfet$7_1.transmission_gate$28_1.out INP_5T 0.23071f
C1149 transmission_gate$2$1_6.out programmable_telescopic_cascode_0.programmable_pfet$3_0.g 0.81781f
C1150 programmable_common_source_0.EN0 scan_chain_0.D_ff1_4.D_latch1$1_0.NAND2$2_2.B 0.0025f
C1151 programmable_5tOTA_0.ena_bar<1> scan_chain_0.D_ff1_0.D_latch1$1_0.inv1$3_0.Y 0
C1152 programmable_5tOTA_0.programmable_pfet$4_0.g INN_5T 0.06126f
C1153 programmable_telescopic_cascode_0.programmable_pfet$3_0.g IBIAS 0.00132f
C1154 transmission_gate$2$1_2.out IN_CS 0.10923f
C1155 scan_chain_0.D_ff1_3.D_latch1$1_0.inv1$3_0.Y PROG_ENA 0.00134f
C1156 scan_chain_0.D_ff1_3.D_latch1$1_0.D scan_chain_0.D_ff1_3.D_latch1$1_0.inv1$3_0.Y 0.29948f
C1157 a_60455_79067# CLK 0
C1158 transmission_gate$2$1_6.out programmable_folded_cascode_0.programmable_pfet_1.transmission_gate$16_1.out 2.4085f
C1159 transmission_gate$2$1_3.out scan_chain_0.D_ff1_3.inv1$4_0.Y 0.00956f
C1160 transmission_gate$2$1_7.out INP_TELESCOPIC 0.01166f
C1161 scan_chain_0.D_ff1_2.inv1$4_0.Y transmission_gate$2$1_2.out 0.01266f
C1162 a_32014_79808# a_33498_79808# 0.00361f
C1163 scan_chain_0.D_ff1_5.inv1$4_0.Y scan_chain_0.D_ff1_5.D_latch1$1_0.NAND2$2_2.B 0.40095f
C1164 transmission_gate$2$1_3.out scan_chain_0.D_ff1_3.D_latch1$1_1.NAND2$2_0.A 0.00107f
C1165 scan_chain_0.D_ff1_5.D_latch1$1_0.NAND2$2_0.A a_6548_79067# 0
C1166 transmission_gate$2$1_7.ena programmable_telescopic_cascode_0.programmable_nfet$5_0.transmission_gate$25_1.out 0
C1167 scan_chain_0.D_ff1_3.D_latch1$1_1.inv1$3_0.Y scan_chain_0.D_ff1_3.D_latch1$1_1.NAND2$2_2.B 0.44307f
C1168 a_20467_79067# transmission_gate$2$1_7.ena 0
C1169 scan_chain_0.D_ff1_5.D_latch1$1_0.D a_2693_79067# 0.02982f
C1170 programmable_folded_cascode_0.programmable_pfet_1.transmission_gate$16_1.out IBIAS 0
C1171 programmable_5tOTA_0.programmable_pfet$4_1.transmission_gate$27_0.out INN_5T 0.05042f
C1172 scan_chain_0.D_ff1_1.D_latch1$1_0.D CLK 0.03837f
C1173 programmable_common_source_0.EN0 a_52754_79067# 0.16279f
C1174 programmable_5tOTA_0.programmable_pfet$4_0.g OUT_5T 1.34907f
C1175 programmable_folded_cascode_0.programmable_pfet_0.transmission_gate$16_1.out programmable_folded_cascode_0.programmable_pfet$1_1.transmission_gate$17_0.out 0.00379f
C1176 transmission_gate$2$1_3.out a_41198_79067# 0.02046f
C1177 scan_chain_0.D_ff1_6.D_latch1$1_1.Q_bar transmission_gate$2$1_7.ena 0
C1178 a_20467_79808# scan_chain_0.D_ff1_7.inv1$4_0.Y 0.00415f
C1179 scan_chain_0.D_ff1_3.D_latch1$1_1.Q_bar scan_chain_0.D_ff1_3.D_latch1$1_0.NAND2$2_2.B 0.00216f
C1180 programmable_telescopic_cascode_0.programmable_nfet$4_0.transmission_gate$24_0.out programmable_telescopic_cascode_0.programmable_nfet$4_0.s 6.52066f
C1181 programmable_telescopic_cascode_0.programmable_nfet$5_1.transmission_gate$25_1.out VDD 0.18909f
C1182 scan_chain_0.D_ff1_1.inv1$4_0.Y scan_chain_0.D_ff1_1.D_latch1$1_0.inv1$3_0.Y 0.00878f
C1183 scan_chain_0.D_ff1_2.D_latch1$1_0.D PROG_ENA 0.00152f
C1184 transmission_gate$2$1_2.out a_55117_79067# 0
C1185 programmable_5tOTA_0.programmable_pfet$4_0.transmission_gate$27_0.out programmable_5tOTA_0.programmable_nfet$7_1.transmission_gate$28_0.out 0.0027f
C1186 programmable_telescopic_cascode_0.programmable_nfet$4_0.transmission_gate$24_1.out INP_FOLDED 0.03109f
C1187 programmable_telescopic_cascode_0.EN1 programmable_telescopic_cascode_0.programmable_nfet$5_0.transmission_gate$25_0.out 0.04339f
C1188 programmable_5tOTA_0.programmable_pfet$4_0.g programmable_5tOTA_0.programmable_nfet$7_1.transmission_gate$28_1.out 1.09618f
C1189 scan_chain_0.D_ff1_2.inv1$4_0.Y a_45053_79067# 0
C1190 transmission_gate$2$1_2.out programmable_5tOTA_0.programmable_pfet$4_0.g 1.28411f
C1191 programmable_5tOTA_0.ena_bar<0> scan_chain_0.D_ff1_4.D_latch1$1_0.NAND2$2_2.B 0.03921f
C1192 programmable_telescopic_cascode_0.EN1 scan_chain_0.D_ff1_1.D_latch1$1_1.Q_bar 0
C1193 programmable_folded_cascode_0.EN1 a_14249_79067# 0.16279f
C1194 scan_chain_0.D_ff1_2.D_latch1$1_0.D scan_chain_0.D_ff1_2.D_latch1$1_0.NAND2$2_2.B 0.00115f
C1195 programmable_telescopic_cascode_0.programmable_pfet$3_0.g programmable_telescopic_cascode_0.programmable_nfet$4_1.transmission_gate$24_1.out 0.13748f
C1196 scan_chain_0.D_ff1_4.D_latch1$1_0.D transmission_gate$2$1_7.ena 0
C1197 transmission_gate$2$1_3.out CLK 0.0853f
C1198 transmission_gate$2$1_7.ena programmable_telescopic_cascode_0.programmable_pfet$3_1.transmission_gate$23_0.out 0.00142f
C1199 transmission_gate$2$1_6.out programmable_folded_cascode_0.programmable_nfet$2_0.transmission_gate$20_1.out 0.43534f
C1200 programmable_5tOTA_0.programmable_pfet$4_1.transmission_gate$27_0.out OUT_5T 2.85426f
C1201 scan_chain_0.D_ff1_7.D_latch1$1_1.Q_bar CLK 0.00483f
C1202 scan_chain_0.D_ff1_6.D_latch1$1_1.NAND2$2_2.B transmission_gate$2$1_7.ena 0
C1203 scan_chain_0.D_ff1_1.inv1$4_0.Y programmable_5tOTA_0.ena_bar<0> 0.00125f
C1204 a_16612_79808# VDD 0.00347f
C1205 transmission_gate$2$1_6.out programmable_folded_cascode_0.programmable_pfet$1_0.transmission_gate$17_1.out 1.07163f
C1206 scan_chain_0.D_ff1_1.D_latch1$1_1.Q_bar a_33497_79067# 0.16279f
C1207 transmission_gate$2$1_2.out PROG_ENA 0.10808f
C1208 transmission_gate$2$1_2.out scan_chain_0.D_ff1_3.D_latch1$1_0.D 0.02594f
C1209 transmission_gate$2$1_2.out programmable_5tOTA_0.programmable_pfet$4_1.transmission_gate$27_0.out 0.84028f
C1210 programmable_folded_cascode_0.programmable_nfet$1_0.g programmable_folded_cascode_0.programmable_pfet$1_1.transmission_gate$17_0.out 2.15369f
C1211 programmable_common_source_0.EN1 transmission_gate$2$1_7.ena 0.00711f
C1212 programmable_common_source_0.EN1 SCAN_OUT 0.08365f
C1213 transmission_gate$2$1_4.out programmable_telescopic_cascode_0.programmable_nfet$5_1.d 0.00226f
C1214 a_51271_79067# VDD 0.0098f
C1215 transmission_gate$2$1_2.out scan_chain_0.D_ff1_2.D_latch1$1_0.NAND2$2_2.B 0.01603f
C1216 scan_chain_0.D_ff1_2.D_latch1$1_0.D a_43570_79808# 0.0043f
C1217 transmission_gate$2$1_4.out programmable_telescopic_cascode_0.programmable_pfet$2_0.transmission_gate$22_1.out 0.11421f
C1218 scan_chain_0.D_ff1_2.D_latch1$1_1.NAND2$2_0.A a_39715_79808# 0.23035f
C1219 scan_chain_0.D_ff1_6.D_latch1$1_0.NAND2$2_2.B a_14249_79067# 0.00415f
C1220 a_41199_79808# VDD 0.0019f
C1221 programmable_5tOTA_0.ena_bar<0> scan_chain_0.D_ff1_3.D_latch1$1_0.inv1$3_0.Y 0.0308f
C1222 programmable_folded_cascode_0.OUT programmable_folded_cascode_0.programmable_pfet$1_1.transmission_gate$17_1.out 0.05285f
C1223 programmable_telescopic_cascode_0.EN1 programmable_telescopic_cascode_0.programmable_pfet$3_0.transmission_gate$23_1.out 0.00656f
C1224 scan_chain_0.D_ff1_8.inv1$4_0.Y programmable_telescopic_cascode_0.EN1 0.00191f
C1225 programmable_telescopic_cascode_0.EN0 scan_chain_0.D_ff1_1.inv1$4_0.Y 0
C1226 transmission_gate$2$1_2.out programmable_common_source_0.EN0 0.02623f
C1227 programmable_telescopic_cascode_0.programmable_nfet$6_0.transmission_gate$26_1.out VDD 0.18726f
C1228 programmable_telescopic_cascode_0.programmable_nfet$5_0.transmission_gate$25_0.out programmable_telescopic_cascode_0.programmable_nfet$4_0.s 0.85448f
C1229 programmable_5tOTA_0.ena_bar<0> INN_5T 0.20796f
C1230 programmable_5tOTA_0.ena_bar<1> a_60455_79067# 0
C1231 scan_chain_0.D_ff1_3.D_latch1$1_0.NAND2$2_0.A VDD 0.76162f
C1232 programmable_telescopic_cascode_0.EN1 programmable_telescopic_cascode_0.programmable_pfet$3_1.d 0
C1233 a_45053_79067# PROG_ENA 0
C1234 a_58972_79067# CLK 0
C1235 scan_chain_0.D_ff1_3.D_latch1$1_1.NAND2$2_0.A scan_chain_0.D_ff1_3.D_latch1$1_1.NAND2$2_2.B 0.01576f
C1236 programmable_telescopic_cascode_0.programmable_nfet$5_1.d INP_5T 0.20665f
C1237 transmission_gate$2$1_2.out scan_chain_0.D_ff1_0.D_latch1$1_1.Q_bar 0.00357f
C1238 transmission_gate$2$1_3.out a_51271_79808# 0
C1239 a_43570_79808# transmission_gate$2$1_2.out 0
C1240 transmission_gate$2$1_7.out programmable_folded_cascode_0.programmable_nfet$3_0.transmission_gate$21_0.out 0.42698f
C1241 programmable_telescopic_cascode_0.programmable_pfet$2_0.transmission_gate$22_1.out INP_5T 0.03019f
C1242 scan_chain_0.D_ff1_5.D_latch1$1_0.NAND2$2_0.A a_5065_79067# 0.02432f
C1243 programmable_5tOTA_0.ena_bar<0> scan_chain_0.D_ff1_2.D_latch1$1_0.D 0.05091f
C1244 transmission_gate$2$1_7.ena programmable_telescopic_cascode_0.programmable_pfet$2_0.g 0.00208f
C1245 scan_chain_0.D_ff1_2.D_latch1$1_0.NAND2$2_2.B a_45053_79067# 0.00415f
C1246 programmable_folded_cascode_0.EN0 transmission_gate$2$1_5.out 0.67331f
C1247 scan_chain_0.D_ff1_6.inv1$4_0.Y a_14249_79067# 0
C1248 programmable_telescopic_cascode_0.programmable_pfet$2_0.transmission_gate$22_0.out programmable_folded_cascode_0.OUT 0.05105f
C1249 scan_chain_0.D_ff1_2.D_latch1$1_1.NAND2$2_2.B VDD 1.07924f
C1250 transmission_gate$2$1_6.out programmable_folded_cascode_0.EN1 22.9921f
C1251 a_32014_79808# CLK 0.00415f
C1252 scan_chain_0.D_ff1_6.D_latch1$1_0.D scan_chain_0.D_ff1_6.D_latch1$1_0.NAND2$2_2.B 0.00115f
C1253 programmable_telescopic_cascode_0.programmable_nfet$4_0.g CLK 0.00189f
C1254 transmission_gate$2$1_3.out a_39715_79067# 0.02185f
C1255 a_52755_79808# a_52754_79067# 0
C1256 programmable_5tOTA_0.ena_bar<0> OUT_5T 0.02928f
C1257 programmable_telescopic_cascode_0.programmable_pfet$3_0.transmission_gate$23_0.out VDD 10.1796f
C1258 programmable_folded_cascode_0.EN1 IBIAS 0.06991f
C1259 programmable_folded_cascode_0.programmable_nfet$1_0.g programmable_folded_cascode_0.programmable_nfet$1_1.transmission_gate$19_0.out 0.38253f
C1260 transmission_gate$2$1_4.out scan_chain_0.D_ff1_1.D_latch1$1_1.NAND2$2_2.B 0.00213f
C1261 scan_chain_0.D_ff1_3.D_latch1$1_0.NAND2$2_0.A programmable_common_source_0.EN0 0.02095f
C1262 scan_chain_0.D_ff1_2.inv1$4_0.Y a_43570_79067# 0.00477f
C1263 scan_chain_0.D_ff1_3.D_latch1$1_1.NAND2$2_2.B CLK 0.40703f
C1264 programmable_5tOTA_0.ena_bar<0> programmable_5tOTA_0.programmable_nfet$7_1.transmission_gate$28_1.out 0
C1265 programmable_folded_cascode_0.EN1 programmable_folded_cascode_0.programmable_nfet_1.transmission_gate$18_0.out 0
C1266 a_14250_79808# a_14249_79067# 0
C1267 programmable_folded_cascode_0.OUT programmable_folded_cascode_0.programmable_nfet$1_1.transmission_gate$19_1.out 0.01131f
C1268 programmable_5tOTA_0.ena_bar<0> transmission_gate$2$1_2.out 1.0101f
C1269 transmission_gate$2$1_3.out programmable_5tOTA_0.ena_bar<1> 0.38803f
C1270 programmable_telescopic_cascode_0.EN0 scan_chain_0.D_ff1_2.D_latch1$1_0.D 0
C1271 programmable_5tOTA_0.programmable_pfet$4_1.transmission_gate$27_1.out INP_5T 0.03093f
C1272 scan_chain_0.D_ff1_8.D_latch1$1_0.NAND2$2_0.A scan_chain_0.D_ff1_8.D_latch1$1_0.inv1$3_0.Y 0
C1273 a_18096_79808# CLK 0
C1274 transmission_gate$2$1_6.out scan_chain_0.D_ff1_6.D_latch1$1_0.NAND2$2_2.B 0.01632f
C1275 programmable_telescopic_cascode_0.programmable_pfet$3_0.d programmable_telescopic_cascode_0.programmable_nfet$5_1.d 0
C1276 programmable_folded_cascode_0.EN0 programmable_telescopic_cascode_0.programmable_nfet$5_1.transmission_gate$25_1.out 0.04713f
C1277 scan_chain_0.D_ff1_1.D_latch1$1_1.inv1$3_0.Y VDD 0.42027f
C1278 scan_chain_0.D_ff1_1.inv1$4_0.Y a_37353_79808# 0
C1279 programmable_common_source_0.programmable_pfet$5_0.transmission_gate$30_1.out OUT_CS 2.52554f
C1280 transmission_gate$2$1_2.out a_47416_79808# 0.0043f
C1281 programmable_telescopic_cascode_0.programmable_pfet$2_0.transmission_gate$22_1.out programmable_telescopic_cascode_0.programmable_pfet$3_0.d 3.22893f
C1282 a_33498_79808# a_33497_79067# 0
C1283 scan_chain_0.D_ff1_6.D_latch1$1_0.D scan_chain_0.D_ff1_6.inv1$4_0.Y 0.01122f
C1284 programmable_folded_cascode_0.programmable_pfet_1.transmission_gate$16_0.out INP_FOLDED 0.07777f
C1285 scan_chain_0.D_ff1_6.D_latch1$1_1.NAND2$2_0.A scan_chain_0.D_ff1_6.D_latch1$1_0.D 0.41823f
C1286 a_60456_79808# SCAN_OUT 0
C1287 programmable_common_source_0.programmable_pfet$5_0.transmission_gate$30_0.out VDD 13.2925f
C1288 programmable_telescopic_cascode_0.programmable_nfet$4_1.transmission_gate$24_0.out OUT_TELESCOPIC 6.29931f
C1289 programmable_folded_cascode_0.EN1 programmable_telescopic_cascode_0.programmable_nfet$4_1.transmission_gate$24_1.out 0.01096f
C1290 programmable_common_source_0.EN1 a_68156_79067# 0
C1291 programmable_telescopic_cascode_0.programmable_pfet$2_0.transmission_gate$22_1.out PROG_ENA 0
C1292 a_48900_79808# scan_chain_0.D_ff1_3.D_latch1$1_1.Q_bar 0.01093f
C1293 scan_chain_0.D_ff1_2.D_latch1$1_1.inv1$3_0.Y CLK 0.02415f
C1294 scan_chain_0.D_ff1_6.D_latch1$1_0.NAND2$2_2.B a_12766_79067# 0.12535f
C1295 scan_chain_0.D_ff1_8.D_latch1$1_1.Q_bar scan_chain_0.D_ff1_8.D_latch1$1_1.NAND2$2_2.B 0.13783f
C1296 programmable_5tOTA_0.ena_bar<0> a_45053_79067# 0.0119f
C1297 scan_chain_0.D_ff1_8.inv1$4_0.Y a_29652_79808# 0
C1298 scan_chain_0.D_ff1_6.inv1$4_0.Y transmission_gate$2$1_6.out 0.01266f
C1299 scan_chain_0.D_ff1_0.D_latch1$1_1.NAND2$2_2.B SCAN_OUT 0.06117f
C1300 programmable_5tOTA_0.ena_bar<1> a_58972_79067# 0
C1301 programmable_5tOTA_0.programmable_pfet$4_0.g programmable_5tOTA_0.programmable_pfet$4_1.transmission_gate$27_1.out 0.21506f
C1302 scan_chain_0.D_ff1_4.D_latch1$1_0.D scan_chain_0.D_ff1_4.D_latch1$1_0.NAND2$2_0.A 0.44673f
C1303 a_43570_79067# PROG_ENA 0
C1304 transmission_gate$2$1_7.out programmable_folded_cascode_0.programmable_nfet$2_0.transmission_gate$20_0.out 0.45298f
C1305 programmable_folded_cascode_0.EN1 programmable_folded_cascode_0.programmable_nfet$2_1.transmission_gate$20_0.out 0
C1306 scan_chain_0.D_ff1_7.D_latch1$1_1.Q_bar scan_chain_0.D_ff1_7.D_latch1$1_0.inv1$3_0.Y 0.00416f
C1307 programmable_telescopic_cascode_0.programmable_pfet$2_0.g INP_FOLDED 0.11532f
C1308 programmable_common_source_0.EN1 scan_chain_0.D_ff1_0.D_latch1$1_0.inv1$3_0.Y 0
C1309 transmission_gate$2$1_2.out a_64302_79808# 0
C1310 scan_chain_0.D_ff1_2.D_latch1$1_0.NAND2$2_2.B a_43570_79067# 0.12535f
C1311 a_1210_79808# a_1210_79067# 0
C1312 transmission_gate$2$1_7.out programmable_folded_cascode_0.programmable_pfet$1_0.transmission_gate$17_0.out 0.95441f
C1313 programmable_5tOTA_0.programmable_pfet$4_1.transmission_gate$27_0.out programmable_5tOTA_0.programmable_pfet$4_1.transmission_gate$27_1.out 0.00503f
C1314 scan_chain_0.D_ff1_6.inv1$4_0.Y a_12766_79067# 0.00477f
C1315 scan_chain_0.D_ff1_6.D_latch1$1_1.inv1$3_0.Y a_8911_79067# 0.00457f
C1316 transmission_gate$2$1_6.out a_14250_79808# 0.16273f
C1317 programmable_folded_cascode_0.EN0 programmable_telescopic_cascode_0.programmable_nfet$6_0.transmission_gate$26_1.out 0.04849f
C1318 programmable_common_source_0.EN0 programmable_common_source_0.programmable_pfet$5_0.transmission_gate$30_0.out 0.02889f
C1319 scan_chain_0.D_ff1_4.D_latch1$1_0.NAND2$2_0.A programmable_common_source_0.EN1 0.41823f
C1320 a_56600_79067# transmission_gate$2$1_7.ena 0
C1321 scan_chain_0.D_ff1_8.D_latch1$1_0.D transmission_gate$2$1_7.ena 0
C1322 programmable_5tOTA_0.ena_bar<1> scan_chain_0.D_ff1_3.D_latch1$1_1.NAND2$2_2.B 0.00261f
C1323 programmable_telescopic_cascode_0.programmable_pfet$3_0.g VDD 37.8645f
C1324 scan_chain_0.D_ff1_1.D_latch1$1_1.NAND2$2_2.B PROG_ENA 0.00233f
C1325 scan_chain_0.D_ff1_0.inv1$4_0.Y CLK 0.28047f
C1326 scan_chain_0.D_ff1_0.D_latch1$1_1.Q_bar scan_chain_0.D_ff1_0.D_latch1$1_0.NAND2$2_0.A 0
C1327 scan_chain_0.D_ff1_5.D_latch1$1_1.Q_bar PROG_ENA 0.00175f
C1328 scan_chain_0.D_ff1_0.D_latch1$1_1.NAND2$2_0.A CLK 0.22611f
C1329 scan_chain_0.D_ff1_3.D_latch1$1_0.NAND2$2_0.A a_52755_79808# 0.00428f
C1330 transmission_gate$2$1_3.out a_45054_79808# 0.00357f
C1331 a_43570_79808# a_43570_79067# 0
C1332 programmable_folded_cascode_0.programmable_pfet_1.transmission_gate$16_1.out VDD 21.6885f
C1333 scan_chain_0.D_ff1_2.D_latch1$1_1.inv1$3_0.Y a_39715_79067# 0.00457f
C1334 transmission_gate$2$1_5.out programmable_telescopic_cascode_0.programmable_nfet$6_0.d 0.03016f
C1335 a_35869_79808# a_37353_79808# 0.00361f
C1336 programmable_folded_cascode_0.OUT INP_TELESCOPIC 0.80308f
C1337 transmission_gate$2$1_4.out transmission_gate$2$1_7.ena 0.0688f
C1338 scan_chain_0.D_ff1_5.D_latch1$1_1.inv1$3_0.Y a_1210_79067# 0.00457f
C1339 programmable_folded_cascode_0.EN0 programmable_telescopic_cascode_0.programmable_pfet$3_0.transmission_gate$23_0.out 0.07385f
C1340 a_25796_79067# VDD 0.01492f
C1341 scan_chain_0.D_ff1_6.D_latch1$1_0.D a_12766_79808# 0.0043f
C1342 programmable_telescopic_cascode_0.EN1 CLK 0.05595f
C1343 transmission_gate$2$1_5.out a_21950_79067# 0.02983f
C1344 scan_chain_0.D_ff1_6.D_latch1$1_1.NAND2$2_0.A a_8911_79808# 0.23035f
C1345 transmission_gate$2$1_7.out OUT_TELESCOPIC 0.08142f
C1346 programmable_common_source_0.EN1 a_66673_79067# 0
C1347 scan_chain_0.D_ff1_7.D_latch1$1_1.NAND2$2_0.A scan_chain_0.D_ff1_7.D_latch1$1_1.inv1$3_0.Y 0
C1348 scan_chain_0.D_ff1_8.D_latch1$1_1.inv1$3_0.Y PROG_ENA 0.00134f
C1349 programmable_5tOTA_0.ena_bar<0> scan_chain_0.D_ff1_0.D_latch1$1_0.NAND2$2_0.A 0
C1350 programmable_5tOTA_0.ena_bar<0> a_43570_79067# 0.01075f
C1351 scan_chain_0.D_ff1_4.D_latch1$1_0.D scan_chain_0.D_ff1_4.D_latch1$1_0.inv1$3_0.Y 0.29948f
C1352 a_33497_79067# CLK 0
C1353 programmable_telescopic_cascode_0.EN0 programmable_telescopic_cascode_0.programmable_nfet$5_1.d 0
C1354 a_28168_79808# a_29652_79808# 0.00361f
C1355 programmable_telescopic_cascode_0.programmable_nfet$5_1.transmission_gate$25_1.out programmable_telescopic_cascode_0.programmable_nfet$6_0.d 0.40936f
C1356 programmable_telescopic_cascode_0.EN0 programmable_telescopic_cascode_0.programmable_pfet$2_0.transmission_gate$22_1.out 0.00874f
C1357 a_12766_79808# transmission_gate$2$1_6.out 0
C1358 scan_chain_0.D_ff1_2.inv1$4_0.Y transmission_gate$2$1_7.ena 0.00353f
C1359 programmable_common_source_0.programmable_pfet$5_0.transmission_gate$30_0.out programmable_common_source_0.programmable_nfet$9_0.transmission_gate$31_1.out 0.042f
C1360 a_58972_79808# scan_chain_0.D_ff1_4.inv1$4_0.Y 0.00415f
C1361 transmission_gate$2$1_5.out programmable_telescopic_cascode_0.programmable_nfet$4_0.transmission_gate$24_1.out 0.63353f
C1362 programmable_folded_cascode_0.programmable_nfet$2_0.transmission_gate$20_1.out VDD 0.22343f
C1363 programmable_telescopic_cascode_0.programmable_nfet$5_1.d INN_TELESCOPIC 5.82794f
C1364 programmable_5tOTA_0.ena_bar<0> programmable_5tOTA_0.programmable_pfet$4_1.transmission_gate$27_1.out 0.00704f
C1365 programmable_common_source_0.EN1 a_60455_79067# 0.16279f
C1366 programmable_folded_cascode_0.programmable_pfet$1_0.transmission_gate$17_1.out VDD 2.41886f
C1367 scan_chain_0.D_ff1_4.D_latch1$1_1.Q_bar scan_chain_0.D_ff1_4.D_latch1$1_0.NAND2$2_2.B 0.00216f
C1368 programmable_telescopic_cascode_0.programmable_pfet$2_0.transmission_gate$22_1.out INN_TELESCOPIC 0.02355f
C1369 a_5065_79067# a_6548_79067# 0.00361f
C1370 programmable_folded_cascode_0.programmable_pfet_0.transmission_gate$16_1.out INP_FOLDED 0.15555f
C1371 a_12766_79808# a_12766_79067# 0
C1372 programmable_5tOTA_0.ena_bar<1> programmable_5tOTA_0.programmable_nfet$7_1.transmission_gate$28_0.out 0.00682f
C1373 a_55117_79067# transmission_gate$2$1_7.ena 0
C1374 programmable_5tOTA_0.ena_bar<1> scan_chain_0.D_ff1_0.inv1$4_0.Y 0.0043f
C1375 programmable_telescopic_cascode_0.programmable_nfet$4_0.transmission_gate$24_1.out programmable_telescopic_cascode_0.programmable_nfet$5_1.transmission_gate$25_1.out 0
C1376 programmable_5tOTA_0.ena_bar<1> scan_chain_0.D_ff1_0.D_latch1$1_1.NAND2$2_0.A 0.06699f
C1377 scan_chain_0.D_ff1_7.D_latch1$1_0.D a_20467_79067# 0
C1378 VDD SCAN_OUT 2.18594f
C1379 programmable_folded_cascode_0.programmable_nfet$3_0.g programmable_folded_cascode_0.programmable_nfet$2_0.transmission_gate$20_1.out 0
C1380 a_2694_79808# PROG_ENA 0
C1381 programmable_telescopic_cascode_0.programmable_pfet$2_1.transmission_gate$22_1.out OUT_TELESCOPIC 3.39957f
C1382 programmable_folded_cascode_0.programmable_nfet_0.transmission_gate$18_1.out INP_5T 0.08004f
C1383 transmission_gate$2$1_7.ena PROG_ENA 1.01968f
C1384 scan_chain_0.D_ff1_3.D_latch1$1_0.D transmission_gate$2$1_7.ena 0
C1385 transmission_gate$2$1_3.out programmable_common_source_0.EN1 0.00668f
C1386 a_35869_79067# a_37352_79067# 0.00361f
C1387 programmable_telescopic_cascode_0.programmable_nfet$6_0.transmission_gate$26_1.out programmable_telescopic_cascode_0.programmable_nfet$6_0.d 1.21725f
C1388 programmable_telescopic_cascode_0.EN0 scan_chain_0.D_ff1_1.D_latch1$1_1.NAND2$2_2.B 0
C1389 a_24313_79067# VDD 0.02967f
C1390 transmission_gate$2$1_5.out programmable_telescopic_cascode_0.programmable_nfet$5_0.transmission_gate$25_1.out 0.62082f
C1391 transmission_gate$2$1_7.out programmable_telescopic_cascode_0.programmable_nfet$4_1.transmission_gate$24_0.out 0.02011f
C1392 a_29652_79808# CLK 0
C1393 programmable_folded_cascode_0.EN0 programmable_telescopic_cascode_0.programmable_pfet$3_0.g 0.10539f
C1394 scan_chain_0.D_ff1_0.Q_bar SCAN_OUT 1.72375f
C1395 a_1210_79067# SCAN_IN 0
C1396 scan_chain_0.D_ff1_2.D_latch1$1_0.NAND2$2_2.B transmission_gate$2$1_7.ena 0
C1397 programmable_folded_cascode_0.EN1 VDD 23.0578f
C1398 programmable_folded_cascode_0.programmable_pfet$1_1.transmission_gate$17_0.out programmable_folded_cascode_0.programmable_pfet$1_1.transmission_gate$17_1.out 0.00142f
C1399 programmable_telescopic_cascode_0.EN1 scan_chain_0.D_ff1_8.D_latch1$1_0.NAND2$2_2.B 0.13928f
C1400 programmable_folded_cascode_0.programmable_nfet$1_0.g INP_FOLDED 0.40579f
C1401 programmable_common_source_0.EN0 transmission_gate$2$1_7.ena 0.01321f
C1402 a_32014_79067# CLK 0.00479f
C1403 transmission_gate$2$1_6.out INN_FOLDED 0.44655f
C1404 programmable_folded_cascode_0.EN0 programmable_folded_cascode_0.programmable_pfet_1.transmission_gate$16_1.out 0.08239f
C1405 programmable_common_source_0.EN0 SCAN_OUT 0.00244f
C1406 a_18095_79067# PROG_ENA 0
C1407 transmission_gate$2$1_6.out programmable_telescopic_cascode_0.programmable_pfet$2_1.transmission_gate$22_0.out 0.01006f
C1408 scan_chain_0.D_ff1_4.D_latch1$1_1.NAND2$2_0.A scan_chain_0.D_ff1_4.D_latch1$1_1.NAND2$2_2.B 0.01576f
C1409 transmission_gate$2$1_3.out IBIAS 0.27041f
C1410 programmable_5tOTA_0.ena_bar<1> OUT_CS 0.1262f
C1411 IBIAS INN_FOLDED 0.05751f
C1412 programmable_telescopic_cascode_0.EN0 scan_chain_0.D_ff1_8.D_latch1$1_1.inv1$3_0.Y 0
C1413 scan_chain_0.D_ff1_6.D_latch1$1_0.NAND2$2_2.B VDD 1.059f
C1414 transmission_gate$2$1_5.out programmable_telescopic_cascode_0.programmable_pfet$3_1.transmission_gate$23_0.out 0.06984f
C1415 a_60456_79808# a_60455_79067# 0
C1416 scan_chain_0.D_ff1_1.D_latch1$1_0.inv1$3_0.Y transmission_gate$2$1_7.ena 0
C1417 transmission_gate$2$1_6.out programmable_folded_cascode_0.programmable_nfet_1.transmission_gate$18_1.out 0.35385f
C1418 transmission_gate$2$1_2.out scan_chain_0.D_ff1_4.D_latch1$1_1.Q_bar 0.00357f
C1419 programmable_folded_cascode_0.EN1 programmable_folded_cascode_0.programmable_nfet$3_0.g 0.30322f
C1420 scan_chain_0.D_ff1_7.D_latch1$1_0.NAND2$2_2.B CLK 0.00592f
C1421 programmable_folded_cascode_0.EN0 programmable_folded_cascode_0.programmable_nfet$2_0.transmission_gate$20_1.out 0
C1422 programmable_telescopic_cascode_0.programmable_pfet$2_0.transmission_gate$22_0.out programmable_telescopic_cascode_0.programmable_nfet$5_1.d 0.00122f
C1423 transmission_gate$2$1_7.out programmable_telescopic_cascode_0.programmable_nfet$5_1.transmission_gate$25_0.out 0.0237f
C1424 transmission_gate$2$1_2.out scan_chain_0.D_ff1_0.D_latch1$1_0.NAND2$2_2.B 0
C1425 programmable_folded_cascode_0.programmable_nfet_1.transmission_gate$18_0.out programmable_folded_cascode_0.programmable_nfet_1.transmission_gate$18_1.out 0.00458f
C1426 programmable_5tOTA_0.ena_bar<1> a_66673_79808# 0.01312f
C1427 programmable_5tOTA_0.ena_bar<0> transmission_gate$2$1_7.ena 0.03305f
C1428 scan_chain_0.D_ff1_0.D_latch1$1_0.D SCAN_OUT 0.02182f
C1429 programmable_telescopic_cascode_0.programmable_pfet$2_0.transmission_gate$22_1.out programmable_telescopic_cascode_0.programmable_pfet$2_0.transmission_gate$22_0.out 0.00104f
C1430 scan_chain_0.D_ff1_8.D_latch1$1_0.inv1$3_0.Y a_25796_79067# 0
C1431 programmable_telescopic_cascode_0.programmable_nfet$4_1.transmission_gate$24_1.out INN_FOLDED 0.02699f
C1432 programmable_folded_cascode_0.EN0 programmable_folded_cascode_0.programmable_pfet$1_0.transmission_gate$17_1.out 0.02247f
C1433 scan_chain_0.D_ff1_6.inv1$4_0.Y VDD 0.97849f
C1434 scan_chain_0.D_ff1_5.D_latch1$1_0.inv1$3_0.Y VDD 0.39107f
C1435 transmission_gate$2$1_6.out programmable_telescopic_cascode_0.programmable_nfet$4_0.g 0.06324f
C1436 programmable_folded_cascode_0.programmable_nfet$3_0.transmission_gate$21_1.out INP_5T 0.13749f
C1437 programmable_folded_cascode_0.programmable_nfet$2_0.g programmable_folded_cascode_0.programmable_nfet$2_0.transmission_gate$20_1.out 0.20152f
C1438 scan_chain_0.D_ff1_6.D_latch1$1_1.NAND2$2_0.A VDD 0.78627f
C1439 transmission_gate$2$1_3.out a_60456_79808# 0
C1440 programmable_folded_cascode_0.OUT programmable_folded_cascode_0.programmable_nfet$2_0.transmission_gate$20_0.out 0
C1441 programmable_telescopic_cascode_0.programmable_nfet$4_0.g IBIAS 0.56976f
C1442 a_14250_79808# VDD 0.00913f
C1443 scan_chain_0.D_ff1_6.D_latch1$1_0.inv1$3_0.Y CLK 0.00358f
C1444 transmission_gate$2$1_5.out programmable_telescopic_cascode_0.programmable_pfet$2_0.g 1.06026f
C1445 programmable_telescopic_cascode_0.EN0 transmission_gate$2$1_7.ena 0.80585f
C1446 a_68157_79808# SCAN_OUT 0.16273f
C1447 scan_chain_0.D_ff1_4.D_latch1$1_0.inv1$3_0.Y a_56600_79067# 0
C1448 programmable_folded_cascode_0.programmable_pfet$1_0.g programmable_folded_cascode_0.programmable_pfet$1_0.transmission_gate$17_1.out 0.23658f
C1449 programmable_folded_cascode_0.programmable_pfet$1_0.transmission_gate$17_0.out programmable_folded_cascode_0.OUT 2.15245f
C1450 scan_chain_0.D_ff1_0.D_latch1$1_0.inv1$3_0.Y VDD 0.39397f
C1451 transmission_gate$2$1_3.out scan_chain_0.D_ff1_0.D_latch1$1_1.NAND2$2_2.B 0.00915f
C1452 transmission_gate$2$1_6.out programmable_folded_cascode_0.programmable_nfet$2_1.transmission_gate$20_1.out 0.34905f
C1453 transmission_gate$2$1_7.ena INN_TELESCOPIC 0
C1454 programmable_common_source_0.EN0 a_68156_79067# 0
C1455 transmission_gate$2$1_3.out programmable_5tOTA_0.programmable_pfet$4_0.transmission_gate$27_1.out 1.02244f
C1456 a_16612_79067# PROG_ENA 0
C1457 transmission_gate$2$1_7.out programmable_telescopic_cascode_0.programmable_nfet$6_0.transmission_gate$26_0.out 0.03945f
C1458 programmable_folded_cascode_0.EN0 programmable_folded_cascode_0.EN1 13.7523f
C1459 programmable_folded_cascode_0.programmable_nfet$1_1.transmission_gate$19_0.out programmable_folded_cascode_0.programmable_nfet$1_1.transmission_gate$19_1.out 0.00448f
C1460 programmable_telescopic_cascode_0.programmable_pfet$3_0.g programmable_telescopic_cascode_0.programmable_nfet$6_0.d 0
C1461 programmable_telescopic_cascode_0.programmable_nfet$4_1.transmission_gate$24_1.out programmable_telescopic_cascode_0.programmable_nfet$4_0.g 0.21559f
C1462 a_1210_79808# scan_chain_0.D_ff1_5.D_latch1$1_0.D 0
C1463 a_29651_79067# transmission_gate$2$1_7.ena 0
C1464 programmable_folded_cascode_0.EN1 programmable_folded_cascode_0.programmable_nfet$2_0.g 0.13915f
C1465 transmission_gate$2$1_3.out scan_chain_0.D_ff1_4.D_latch1$1_1.inv1$3_0.Y 0.01539f
C1466 programmable_common_source_0.EN0 scan_chain_0.D_ff1_0.D_latch1$1_0.inv1$3_0.Y 0
C1467 transmission_gate$2$1_2.out a_56601_79808# 0
C1468 programmable_folded_cascode_0.OUT OUT_TELESCOPIC 1.70588f
C1469 scan_chain_0.D_ff1_5.D_latch1$1_0.NAND2$2_2.B PROG_ENA 0.00233f
C1470 programmable_folded_cascode_0.EN1 programmable_folded_cascode_0.programmable_pfet$1_0.g 0.13137f
C1471 transmission_gate$2$1_2.out a_64301_79067# 0
C1472 transmission_gate$2$1_7.out programmable_telescopic_cascode_0.programmable_pfet$2_1.transmission_gate$22_1.out 0.00764f
C1473 programmable_telescopic_cascode_0.programmable_pfet$3_0.g programmable_telescopic_cascode_0.programmable_nfet$4_0.transmission_gate$24_1.out 3.25042f
C1474 programmable_5tOTA_0.ena_bar<0> a_68156_79067# 0.0119f
C1475 a_12766_79808# VDD 0.00536f
C1476 programmable_common_source_0.EN1 scan_chain_0.D_ff1_0.inv1$4_0.Y 0.0069f
C1477 programmable_common_source_0.EN1 scan_chain_0.D_ff1_0.D_latch1$1_1.NAND2$2_0.A 0
C1478 transmission_gate$2$1_6.out programmable_folded_cascode_0.programmable_nfet$1_0.transmission_gate$19_1.out 0.44637f
C1479 scan_chain_0.D_ff1_4.inv1$4_0.Y CLK 0.32366f
C1480 scan_chain_0.D_ff1_4.D_latch1$1_1.NAND2$2_0.A CLK 0.22611f
C1481 programmable_folded_cascode_0.programmable_nfet$2_1.transmission_gate$20_0.out programmable_folded_cascode_0.programmable_nfet$2_1.transmission_gate$20_1.out 0
C1482 programmable_telescopic_cascode_0.programmable_pfet$3_0.transmission_gate$23_1.out programmable_telescopic_cascode_0.programmable_pfet$3_1.d 0.13558f
C1483 a_33498_79808# scan_chain_0.D_ff1_1.D_latch1$1_1.Q_bar 0.01093f
C1484 scan_chain_0.D_ff1_0.D_latch1$1_0.NAND2$2_0.A scan_chain_0.D_ff1_0.D_latch1$1_0.NAND2$2_2.B 0.01576f
C1485 scan_chain_0.D_ff1_8.D_latch1$1_0.D scan_chain_0.D_ff1_8.D_latch1$1_0.NAND2$2_0.A 0.44673f
C1486 programmable_telescopic_cascode_0.programmable_nfet$5_1.d INP_TELESCOPIC 0
C1487 a_6548_79067# CLK 0
C1488 scan_chain_0.D_ff1_0.D_latch1$1_0.D scan_chain_0.D_ff1_0.D_latch1$1_0.inv1$3_0.Y 0.29948f
C1489 scan_chain_0.D_ff1_7.D_latch1$1_0.inv1$3_0.Y scan_chain_0.D_ff1_7.D_latch1$1_0.NAND2$2_2.B 0.44289f
C1490 programmable_folded_cascode_0.EN0 scan_chain_0.D_ff1_6.D_latch1$1_1.NAND2$2_0.A 0
C1491 scan_chain_0.D_ff1_0.inv1$4_0.Y IBIAS 0.02735f
C1492 a_60455_79067# VDD 0.01628f
C1493 transmission_gate$2$1_6.out programmable_telescopic_cascode_0.EN1 0
C1494 programmable_common_source_0.EN0 a_66673_79067# 0
C1495 programmable_5tOTA_0.ena_bar<0> scan_chain_0.D_ff1_4.D_latch1$1_0.NAND2$2_0.A 0
C1496 scan_chain_0.D_ff1_4.D_latch1$1_0.inv1$3_0.Y PROG_ENA 0.00134f
C1497 scan_chain_0.D_ff1_8.D_latch1$1_0.NAND2$2_0.A transmission_gate$2$1_4.out 0.41823f
C1498 scan_chain_0.D_ff1_7.D_latch1$1_1.Q_bar scan_chain_0.D_ff1_7.D_latch1$1_0.NAND2$2_0.A 0
C1499 scan_chain_0.D_ff1_1.D_latch1$1_0.D VDD 1.64552f
C1500 scan_chain_0.D_ff1_0.D_latch1$1_1.Q_bar a_66673_79067# 0
C1501 programmable_telescopic_cascode_0.EN1 IBIAS 0.07018f
C1502 programmable_common_source_0.EN1 OUT_CS 0.2363f
C1503 transmission_gate$2$1_5.out transmission_gate$2$1_4.out 5.64182f
C1504 a_28168_79067# transmission_gate$2$1_7.ena 0
C1505 scan_chain_0.D_ff1_3.D_latch1$1_0.inv1$3_0.Y scan_chain_0.D_ff1_3.D_latch1$1_0.NAND2$2_2.B 0.44289f
C1506 programmable_telescopic_cascode_0.programmable_pfet$3_0.transmission_gate$23_0.out programmable_telescopic_cascode_0.programmable_pfet$2_0.g 0
C1507 transmission_gate$2$1_7.ena programmable_telescopic_cascode_0.programmable_pfet$2_0.transmission_gate$22_0.out 0
C1508 programmable_common_source_0.EN1 programmable_common_source_0.programmable_pfet$5_0.transmission_gate$30_0.out 0.57952f
C1509 programmable_common_source_0.EN0 a_60455_79067# 0
C1510 programmable_telescopic_cascode_0.programmable_nfet$4_1.transmission_gate$24_0.out programmable_folded_cascode_0.OUT 0.04251f
C1511 transmission_gate$2$1_3.out a_48899_79067# 0.02046f
C1512 programmable_common_source_0.EN0 scan_chain_0.D_ff1_4.D_latch1$1_0.inv1$3_0.Y 0.00482f
C1513 transmission_gate$2$1_3.out VDD 10.0698f
C1514 scan_chain_0.D_ff1_7.D_latch1$1_1.Q_bar VDD 0.95432f
C1515 programmable_folded_cascode_0.EN1 programmable_telescopic_cascode_0.programmable_nfet$6_0.d 0.24266f
C1516 VDD INN_FOLDED 10.5888f
C1517 transmission_gate$2$1_2.out a_62818_79067# 0
C1518 programmable_telescopic_cascode_0.programmable_pfet$2_1.transmission_gate$22_0.out VDD 3.38593f
C1519 IBIAS OUT_CS 3.07321f
C1520 programmable_5tOTA_0.ena_bar<0> a_66673_79067# 0.01075f
C1521 transmission_gate$2$1_6.out programmable_telescopic_cascode_0.programmable_nfet$4_0.s 0.08692f
C1522 programmable_5tOTA_0.ena_bar<0> programmable_5tOTA_0.programmable_nfet$7_0.transmission_gate$28_1.out 0
C1523 programmable_telescopic_cascode_0.EN1 programmable_telescopic_cascode_0.programmable_nfet$4_1.transmission_gate$24_1.out 0
C1524 programmable_5tOTA_0.ena_bar<1> scan_chain_0.D_ff1_4.inv1$4_0.Y 0.0043f
C1525 transmission_gate$2$1_4.out programmable_telescopic_cascode_0.programmable_nfet$5_1.transmission_gate$25_1.out 0.05789f
C1526 transmission_gate$2$1_3.out scan_chain_0.D_ff1_0.Q_bar 0.00674f
C1527 programmable_5tOTA_0.ena_bar<1> scan_chain_0.D_ff1_4.D_latch1$1_1.NAND2$2_0.A 0.06699f
C1528 scan_chain_0.D_ff1_2.D_latch1$1_1.NAND2$2_0.A scan_chain_0.D_ff1_2.D_latch1$1_1.Q_bar 0.02095f
C1529 scan_chain_0.D_ff1_5.inv1$4_0.Y scan_chain_0.D_ff1_5.D_latch1$1_0.inv1$3_0.Y 0.00878f
C1530 programmable_telescopic_cascode_0.programmable_nfet$4_0.s IBIAS 0
C1531 scan_chain_0.D_ff1_7.D_latch1$1_1.NAND2$2_2.B transmission_gate$2$1_7.ena 0
C1532 transmission_gate$2$1_7.out programmable_folded_cascode_0.programmable_pfet_0.transmission_gate$16_0.out 1.57891f
C1533 programmable_telescopic_cascode_0.programmable_pfet$3_0.g programmable_telescopic_cascode_0.programmable_pfet$3_1.transmission_gate$23_0.out 0.25714f
C1534 programmable_folded_cascode_0.programmable_nfet_1.transmission_gate$18_1.out VDD 0.2485f
C1535 a_28168_79808# scan_chain_0.D_ff1_8.inv1$4_0.Y 0.00415f
C1536 programmable_5tOTA_0.ena_bar<1> programmable_5tOTA_0.programmable_nfet$8_0.transmission_gate$29_1.out 0.02124f
C1537 transmission_gate$2$1_3.out programmable_common_source_0.EN0 0.00671f
C1538 a_5065_79067# CLK 0
C1539 scan_chain_0.D_ff1_3.D_latch1$1_1.Q_bar scan_chain_0.D_ff1_3.D_latch1$1_0.inv1$3_0.Y 0.00416f
C1540 programmable_telescopic_cascode_0.programmable_pfet$3_1.transmission_gate$23_1.out programmable_telescopic_cascode_0.programmable_pfet$3_1.d 3.40098f
C1541 scan_chain_0.D_ff1_0.D_latch1$1_1.NAND2$2_0.A scan_chain_0.D_ff1_0.D_latch1$1_1.NAND2$2_2.B 0.01576f
C1542 programmable_folded_cascode_0.programmable_pfet$1_1.transmission_gate$17_1.out INP_FOLDED 0.08365f
C1543 programmable_folded_cascode_0.EN1 programmable_telescopic_cascode_0.programmable_nfet$4_0.transmission_gate$24_1.out 0.01096f
C1544 transmission_gate$2$1_2.out scan_chain_0.D_ff1_3.D_latch1$1_0.NAND2$2_2.B 0
C1545 a_58972_79067# VDD 0.01323f
C1546 scan_chain_0.D_ff1_7.D_latch1$1_1.NAND2$2_2.B a_18095_79067# 0.00415f
C1547 transmission_gate$2$1_5.out a_24313_79808# 0.0043f
C1548 scan_chain_0.D_ff1_5.D_latch1$1_1.Q_bar a_2693_79067# 0.16279f
C1549 programmable_5tOTA_0.ena_bar<0> scan_chain_0.D_ff1_4.D_latch1$1_0.inv1$3_0.Y 0.02993f
C1550 scan_chain_0.D_ff1_7.D_latch1$1_0.D PROG_ENA 0.00152f
C1551 scan_chain_0.D_ff1_2.D_latch1$1_0.D scan_chain_0.D_ff1_2.D_latch1$1_0.inv1$3_0.Y 0.29948f
C1552 scan_chain_0.D_ff1_1.D_latch1$1_1.Q_bar CLK 0.00578f
C1553 programmable_folded_cascode_0.programmable_pfet_1.transmission_gate$16_0.out programmable_folded_cascode_0.programmable_pfet_1.transmission_gate$16_1.out 0.00138f
C1554 transmission_gate$2$1_5.out programmable_telescopic_cascode_0.programmable_pfet$3_0.d 0.38583f
C1555 scan_chain_0.D_ff1_6.D_latch1$1_1.inv1$3_0.Y transmission_gate$2$1_7.ena 0
C1556 a_32014_79808# VDD 0.0064f
C1557 a_52754_79067# PROG_ENA 0
C1558 scan_chain_0.D_ff1_2.D_latch1$1_1.Q_bar PROG_ENA 0.00175f
C1559 programmable_telescopic_cascode_0.programmable_nfet$4_0.g VDD 12.6506f
C1560 transmission_gate$2$1_7.out programmable_folded_cascode_0.programmable_nfet$1_0.transmission_gate$19_0.out 0.45464f
C1561 transmission_gate$2$1_5.out PROG_ENA 0.16255f
C1562 scan_chain_0.D_ff1_3.D_latch1$1_1.NAND2$2_2.B a_48899_79067# 0.00415f
C1563 transmission_gate$2$1_7.out programmable_folded_cascode_0.OUT 1.21933f
C1564 scan_chain_0.D_ff1_2.D_latch1$1_1.Q_bar scan_chain_0.D_ff1_2.D_latch1$1_0.NAND2$2_2.B 0.00216f
C1565 scan_chain_0.D_ff1_4.D_latch1$1_1.Q_bar transmission_gate$2$1_7.ena 0
C1566 transmission_gate$2$1_4.out programmable_telescopic_cascode_0.programmable_nfet$6_0.transmission_gate$26_1.out 0.06054f
C1567 scan_chain_0.D_ff1_3.D_latch1$1_1.NAND2$2_2.B VDD 1.07924f
C1568 programmable_telescopic_cascode_0.programmable_pfet$3_0.g programmable_telescopic_cascode_0.programmable_pfet$2_0.g 11.7803f
C1569 transmission_gate$2$1_3.out a_47416_79067# 0.0204f
C1570 transmission_gate$2$1_3.out scan_chain_0.D_ff1_0.D_latch1$1_0.D 0.02555f
C1571 programmable_common_source_0.EN0 a_58972_79067# 0
C1572 transmission_gate$2$1_6.out programmable_folded_cascode_0.programmable_nfet_0.transmission_gate$18_0.out 0.00513f
C1573 scan_chain_0.D_ff1_1.inv1$4_0.Y a_37352_79067# 0
C1574 programmable_common_source_0.EN0 a_52754_79067# 0.02983f
C1575 transmission_gate$2$1_2.out scan_chain_0.D_ff1_3.D_latch1$1_1.Q_bar 0.00357f
C1576 a_18096_79808# VDD 0.02152f
C1577 programmable_folded_cascode_0.programmable_nfet$2_1.transmission_gate$20_1.out VDD 0.345f
C1578 scan_chain_0.D_ff1_1.D_latch1$1_0.D scan_chain_0.D_ff1_1.D_latch1$1_0.NAND2$2_2.B 0.00115f
C1579 scan_chain_0.D_ff1_8.inv1$4_0.Y CLK 0.32366f
C1580 scan_chain_0.D_ff1_3.D_latch1$1_1.NAND2$2_0.A scan_chain_0.D_ff1_3.D_latch1$1_1.inv1$3_0.Y 0
C1581 programmable_folded_cascode_0.EN1 programmable_telescopic_cascode_0.programmable_nfet$5_0.transmission_gate$25_1.out 0.0137f
C1582 transmission_gate$2$1_7.out a_8911_79067# 0
C1583 programmable_common_source_0.EN1 programmable_common_source_0.programmable_nfet$9_0.transmission_gate$31_0.out 0.00161f
C1584 scan_chain_0.D_ff1_4.D_latch1$1_1.NAND2$2_2.B CLK 0.40703f
C1585 scan_chain_0.D_ff1_8.D_latch1$1_1.NAND2$2_0.A CLK 0.22611f
C1586 scan_chain_0.D_ff1_2.D_latch1$1_1.NAND2$2_0.A a_41199_79808# 0.00428f
C1587 programmable_5tOTA_0.ena_bar<1> a_58972_79808# 0.01312f
C1588 programmable_telescopic_cascode_0.programmable_nfet$5_1.transmission_gate$25_1.out PROG_ENA 0
C1589 transmission_gate$2$1_3.out a_68157_79808# 0
C1590 scan_chain_0.D_ff1_4.D_latch1$1_0.D SCAN_OUT 0.0144f
C1591 transmission_gate$2$1_7.ena INP_TELESCOPIC 0
C1592 transmission_gate$2$1_4.out programmable_telescopic_cascode_0.programmable_pfet$3_0.transmission_gate$23_0.out 1.09522f
C1593 scan_chain_0.D_ff1_2.D_latch1$1_1.inv1$3_0.Y VDD 0.37733f
C1594 a_1210_79808# SCAN_IN 0.00805f
C1595 transmission_gate$2$1_3.out scan_chain_0.D_ff1_1.D_latch1$1_0.NAND2$2_2.B 0.01655f
C1596 programmable_folded_cascode_0.EN0 INN_FOLDED 0.38381f
C1597 programmable_folded_cascode_0.EN0 programmable_telescopic_cascode_0.programmable_pfet$2_1.transmission_gate$22_0.out 0.05171f
C1598 scan_chain_0.D_ff1_6.D_latch1$1_0.D scan_chain_0.D_ff1_6.D_latch1$1_0.inv1$3_0.Y 0.29948f
C1599 transmission_gate$2$1_3.out a_52755_79808# 0
C1600 programmable_common_source_0.programmable_nfet$9_0.transmission_gate$31_0.out IBIAS 0.21129f
C1601 programmable_folded_cascode_0.programmable_nfet$3_0.g programmable_folded_cascode_0.programmable_nfet$2_1.transmission_gate$20_1.out 0.01567f
C1602 programmable_common_source_0.EN1 SCAN_OUT 0.07866f
C1603 programmable_5tOTA_0.ena_bar<0> a_52754_79067# 0.0119f
C1604 programmable_5tOTA_0.ena_bar<0> scan_chain_0.D_ff1_2.D_latch1$1_1.Q_bar 0.02576f
C1605 programmable_telescopic_cascode_0.programmable_pfet$3_0.transmission_gate$23_0.out INP_5T 0.06326f
C1606 transmission_gate$2$1_4.out scan_chain_0.D_ff1_1.D_latch1$1_1.inv1$3_0.Y 0.31006f
C1607 scan_chain_0.D_ff1_3.D_latch1$1_1.inv1$3_0.Y CLK 0.02415f
C1608 programmable_folded_cascode_0.EN1 programmable_telescopic_cascode_0.programmable_pfet$3_1.transmission_gate$23_0.out 0.0274f
C1609 a_2694_79808# a_2693_79067# 0
C1610 scan_chain_0.D_ff1_7.D_latch1$1_1.NAND2$2_2.B a_16612_79067# 0.16593f
C1611 scan_chain_0.D_ff1_2.D_latch1$1_1.NAND2$2_0.A scan_chain_0.D_ff1_2.D_latch1$1_1.NAND2$2_2.B 0.01576f
C1612 a_2693_79067# transmission_gate$2$1_7.ena 0
C1613 a_33498_79808# CLK 0
C1614 programmable_folded_cascode_0.programmable_pfet$1_0.g INN_FOLDED 0.02518f
C1615 programmable_folded_cascode_0.EN0 programmable_folded_cascode_0.programmable_nfet_1.transmission_gate$18_1.out 0
C1616 scan_chain_0.D_ff1_6.D_latch1$1_1.Q_bar scan_chain_0.D_ff1_6.D_latch1$1_0.NAND2$2_2.B 0.00216f
C1617 programmable_telescopic_cascode_0.programmable_pfet$2_1.transmission_gate$22_1.out programmable_folded_cascode_0.OUT 0.0081f
C1618 scan_chain_0.D_ff1_3.D_latch1$1_0.D a_51271_79067# 0
C1619 a_51271_79067# PROG_ENA 0
C1620 a_41199_79808# PROG_ENA 0
C1621 programmable_folded_cascode_0.programmable_nfet$1_0.transmission_gate$19_1.out VDD 0.23994f
C1622 scan_chain_0.D_ff1_5.D_latch1$1_1.inv1$3_0.Y SCAN_IN 0.31257f
C1623 programmable_folded_cascode_0.EN1 programmable_folded_cascode_0.programmable_pfet_1.transmission_gate$16_0.out 0.02999f
C1624 programmable_5tOTA_0.ena_bar<1> programmable_5tOTA_0.programmable_pfet$4_0.transmission_gate$27_0.out 0.01467f
C1625 programmable_5tOTA_0.programmable_nfet$7_1.transmission_gate$28_0.out VDD 0.2211f
C1626 programmable_telescopic_cascode_0.programmable_nfet$6_0.transmission_gate$26_1.out PROG_ENA 0
C1627 programmable_folded_cascode_0.programmable_nfet$2_0.g programmable_folded_cascode_0.programmable_nfet_1.transmission_gate$18_1.out 0
C1628 scan_chain_0.D_ff1_3.D_latch1$1_1.NAND2$2_2.B a_47416_79067# 0.16593f
C1629 scan_chain_0.D_ff1_0.inv1$4_0.Y VDD 1.15817f
C1630 scan_chain_0.D_ff1_6.D_latch1$1_0.inv1$3_0.Y a_12766_79067# 0.00457f
C1631 scan_chain_0.D_ff1_3.D_latch1$1_0.D scan_chain_0.D_ff1_3.D_latch1$1_0.NAND2$2_0.A 0.44673f
C1632 scan_chain_0.D_ff1_0.D_latch1$1_1.NAND2$2_0.A VDD 0.78859f
C1633 programmable_folded_cascode_0.programmable_pfet$1_0.g programmable_folded_cascode_0.programmable_nfet_1.transmission_gate$18_1.out 0.21427f
C1634 transmission_gate$2$1_5.out programmable_telescopic_cascode_0.EN0 2.32647f
C1635 transmission_gate$2$1_3.out a_62818_79808# 0
C1636 scan_chain_0.D_ff1_0.D_latch1$1_0.NAND2$2_2.B a_68156_79067# 0.00415f
C1637 transmission_gate$2$1_2.out a_48900_79808# 0
C1638 programmable_5tOTA_0.ena_bar<1> programmable_5tOTA_0.programmable_nfet$7_0.transmission_gate$28_0.out 0
C1639 scan_chain_0.D_ff1_1.inv1$4_0.Y a_35869_79067# 0.00477f
C1640 programmable_folded_cascode_0.EN0 programmable_telescopic_cascode_0.programmable_nfet$4_0.g 0.0716f
C1641 scan_chain_0.D_ff1_0.D_latch1$1_1.inv1$3_0.Y SCAN_OUT 0.02305f
C1642 programmable_5tOTA_0.ena_bar<1> scan_chain_0.D_ff1_4.D_latch1$1_1.NAND2$2_2.B 0
C1643 programmable_common_source_0.programmable_pfet$5_0.transmission_gate$30_0.out IN_CS 0.32567f
C1644 programmable_telescopic_cascode_0.programmable_pfet$3_0.transmission_gate$23_0.out programmable_telescopic_cascode_0.programmable_pfet$3_0.d 8.06518f
C1645 transmission_gate$2$1_6.out programmable_folded_cascode_0.programmable_pfet_0.g 0.71509f
C1646 programmable_telescopic_cascode_0.programmable_nfet$5_1.d OUT_TELESCOPIC 69.75311f
C1647 scan_chain_0.D_ff1_6.D_latch1$1_1.NAND2$2_0.A scan_chain_0.D_ff1_6.D_latch1$1_1.Q_bar 0.02095f
C1648 scan_chain_0.D_ff1_0.inv1$4_0.Y scan_chain_0.D_ff1_0.Q_bar 0
C1649 programmable_telescopic_cascode_0.EN1 VDD 8.80178f
C1650 scan_chain_0.D_ff1_2.D_latch1$1_1.NAND2$2_2.B PROG_ENA 0.00233f
C1651 transmission_gate$2$1_5.out INN_TELESCOPIC 0.10898f
C1652 INP_TELESCOPIC INP_FOLDED 0.50222f
C1653 programmable_telescopic_cascode_0.programmable_pfet$2_0.transmission_gate$22_1.out OUT_TELESCOPIC 0.15833f
C1654 scan_chain_0.D_ff1_3.D_latch1$1_0.NAND2$2_0.A programmable_common_source_0.EN0 0.41823f
C1655 scan_chain_0.D_ff1_8.inv1$4_0.Y scan_chain_0.D_ff1_8.D_latch1$1_0.NAND2$2_2.B 0.40095f
C1656 scan_chain_0.D_ff1_8.D_latch1$1_0.NAND2$2_0.A a_29651_79067# 0
C1657 programmable_folded_cascode_0.EN1 programmable_telescopic_cascode_0.programmable_pfet$2_0.g 0.04492f
C1658 scan_chain_0.D_ff1_2.D_latch1$1_0.inv1$3_0.Y a_43570_79067# 0.00457f
C1659 programmable_folded_cascode_0.programmable_pfet_0.g IBIAS 0.69705f
C1660 programmable_telescopic_cascode_0.programmable_pfet$3_0.transmission_gate$23_0.out PROG_ENA 0
C1661 scan_chain_0.D_ff1_8.D_latch1$1_0.D a_25796_79067# 0.02982f
C1662 programmable_folded_cascode_0.EN0 programmable_folded_cascode_0.programmable_nfet$2_1.transmission_gate$20_1.out 0
C1663 transmission_gate$2$1_4.out programmable_telescopic_cascode_0.programmable_pfet$3_0.g 0.27659f
C1664 programmable_telescopic_cascode_0.EN0 programmable_telescopic_cascode_0.programmable_nfet$5_1.transmission_gate$25_1.out 0.04347f
C1665 programmable_common_source_0.EN0 scan_chain_0.D_ff1_0.inv1$4_0.Y 0.08004f
C1666 scan_chain_0.D_ff1_4.inv1$4_0.Y programmable_common_source_0.EN1 0.00133f
C1667 a_33497_79067# VDD 0.01851f
C1668 programmable_folded_cascode_0.programmable_pfet_0.g programmable_folded_cascode_0.programmable_nfet_1.transmission_gate$18_0.out 0.03259f
C1669 programmable_5tOTA_0.ena_bar<1> programmable_common_source_0.programmable_pfet$5_0.transmission_gate$30_1.out 0.00911f
C1670 scan_chain_0.D_ff1_3.inv1$4_0.Y CLK 0.32366f
C1671 scan_chain_0.D_ff1_6.D_latch1$1_1.NAND2$2_0.A scan_chain_0.D_ff1_6.D_latch1$1_1.NAND2$2_2.B 0.01576f
C1672 scan_chain_0.D_ff1_4.D_latch1$1_1.Q_bar scan_chain_0.D_ff1_4.D_latch1$1_0.NAND2$2_0.A 0
C1673 scan_chain_0.D_ff1_3.D_latch1$1_1.NAND2$2_0.A CLK 0.22611f
C1674 programmable_telescopic_cascode_0.programmable_nfet$5_1.transmission_gate$25_1.out INN_TELESCOPIC 0.18985f
C1675 programmable_5tOTA_0.ena_bar<1> scan_chain_0.D_ff1_3.D_latch1$1_1.inv1$3_0.Y 0.00102f
C1676 programmable_folded_cascode_0.programmable_nfet$2_0.g programmable_folded_cascode_0.programmable_nfet$2_1.transmission_gate$20_1.out 1.21581f
C1677 VDD OUT_CS 28.6874f
C1678 programmable_5tOTA_0.ena_bar<0> a_51271_79067# 0.01075f
C1679 scan_chain_0.D_ff1_1.D_latch1$1_1.inv1$3_0.Y PROG_ENA 0.00134f
C1680 programmable_folded_cascode_0.programmable_pfet$1_0.g programmable_folded_cascode_0.programmable_nfet$2_1.transmission_gate$20_1.out 0.26191f
C1681 programmable_telescopic_cascode_0.programmable_pfet$3_0.g INP_5T 0.51878f
C1682 a_41198_79067# CLK 0
C1683 programmable_5tOTA_0.ena_bar<0> a_41199_79808# 0
C1684 scan_chain_0.D_ff1_4.inv1$4_0.Y IBIAS 0
C1685 programmable_telescopic_cascode_0.programmable_nfet$4_0.s VDD 2.61969f
C1686 a_1210_79067# transmission_gate$2$1_7.ena 0
C1687 scan_chain_0.D_ff1_8.D_latch1$1_1.Q_bar transmission_gate$2$1_7.ena 0
C1688 scan_chain_0.D_ff1_0.Q_bar OUT_CS 0.00886f
C1689 programmable_folded_cascode_0.programmable_pfet_1.transmission_gate$16_1.out INP_5T 0.11955f
C1690 programmable_5tOTA_0.ena_bar<0> scan_chain_0.D_ff1_3.D_latch1$1_0.NAND2$2_0.A 0
C1691 scan_chain_0.D_ff1_2.D_latch1$1_0.NAND2$2_0.A programmable_5tOTA_0.ena_bar<1> 0.024f
C1692 programmable_folded_cascode_0.programmable_pfet_0.transmission_gate$16_0.out programmable_folded_cascode_0.OUT 0.05189f
C1693 programmable_5tOTA_0.programmable_nfet$8_0.transmission_gate$29_1.out IBIAS 0.63167f
C1694 programmable_common_source_0.EN1 scan_chain_0.D_ff1_0.D_latch1$1_0.inv1$3_0.Y 0
C1695 scan_chain_0.D_ff1_0.D_latch1$1_0.D scan_chain_0.D_ff1_0.inv1$4_0.Y 0.01162f
C1696 programmable_common_source_0.EN0 OUT_CS 0.29839f
C1697 a_51271_79808# scan_chain_0.D_ff1_3.inv1$4_0.Y 0.00415f
C1698 a_66673_79808# VDD 0.00877f
C1699 scan_chain_0.D_ff1_0.D_latch1$1_1.NAND2$2_0.A scan_chain_0.D_ff1_0.D_latch1$1_0.D 0.41823f
C1700 transmission_gate$2$1_5.out a_21951_79808# 0.16273f
C1701 programmable_telescopic_cascode_0.EN0 programmable_telescopic_cascode_0.programmable_nfet$6_0.transmission_gate$26_1.out 0.04373f
C1702 a_8911_79067# a_10394_79067# 0.00361f
C1703 programmable_5tOTA_0.ena_bar<0> scan_chain_0.D_ff1_2.D_latch1$1_1.NAND2$2_2.B 0.04682f
C1704 scan_chain_0.D_ff1_5.D_latch1$1_0.NAND2$2_0.A VDD 0.80598f
C1705 scan_chain_0.D_ff1_0.D_latch1$1_0.NAND2$2_2.B a_66673_79067# 0.12535f
C1706 programmable_common_source_0.EN0 programmable_common_source_0.programmable_pfet$5_0.transmission_gate$30_0.out 0.27367f
C1707 programmable_telescopic_cascode_0.programmable_nfet$4_1.transmission_gate$24_0.out programmable_telescopic_cascode_0.programmable_nfet$5_1.d 6.51274f
C1708 programmable_folded_cascode_0.EN0 programmable_folded_cascode_0.programmable_nfet$1_0.transmission_gate$19_1.out 0
C1709 a_35869_79808# a_35869_79067# 0
C1710 scan_chain_0.D_ff1_6.D_latch1$1_1.NAND2$2_0.A a_10395_79808# 0.00428f
C1711 a_29652_79808# VDD 0.0042f
C1712 programmable_telescopic_cascode_0.programmable_nfet$4_0.transmission_gate$24_1.out INN_FOLDED 0.02565f
C1713 scan_chain_0.D_ff1_0.inv1$4_0.Y a_68157_79808# 0
C1714 programmable_telescopic_cascode_0.programmable_pfet$3_0.g programmable_telescopic_cascode_0.programmable_pfet$3_0.d 59.2538f
C1715 programmable_folded_cascode_0.programmable_nfet$2_0.g programmable_folded_cascode_0.programmable_nfet$1_0.transmission_gate$19_1.out 0
C1716 scan_chain_0.D_ff1_7.inv1$4_0.Y transmission_gate$2$1_7.ena 0.00353f
C1717 programmable_folded_cascode_0.programmable_nfet$2_0.transmission_gate$20_1.out INP_5T 0.12998f
C1718 transmission_gate$2$1_6.out programmable_telescopic_cascode_0.programmable_nfet$4_0.transmission_gate$24_0.out 0.01585f
C1719 scan_chain_0.D_ff1_8.D_latch1$1_0.NAND2$2_0.A a_28168_79067# 0.02432f
C1720 a_39715_79067# a_41198_79067# 0.00361f
C1721 scan_chain_0.D_ff1_4.D_latch1$1_1.Q_bar scan_chain_0.D_ff1_4.D_latch1$1_0.inv1$3_0.Y 0.00416f
C1722 programmable_telescopic_cascode_0.programmable_pfet$3_0.g PROG_ENA 0
C1723 programmable_telescopic_cascode_0.EN0 scan_chain_0.D_ff1_2.D_latch1$1_1.NAND2$2_2.B 0
C1724 programmable_telescopic_cascode_0.programmable_nfet$4_0.transmission_gate$24_0.out IBIAS 0
C1725 scan_chain_0.D_ff1_4.inv1$4_0.Y a_60456_79808# 0
C1726 programmable_5tOTA_0.ena_bar<1> scan_chain_0.D_ff1_3.inv1$4_0.Y 0.0043f
C1727 programmable_folded_cascode_0.programmable_pfet$1_0.transmission_gate$17_1.out INP_5T 0.08847f
C1728 a_32014_79067# VDD 0.01436f
C1729 programmable_folded_cascode_0.OUT programmable_folded_cascode_0.programmable_nfet$1_0.transmission_gate$19_0.out 0.36484f
C1730 programmable_telescopic_cascode_0.EN0 programmable_telescopic_cascode_0.programmable_pfet$3_0.transmission_gate$23_0.out 0.00205f
C1731 programmable_folded_cascode_0.EN1 programmable_folded_cascode_0.programmable_pfet_0.transmission_gate$16_1.out 0.10331f
C1732 programmable_5tOTA_0.ena_bar<1> scan_chain_0.D_ff1_3.D_latch1$1_1.NAND2$2_0.A 0.06758f
C1733 scan_chain_0.D_ff1_3.D_latch1$1_0.NAND2$2_2.B transmission_gate$2$1_7.ena 0
C1734 programmable_folded_cascode_0.EN0 programmable_telescopic_cascode_0.EN1 0.06517f
C1735 transmission_gate$2$1_5.out programmable_telescopic_cascode_0.programmable_pfet$2_0.transmission_gate$22_0.out 0.09584f
C1736 scan_chain_0.D_ff1_7.D_latch1$1_0.NAND2$2_0.A scan_chain_0.D_ff1_7.D_latch1$1_0.NAND2$2_2.B 0.01576f
C1737 programmable_telescopic_cascode_0.EN1 scan_chain_0.D_ff1_1.D_latch1$1_0.NAND2$2_2.B 0
C1738 programmable_folded_cascode_0.programmable_nfet_0.transmission_gate$18_0.out VDD 0.19801f
C1739 scan_chain_0.D_ff1_7.D_latch1$1_0.D scan_chain_0.D_ff1_7.D_latch1$1_1.NAND2$2_2.B 0.01594f
C1740 programmable_5tOTA_0.ena_bar<0> programmable_common_source_0.programmable_pfet$5_0.transmission_gate$30_0.out 0.02046f
C1741 scan_chain_0.D_ff1_7.D_latch1$1_1.NAND2$2_0.A a_18095_79067# 0
C1742 a_39715_79067# CLK 0.00479f
C1743 a_25796_79067# PROG_ENA 0
C1744 programmable_telescopic_cascode_0.programmable_pfet$3_0.transmission_gate$23_0.out INN_TELESCOPIC 0.05065f
C1745 programmable_telescopic_cascode_0.EN0 scan_chain_0.D_ff1_1.D_latch1$1_1.inv1$3_0.Y 0
C1746 programmable_common_source_0.programmable_nfet$9_0.transmission_gate$31_1.out OUT_CS 1.49052f
C1747 programmable_telescopic_cascode_0.programmable_nfet$5_1.transmission_gate$25_0.out programmable_telescopic_cascode_0.programmable_nfet$5_1.d 0.83196f
C1748 scan_chain_0.D_ff1_7.D_latch1$1_0.NAND2$2_2.B VDD 1.1208f
C1749 a_68157_79808# OUT_CS 0
C1750 transmission_gate$2$1_7.out programmable_folded_cascode_0.programmable_pfet$1_1.transmission_gate$17_0.out 0.95441f
C1751 scan_chain_0.D_ff1_7.D_latch1$1_1.Q_bar a_20467_79067# 0
C1752 programmable_telescopic_cascode_0.programmable_nfet$4_0.g programmable_telescopic_cascode_0.programmable_nfet$4_0.transmission_gate$24_1.out 0.31548f
C1753 programmable_5tOTA_0.programmable_pfet$4_0.transmission_gate$27_1.out programmable_5tOTA_0.programmable_nfet$8_0.transmission_gate$29_1.out 0.05476f
C1754 scan_chain_0.D_ff1_2.D_latch1$1_0.NAND2$2_0.A a_45054_79808# 0.00428f
C1755 scan_chain_0.D_ff1_2.D_latch1$1_0.inv1$3_0.Y transmission_gate$2$1_7.ena 0
C1756 programmable_5tOTA_0.ena_bar<1> CLK 0.0182f
C1757 programmable_common_source_0.programmable_nfet$9_0.transmission_gate$31_0.out VDD 0.29689f
C1758 scan_chain_0.D_ff1_0.D_latch1$1_0.D a_66673_79808# 0.0043f
C1759 transmission_gate$2$1_6.out programmable_telescopic_cascode_0.programmable_nfet$5_0.transmission_gate$25_0.out 0.01836f
C1760 programmable_common_source_0.EN1 a_60455_79067# 0.02983f
C1761 programmable_folded_cascode_0.EN1 INP_5T 0.55612f
C1762 scan_chain_0.D_ff1_0.D_latch1$1_1.NAND2$2_0.A a_62818_79808# 0.23035f
C1763 programmable_folded_cascode_0.EN1 programmable_folded_cascode_0.programmable_nfet$1_0.g 0.13884f
C1764 programmable_folded_cascode_0.programmable_nfet$3_0.transmission_gate$21_0.out programmable_folded_cascode_0.programmable_nfet$3_0.transmission_gate$21_1.out 0.00436f
C1765 programmable_folded_cascode_0.EN0 programmable_telescopic_cascode_0.programmable_nfet$4_0.s 0.0455f
C1766 scan_chain_0.D_ff1_3.D_latch1$1_1.Q_bar transmission_gate$2$1_7.ena 0
C1767 scan_chain_0.D_ff1_4.D_latch1$1_1.NAND2$2_0.A scan_chain_0.D_ff1_4.D_latch1$1_1.inv1$3_0.Y 0
C1768 programmable_telescopic_cascode_0.programmable_nfet$5_0.transmission_gate$25_0.out IBIAS 0
C1769 scan_chain_0.D_ff1_8.D_latch1$1_0.NAND2$2_2.B CLK 0.00592f
C1770 transmission_gate$2$1_7.out programmable_telescopic_cascode_0.programmable_nfet$5_1.d 0.09376f
C1771 scan_chain_0.D_ff1_1.D_latch1$1_1.inv1$3_0.Y a_29651_79067# 0
C1772 transmission_gate$2$1_3.out scan_chain_0.D_ff1_4.D_latch1$1_0.D 0.02555f
C1773 transmission_gate$2$1_7.out programmable_telescopic_cascode_0.programmable_pfet$2_0.transmission_gate$22_1.out 0.00589f
C1774 scan_chain_0.D_ff1_6.D_latch1$1_0.inv1$3_0.Y VDD 0.41614f
C1775 a_66673_79808# a_68157_79808# 0.00361f
C1776 programmable_telescopic_cascode_0.programmable_pfet$3_1.transmission_gate$23_0.out INN_FOLDED 0.05052f
C1777 programmable_common_source_0.EN0 programmable_common_source_0.programmable_nfet$9_0.transmission_gate$31_0.out 0.04498f
C1778 programmable_5tOTA_0.programmable_pfet$4_0.transmission_gate$27_0.out IBIAS 0.06742f
C1779 transmission_gate$2$1_6.out programmable_telescopic_cascode_0.programmable_pfet$3_0.transmission_gate$23_1.out 0.006f
C1780 programmable_5tOTA_0.ena_bar<1> a_51271_79808# 0.01312f
C1781 a_24313_79808# a_24313_79067# 0
C1782 transmission_gate$2$1_3.out programmable_common_source_0.EN1 0.02751f
C1783 SCAN_OUT PROG_ENA 0.00281f
C1784 scan_chain_0.D_ff1_5.D_latch1$1_0.NAND2$2_0.A programmable_folded_cascode_0.EN0 0.02095f
C1785 a_58972_79808# a_60456_79808# 0.00361f
C1786 scan_chain_0.D_ff1_0.D_latch1$1_1.inv1$3_0.Y a_60455_79067# 0
C1787 scan_chain_0.D_ff1_7.D_latch1$1_0.inv1$3_0.Y CLK 0.00358f
C1788 transmission_gate$2$1_7.out programmable_folded_cascode_0.programmable_nfet$1_1.transmission_gate$19_0.out 0.36552f
C1789 programmable_folded_cascode_0.EN1 programmable_telescopic_cascode_0.programmable_pfet$3_0.d 0.16511f
C1790 programmable_folded_cascode_0.programmable_pfet_1.transmission_gate$16_0.out INN_FOLDED 0.05037f
C1791 scan_chain_0.D_ff1_5.D_latch1$1_0.D scan_chain_0.D_ff1_5.D_latch1$1_1.Q_bar 1.69947f
C1792 programmable_telescopic_cascode_0.EN0 programmable_telescopic_cascode_0.programmable_pfet$3_0.g 0.01927f
C1793 scan_chain_0.D_ff1_7.D_latch1$1_1.NAND2$2_0.A a_16612_79067# 0.02432f
C1794 transmission_gate$2$1_6.out programmable_telescopic_cascode_0.programmable_pfet$3_1.d 0.08017f
C1795 programmable_common_source_0.EN1 programmable_common_source_0.programmable_pfet$5_0.transmission_gate$30_1.out 0.02395f
C1796 scan_chain_0.D_ff1_4.D_latch1$1_0.D a_58972_79067# 0
C1797 a_24313_79067# PROG_ENA 0
C1798 programmable_folded_cascode_0.EN1 PROG_ENA 0.08509f
C1799 programmable_telescopic_cascode_0.programmable_pfet$3_0.g INN_TELESCOPIC 0.44948f
C1800 programmable_common_source_0.EN0 SCAN_OUT 3.26203f
C1801 programmable_folded_cascode_0.programmable_pfet_0.g VDD 55.274f
C1802 programmable_folded_cascode_0.EN0 programmable_folded_cascode_0.programmable_nfet_0.transmission_gate$18_0.out 0.05068f
C1803 programmable_telescopic_cascode_0.EN1 programmable_telescopic_cascode_0.programmable_nfet$6_0.d 0.00164f
C1804 a_37352_79067# transmission_gate$2$1_7.ena 0
C1805 transmission_gate$2$1_5.out INP_TELESCOPIC 0.10898f
C1806 a_45054_79808# CLK 0
C1807 scan_chain_0.D_ff1_0.D_latch1$1_1.Q_bar SCAN_OUT 0.0383f
C1808 transmission_gate$2$1_7.ena programmable_telescopic_cascode_0.programmable_nfet$4_1.transmission_gate$24_0.out 0
C1809 OUT_TELESCOPIC INP_FOLDED 0.38606f
C1810 programmable_telescopic_cascode_0.programmable_pfet$2_0.g INN_FOLDED 0.08819f
C1811 programmable_telescopic_cascode_0.programmable_pfet$2_0.g programmable_telescopic_cascode_0.programmable_pfet$2_1.transmission_gate$22_0.out 0.22566f
C1812 programmable_common_source_0.programmable_pfet$5_0.transmission_gate$30_1.out IBIAS 0.06752f
C1813 transmission_gate$2$1_3.out scan_chain_0.D_ff1_0.D_latch1$1_1.inv1$3_0.Y 0.01539f
C1814 scan_chain_0.D_ff1_6.D_latch1$1_0.NAND2$2_2.B PROG_ENA 0.00233f
C1815 scan_chain_0.D_ff1_4.inv1$4_0.Y VDD 0.95343f
C1816 programmable_common_source_0.programmable_nfet$9_0.transmission_gate$31_1.out programmable_common_source_0.programmable_nfet$9_0.transmission_gate$31_0.out 0.00448f
C1817 scan_chain_0.D_ff1_4.D_latch1$1_1.NAND2$2_0.A VDD 0.76162f
C1818 transmission_gate$2$1_3.out a_55117_79808# 0
C1819 programmable_folded_cascode_0.programmable_pfet_0.g programmable_folded_cascode_0.programmable_nfet$3_0.g 0.35171f
C1820 scan_chain_0.D_ff1_5.D_latch1$1_0.NAND2$2_0.A scan_chain_0.D_ff1_5.inv1$4_0.Y 0.22611f
C1821 a_6548_79067# VDD 0.01406f
C1822 programmable_5tOTA_0.programmable_pfet$4_0.transmission_gate$27_0.out programmable_5tOTA_0.programmable_pfet$4_0.transmission_gate$27_1.out 0.00503f
C1823 programmable_telescopic_cascode_0.EN1 programmable_telescopic_cascode_0.programmable_nfet$4_0.transmission_gate$24_1.out 0.00127f
C1824 programmable_5tOTA_0.ena_bar<0> SCAN_OUT 3.31078f
C1825 programmable_5tOTA_0.programmable_nfet$8_0.transmission_gate$29_1.out VDD 0.20342f
C1826 programmable_telescopic_cascode_0.programmable_nfet$4_0.s programmable_telescopic_cascode_0.programmable_nfet$6_0.d 6.03592f
C1827 transmission_gate$2$1_6.out programmable_telescopic_cascode_0.programmable_pfet$3_1.transmission_gate$23_1.out 0.0081f
C1828 scan_chain_0.D_ff1_5.D_latch1$1_0.NAND2$2_0.A a_6549_79808# 0.00428f
C1829 scan_chain_0.D_ff1_6.inv1$4_0.Y PROG_ENA 0.44521f
C1830 scan_chain_0.D_ff1_5.D_latch1$1_0.inv1$3_0.Y PROG_ENA 0.00134f
C1831 programmable_common_source_0.EN0 scan_chain_0.D_ff1_4.inv1$4_0.Y 0.07921f
C1832 a_14249_79067# CLK 0
C1833 programmable_common_source_0.EN0 scan_chain_0.D_ff1_4.D_latch1$1_1.NAND2$2_0.A 0
C1834 scan_chain_0.D_ff1_5.D_latch1$1_0.D a_2694_79808# 0.16273f
C1835 programmable_telescopic_cascode_0.programmable_pfet$2_0.g programmable_telescopic_cascode_0.programmable_nfet$4_0.g 1.51372f
C1836 scan_chain_0.D_ff1_8.D_latch1$1_1.inv1$3_0.Y scan_chain_0.D_ff1_8.D_latch1$1_1.NAND2$2_2.B 0.44307f
C1837 transmission_gate$2$1_7.ena programmable_telescopic_cascode_0.programmable_nfet$5_1.transmission_gate$25_0.out 0
C1838 scan_chain_0.D_ff1_5.D_latch1$1_0.D transmission_gate$2$1_7.ena 0
C1839 transmission_gate$2$1_3.out programmable_5tOTA_0.programmable_nfet$8_0.transmission_gate$29_0.out 0.29786f
C1840 a_14250_79808# PROG_ENA 0
C1841 programmable_telescopic_cascode_0.programmable_nfet$4_0.transmission_gate$24_0.out VDD 0.42614f
C1842 programmable_telescopic_cascode_0.EN0 a_24313_79067# 0
C1843 programmable_telescopic_cascode_0.programmable_nfet$4_0.transmission_gate$24_1.out programmable_telescopic_cascode_0.programmable_nfet$4_0.s 3.29334f
C1844 scan_chain_0.D_ff1_3.inv1$4_0.Y IBIAS 0.16301f
C1845 a_45054_79808# programmable_5tOTA_0.ena_bar<1> 0.01093f
C1846 scan_chain_0.D_ff1_1.D_latch1$1_0.D scan_chain_0.D_ff1_1.D_latch1$1_0.NAND2$2_0.A 0.44673f
C1847 a_64302_79808# SCAN_OUT 0
C1848 programmable_telescopic_cascode_0.programmable_nfet$4_1.transmission_gate$24_0.out INP_FOLDED 0.06684f
C1849 scan_chain_0.D_ff1_6.D_latch1$1_0.D CLK 0.00906f
C1850 transmission_gate$2$1_7.out transmission_gate$2$1_7.ena 0.09681f
C1851 scan_chain_0.D_ff1_4.D_latch1$1_1.inv1$3_0.Y scan_chain_0.D_ff1_4.D_latch1$1_1.NAND2$2_2.B 0.44307f
C1852 programmable_telescopic_cascode_0.EN1 programmable_telescopic_cascode_0.programmable_nfet$5_0.transmission_gate$25_1.out 0.00123f
C1853 a_35869_79067# transmission_gate$2$1_7.ena 0
C1854 programmable_telescopic_cascode_0.programmable_nfet$6_0.transmission_gate$26_1.out INP_TELESCOPIC 0.03134f
C1855 programmable_telescopic_cascode_0.programmable_pfet$3_0.g programmable_telescopic_cascode_0.programmable_pfet$2_0.transmission_gate$22_0.out 7.81101f
C1856 programmable_folded_cascode_0.EN0 programmable_folded_cascode_0.programmable_pfet_0.g 2.31284f
C1857 programmable_common_source_0.EN1 CLK 0.05487f
C1858 programmable_folded_cascode_0.EN1 INN_TELESCOPIC 0.01814f
C1859 transmission_gate$2$1_3.out a_56600_79067# 0.02046f
C1860 programmable_common_source_0.EN0 scan_chain_0.D_ff1_0.D_latch1$1_0.inv1$3_0.Y 0.00156f
C1861 a_58972_79808# VDD 0.00684f
C1862 scan_chain_0.D_ff1_1.D_latch1$1_0.NAND2$2_0.A transmission_gate$2$1_3.out 0.41823f
C1863 scan_chain_0.D_ff1_5.D_latch1$1_0.NAND2$2_0.A a_5065_79808# 0.23035f
C1864 programmable_folded_cascode_0.programmable_pfet_0.transmission_gate$16_1.out INN_FOLDED 0.10074f
C1865 scan_chain_0.D_ff1_8.D_latch1$1_1.Q_bar scan_chain_0.D_ff1_8.D_latch1$1_0.NAND2$2_0.A 0
C1866 transmission_gate$2$1_6.out CLK 0.11531f
C1867 scan_chain_0.D_ff1_0.D_latch1$1_1.Q_bar scan_chain_0.D_ff1_0.D_latch1$1_0.inv1$3_0.Y 0.00416f
C1868 transmission_gate$2$1_7.ena programmable_telescopic_cascode_0.programmable_nfet$6_0.transmission_gate$26_0.out 0
C1869 a_5065_79067# VDD 0.03353f
C1870 transmission_gate$2$1_4.out transmission_gate$2$1_3.out 0
C1871 programmable_folded_cascode_0.programmable_pfet_0.g programmable_folded_cascode_0.programmable_pfet$1_0.g 0.15274f
C1872 programmable_telescopic_cascode_0.EN1 programmable_telescopic_cascode_0.programmable_pfet$3_1.transmission_gate$23_0.out 0.01333f
C1873 scan_chain_0.D_ff1_8.D_latch1$1_1.NAND2$2_2.B transmission_gate$2$1_7.ena 0
C1874 IBIAS CLK 0.05632f
C1875 programmable_common_source_0.EN1 scan_chain_0.D_ff1_0.inv1$4_0.Y 0.04032f
C1876 programmable_folded_cascode_0.OUT programmable_folded_cascode_0.programmable_pfet$1_1.transmission_gate$17_0.out 0.02642f
C1877 transmission_gate$2$1_4.out programmable_telescopic_cascode_0.programmable_pfet$2_1.transmission_gate$22_0.out 1.07008f
C1878 programmable_common_source_0.EN1 scan_chain_0.D_ff1_0.D_latch1$1_1.NAND2$2_0.A 0.44675f
C1879 programmable_telescopic_cascode_0.programmable_nfet$5_0.transmission_gate$25_0.out VDD 0.15769f
C1880 programmable_telescopic_cascode_0.programmable_nfet$5_0.transmission_gate$25_1.out programmable_telescopic_cascode_0.programmable_nfet$4_0.s 0.41671f
C1881 a_12766_79067# CLK 0
C1882 scan_chain_0.D_ff1_1.D_latch1$1_1.Q_bar VDD 0.96651f
C1883 scan_chain_0.D_ff1_7.D_latch1$1_0.D scan_chain_0.D_ff1_7.inv1$4_0.Y 0.01122f
C1884 transmission_gate$2$1_2.out scan_chain_0.D_ff1_4.D_latch1$1_0.NAND2$2_2.B 0
C1885 transmission_gate$2$1_3.out INP_5T 0.31154f
C1886 a_1210_79808# a_2694_79808# 0.00361f
C1887 programmable_folded_cascode_0.EN0 a_6548_79067# 0.16279f
C1888 scan_chain_0.D_ff1_7.D_latch1$1_1.NAND2$2_0.A scan_chain_0.D_ff1_7.D_latch1$1_0.D 0.41823f
C1889 transmission_gate$2$1_3.out IN_CS 0.0928f
C1890 INP_5T INN_FOLDED 0.03732f
C1891 programmable_telescopic_cascode_0.programmable_nfet$5_1.d programmable_folded_cascode_0.OUT 0.16191f
C1892 programmable_telescopic_cascode_0.programmable_pfet$2_1.transmission_gate$22_0.out INP_5T 0.06038f
C1893 transmission_gate$2$1_7.out programmable_folded_cascode_0.programmable_nfet_0.transmission_gate$18_1.out 0.00103f
C1894 scan_chain_0.D_ff1_7.D_latch1$1_0.NAND2$2_2.B a_21950_79067# 0.00415f
C1895 programmable_5tOTA_0.ena_bar<0> scan_chain_0.D_ff1_0.D_latch1$1_0.inv1$3_0.Y 0.02863f
C1896 programmable_5tOTA_0.programmable_pfet$4_0.transmission_gate$27_0.out VDD 4.12227f
C1897 transmission_gate$2$1_3.out scan_chain_0.D_ff1_2.inv1$4_0.Y 0.01164f
C1898 scan_chain_0.D_ff1_7.D_latch1$1_1.inv1$3_0.Y transmission_gate$2$1_7.ena 0
C1899 transmission_gate$2$1_7.ena programmable_telescopic_cascode_0.programmable_pfet$2_1.transmission_gate$22_1.out 0
C1900 programmable_telescopic_cascode_0.programmable_pfet$2_0.transmission_gate$22_1.out programmable_folded_cascode_0.OUT 0.02552f
C1901 transmission_gate$2$1_3.out scan_chain_0.D_ff1_2.D_latch1$1_1.NAND2$2_0.A 0.46461f
C1902 a_60455_79067# PROG_ENA 0
C1903 scan_chain_0.D_ff1_7.inv1$4_0.Y transmission_gate$2$1_5.out 0.01276f
C1904 a_35869_79808# scan_chain_0.D_ff1_1.inv1$4_0.Y 0.00415f
C1905 transmission_gate$2$1_7.out INP_FOLDED 0.06039f
C1906 programmable_telescopic_cascode_0.programmable_pfet$3_0.transmission_gate$23_1.out VDD 5.6552f
C1907 a_51271_79808# IBIAS 0.00754f
C1908 scan_chain_0.D_ff1_5.D_latch1$1_1.NAND2$2_2.B CLK 0.40324f
C1909 programmable_folded_cascode_0.programmable_nfet$1_0.g programmable_folded_cascode_0.programmable_nfet_1.transmission_gate$18_1.out 0.04814f
C1910 programmable_folded_cascode_0.EN1 programmable_folded_cascode_0.programmable_pfet$1_1.transmission_gate$17_1.out 0.00672f
C1911 programmable_5tOTA_0.ena_bar<1> programmable_common_source_0.EN1 0.03063f
C1912 programmable_common_source_0.EN1 OUT_CS 0.09961f
C1913 INN_5T OUT_5T 1.39758f
C1914 scan_chain_0.D_ff1_0.D_latch1$1_1.NAND2$2_0.A scan_chain_0.D_ff1_0.D_latch1$1_1.inv1$3_0.Y 0
C1915 transmission_gate$2$1_2.out scan_chain_0.D_ff1_3.D_latch1$1_0.inv1$3_0.Y 0
C1916 scan_chain_0.D_ff1_8.inv1$4_0.Y VDD 0.98127f
C1917 a_8911_79808# CLK 0.00415f
C1918 programmable_5tOTA_0.programmable_nfet$7_0.transmission_gate$28_0.out VDD 0.18508f
C1919 scan_chain_0.D_ff1_3.D_latch1$1_0.NAND2$2_2.B a_52754_79067# 0.00415f
C1920 a_60456_79808# CLK 0
C1921 scan_chain_0.D_ff1_1.D_latch1$1_0.D PROG_ENA 0.00152f
C1922 programmable_telescopic_cascode_0.EN1 programmable_telescopic_cascode_0.programmable_pfet$2_0.g 0.03148f
C1923 scan_chain_0.D_ff1_4.D_latch1$1_1.NAND2$2_2.B VDD 1.07924f
C1924 scan_chain_0.D_ff1_8.D_latch1$1_1.NAND2$2_0.A VDD 0.80517f
C1925 transmission_gate$2$1_4.out a_32014_79808# 0.0043f
C1926 transmission_gate$2$1_3.out programmable_5tOTA_0.programmable_pfet$4_0.g 0.66736f
C1927 transmission_gate$2$1_3.out a_55117_79067# 0.02046f
C1928 transmission_gate$2$1_4.out programmable_telescopic_cascode_0.programmable_nfet$4_0.g 0.12311f
C1929 programmable_folded_cascode_0.OUT programmable_folded_cascode_0.programmable_nfet$1_1.transmission_gate$19_0.out 0.15243f
C1930 programmable_folded_cascode_0.EN0 programmable_telescopic_cascode_0.programmable_nfet$4_0.transmission_gate$24_0.out 0.05415f
C1931 programmable_telescopic_cascode_0.programmable_pfet$3_1.d VDD 0.19676p
C1932 transmission_gate$2$1_2.out INN_5T 0.16072f
C1933 programmable_common_source_0.EN0 a_60455_79067# 0
C1934 scan_chain_0.D_ff1_5.D_latch1$1_1.inv1$3_0.Y transmission_gate$2$1_7.ena 0.01126f
C1935 programmable_telescopic_cascode_0.programmable_pfet$2_1.transmission_gate$22_0.out programmable_telescopic_cascode_0.programmable_pfet$3_0.d 0.06196f
C1936 programmable_telescopic_cascode_0.programmable_pfet$3_0.d INN_FOLDED 0.386f
C1937 scan_chain_0.D_ff1_0.D_latch1$1_1.NAND2$2_2.B CLK 0.40528f
C1938 transmission_gate$2$1_3.out PROG_ENA 0.10823f
C1939 transmission_gate$2$1_3.out scan_chain_0.D_ff1_3.D_latch1$1_0.D 0.02555f
C1940 programmable_5tOTA_0.ena_bar<1> IBIAS 0.29226f
C1941 programmable_telescopic_cascode_0.programmable_nfet$4_0.g INP_5T 0.09923f
C1942 scan_chain_0.D_ff1_5.inv1$4_0.Y a_6548_79067# 0
C1943 programmable_folded_cascode_0.EN1 programmable_telescopic_cascode_0.programmable_pfet$2_0.transmission_gate$22_0.out 0.0274f
C1944 scan_chain_0.D_ff1_7.D_latch1$1_1.Q_bar PROG_ENA 0.00175f
C1945 transmission_gate$2$1_3.out programmable_5tOTA_0.programmable_pfet$4_1.transmission_gate$27_0.out 0
C1946 programmable_common_source_0.programmable_pfet$5_0.transmission_gate$30_1.out VDD 6.56297f
C1947 scan_chain_0.D_ff1_2.D_latch1$1_1.Q_bar scan_chain_0.D_ff1_2.D_latch1$1_0.inv1$3_0.Y 0.00416f
C1948 scan_chain_0.D_ff1_5.D_latch1$1_0.D scan_chain_0.D_ff1_5.D_latch1$1_0.NAND2$2_2.B 0.00115f
C1949 programmable_telescopic_cascode_0.programmable_pfet$2_1.transmission_gate$22_0.out PROG_ENA 0
C1950 transmission_gate$2$1_3.out scan_chain_0.D_ff1_2.D_latch1$1_0.NAND2$2_2.B 0.00915f
C1951 transmission_gate$2$1_2.out OUT_5T 0.02203f
C1952 programmable_common_source_0.EN0 scan_chain_0.D_ff1_4.D_latch1$1_1.NAND2$2_2.B 0.00266f
C1953 scan_chain_0.D_ff1_3.D_latch1$1_1.inv1$3_0.Y VDD 0.37659f
C1954 scan_chain_0.D_ff1_7.D_latch1$1_0.D a_20467_79808# 0.0043f
C1955 a_33498_79808# VDD 0.00822f
C1956 programmable_telescopic_cascode_0.programmable_pfet$2_0.g programmable_telescopic_cascode_0.programmable_nfet$4_0.s 0.22861f
C1957 a_6549_79808# a_6548_79067# 0
C1958 scan_chain_0.D_ff1_7.D_latch1$1_1.NAND2$2_0.A a_16612_79808# 0.23035f
C1959 transmission_gate$2$1_2.out programmable_5tOTA_0.programmable_nfet$7_1.transmission_gate$28_1.out 0.42287f
C1960 scan_chain_0.D_ff1_0.Q_bar programmable_common_source_0.programmable_pfet$5_0.transmission_gate$30_1.out 0
C1961 transmission_gate$2$1_5.out OUT_TELESCOPIC 0.33857f
C1962 scan_chain_0.D_ff1_1.D_latch1$1_0.D scan_chain_0.D_ff1_1.D_latch1$1_0.inv1$3_0.Y 0.29948f
C1963 transmission_gate$2$1_3.out programmable_common_source_0.EN0 0.02573f
C1964 programmable_folded_cascode_0.EN1 programmable_folded_cascode_0.programmable_nfet$1_1.transmission_gate$19_1.out 0.05054f
C1965 scan_chain_0.D_ff1_7.D_latch1$1_0.NAND2$2_2.B a_20467_79067# 0.12535f
C1966 transmission_gate$2$1_7.out programmable_folded_cascode_0.programmable_nfet$3_0.transmission_gate$21_1.out 0
C1967 programmable_5tOTA_0.ena_bar<0> a_60455_79067# 0.0119f
C1968 transmission_gate$2$1_7.out scan_chain_0.D_ff1_5.D_latch1$1_0.NAND2$2_2.B 0.01635f
C1969 scan_chain_0.D_ff1_4.D_latch1$1_1.inv1$3_0.Y CLK 0.02415f
C1970 programmable_folded_cascode_0.EN1 scan_chain_0.D_ff1_7.D_latch1$1_1.NAND2$2_2.B 0.00218f
C1971 scan_chain_0.D_ff1_2.D_latch1$1_0.NAND2$2_0.A VDD 0.76162f
C1972 programmable_folded_cascode_0.EN0 programmable_telescopic_cascode_0.programmable_nfet$5_0.transmission_gate$25_0.out 0.05393f
C1973 transmission_gate$2$1_3.out scan_chain_0.D_ff1_0.D_latch1$1_1.Q_bar 0.00634f
C1974 a_10394_79067# transmission_gate$2$1_7.ena 0
C1975 transmission_gate$2$1_3.out a_43570_79808# 0.00357f
C1976 programmable_common_source_0.EN0 programmable_common_source_0.programmable_pfet$5_0.transmission_gate$30_1.out 0.02024f
C1977 a_58972_79067# PROG_ENA 0
C1978 programmable_telescopic_cascode_0.programmable_nfet$4_0.g programmable_telescopic_cascode_0.programmable_pfet$3_0.d 0
C1979 a_20467_79808# transmission_gate$2$1_5.out 0
C1980 scan_chain_0.D_ff1_1.D_latch1$1_1.Q_bar scan_chain_0.D_ff1_1.D_latch1$1_0.NAND2$2_2.B 0.00216f
C1981 programmable_telescopic_cascode_0.programmable_pfet$3_1.transmission_gate$23_1.out VDD 5.2657f
C1982 scan_chain_0.D_ff1_3.D_latch1$1_0.NAND2$2_2.B a_51271_79067# 0.12535f
C1983 a_28168_79808# VDD 0.0137f
C1984 programmable_5tOTA_0.ena_bar<1> a_60456_79808# 0.01415f
C1985 transmission_gate$2$1_2.out a_45053_79067# 0.02993f
C1986 scan_chain_0.D_ff1_7.D_latch1$1_1.inv1$3_0.Y a_16612_79067# 0.00457f
C1987 scan_chain_0.D_ff1_4.D_latch1$1_1.Q_bar SCAN_OUT 0.00229f
C1988 a_39715_79808# scan_chain_0.D_ff1_2.D_latch1$1_0.D 0
C1989 programmable_telescopic_cascode_0.programmable_nfet$4_0.g PROG_ENA 0
C1990 scan_chain_0.D_ff1_2.D_latch1$1_1.NAND2$2_0.A scan_chain_0.D_ff1_2.D_latch1$1_1.inv1$3_0.Y 0
C1991 transmission_gate$2$1_3.out programmable_5tOTA_0.ena_bar<0> 31.5501f
C1992 programmable_common_source_0.EN0 a_58972_79067# 0
C1993 programmable_5tOTA_0.ena_bar<1> scan_chain_0.D_ff1_0.D_latch1$1_1.NAND2$2_2.B 0
C1994 scan_chain_0.D_ff1_6.D_latch1$1_1.Q_bar scan_chain_0.D_ff1_6.D_latch1$1_0.inv1$3_0.Y 0.00416f
C1995 programmable_telescopic_cascode_0.EN0 scan_chain_0.D_ff1_1.D_latch1$1_0.D 0
C1996 scan_chain_0.D_ff1_3.D_latch1$1_0.NAND2$2_0.A scan_chain_0.D_ff1_3.D_latch1$1_0.NAND2$2_2.B 0.01576f
C1997 scan_chain_0.D_ff1_0.D_latch1$1_0.NAND2$2_2.B SCAN_OUT 0.07707f
C1998 scan_chain_0.D_ff1_3.inv1$4_0.Y VDD 0.91701f
C1999 transmission_gate$2$1_7.ena SCAN_IN 0.00538f
C2000 programmable_folded_cascode_0.EN0 programmable_telescopic_cascode_0.programmable_pfet$3_0.transmission_gate$23_1.out 0.04694f
C2001 programmable_5tOTA_0.ena_bar<1> programmable_5tOTA_0.programmable_pfet$4_0.transmission_gate$27_1.out 0.01366f
C2002 scan_chain_0.D_ff1_3.D_latch1$1_1.NAND2$2_2.B PROG_ENA 0.00233f
C2003 scan_chain_0.D_ff1_3.D_latch1$1_0.D scan_chain_0.D_ff1_3.D_latch1$1_1.NAND2$2_2.B 0.01594f
C2004 scan_chain_0.D_ff1_3.D_latch1$1_1.NAND2$2_0.A a_48899_79067# 0
C2005 scan_chain_0.D_ff1_3.D_latch1$1_1.NAND2$2_0.A VDD 0.76162f
C2006 programmable_folded_cascode_0.programmable_nfet$1_0.g programmable_folded_cascode_0.programmable_nfet$1_0.transmission_gate$19_1.out 0.19981f
C2007 programmable_common_source_0.EN1 programmable_common_source_0.programmable_nfet$9_0.transmission_gate$31_0.out 0
C2008 transmission_gate$2$1_3.out a_47416_79808# 0
C2009 scan_chain_0.D_ff1_5.inv1$4_0.Y a_5065_79067# 0.00477f
C2010 a_18096_79808# PROG_ENA 0
C2011 programmable_folded_cascode_0.programmable_nfet$1_0.transmission_gate$19_1.out INP_5T 0.07676f
C2012 scan_chain_0.D_ff1_3.D_latch1$1_1.inv1$3_0.Y a_47416_79067# 0.00457f
C2013 programmable_folded_cascode_0.EN0 programmable_telescopic_cascode_0.programmable_pfet$3_1.d 0.03836f
C2014 a_41198_79067# VDD 0.01219f
C2015 programmable_5tOTA_0.programmable_nfet$7_1.transmission_gate$28_0.out INP_5T 0.23025f
C2016 programmable_telescopic_cascode_0.EN0 transmission_gate$2$1_3.out 0
C2017 transmission_gate$2$1_4.out programmable_telescopic_cascode_0.EN1 2.56929f
C2018 programmable_telescopic_cascode_0.EN0 programmable_telescopic_cascode_0.programmable_pfet$2_1.transmission_gate$22_0.out 0.00204f
C2019 scan_chain_0.D_ff1_3.D_latch1$1_1.Q_bar a_51271_79067# 0
C2020 programmable_telescopic_cascode_0.programmable_nfet$4_0.transmission_gate$24_0.out programmable_telescopic_cascode_0.programmable_nfet$6_0.d 0
C2021 transmission_gate$2$1_5.out programmable_telescopic_cascode_0.programmable_nfet$4_1.transmission_gate$24_0.out 0.35635f
C2022 scan_chain_0.D_ff1_1.D_latch1$1_1.NAND2$2_0.A scan_chain_0.D_ff1_1.D_latch1$1_1.NAND2$2_2.B 0.01576f
C2023 programmable_5tOTA_0.ena_bar<1> scan_chain_0.D_ff1_4.D_latch1$1_1.inv1$3_0.Y 0
C2024 scan_chain_0.D_ff1_2.D_latch1$1_1.inv1$3_0.Y PROG_ENA 0.00134f
C2025 programmable_5tOTA_0.ena_bar<0> a_58972_79067# 0.01075f
C2026 a_48899_79067# CLK 0
C2027 scan_chain_0.D_ff1_3.inv1$4_0.Y programmable_common_source_0.EN0 0.00155f
C2028 INN_TELESCOPIC INN_FOLDED 0.75442f
C2029 programmable_telescopic_cascode_0.programmable_pfet$2_1.transmission_gate$22_0.out INN_TELESCOPIC 0.0471f
C2030 scan_chain_0.D_ff1_2.D_latch1$1_0.D a_43570_79067# 0
C2031 scan_chain_0.D_ff1_3.D_latch1$1_1.Q_bar scan_chain_0.D_ff1_3.D_latch1$1_0.NAND2$2_0.A 0
C2032 programmable_folded_cascode_0.EN1 INP_TELESCOPIC 0.01814f
C2033 VDD CLK 28.7293f
C2034 programmable_5tOTA_0.programmable_pfet$4_1.transmission_gate$27_1.out INN_5T 0.02529f
C2035 scan_chain_0.D_ff1_8.inv1$4_0.Y scan_chain_0.D_ff1_8.D_latch1$1_0.inv1$3_0.Y 0.00878f
C2036 transmission_gate$2$1_6.out a_14249_79067# 0.02983f
C2037 a_8911_79067# transmission_gate$2$1_7.ena 0
C2038 transmission_gate$2$1_3.out a_64302_79808# 0
C2039 programmable_telescopic_cascode_0.EN1 scan_chain_0.D_ff1_2.inv1$4_0.Y 0
C2040 programmable_folded_cascode_0.programmable_pfet_0.transmission_gate$16_0.out INP_FOLDED 0.07777f
C2041 scan_chain_0.D_ff1_6.D_latch1$1_1.NAND2$2_0.A scan_chain_0.D_ff1_6.D_latch1$1_1.inv1$3_0.Y 0
C2042 programmable_telescopic_cascode_0.programmable_nfet$4_0.transmission_gate$24_1.out programmable_telescopic_cascode_0.programmable_nfet$4_0.transmission_gate$24_0.out 0.0044f
C2043 programmable_5tOTA_0.programmable_pfet$4_0.g programmable_5tOTA_0.programmable_nfet$7_1.transmission_gate$28_0.out 0.71253f
C2044 transmission_gate$2$1_4.out programmable_telescopic_cascode_0.programmable_nfet$4_0.s 0.00226f
C2045 transmission_gate$2$1_2.out scan_chain_0.D_ff1_0.D_latch1$1_0.NAND2$2_0.A 0.0131f
C2046 programmable_telescopic_cascode_0.programmable_pfet$3_0.transmission_gate$23_0.out OUT_TELESCOPIC 0.05906f
C2047 programmable_5tOTA_0.programmable_pfet$4_1.transmission_gate$27_1.out OUT_5T 1.38081f
C2048 programmable_folded_cascode_0.programmable_nfet_0.transmission_gate$18_1.out programmable_folded_cascode_0.programmable_nfet$1_0.transmission_gate$19_0.out 0.06918f
C2049 scan_chain_0.D_ff1_8.D_latch1$1_1.Q_bar a_25796_79067# 0.16279f
C2050 a_12766_79067# a_14249_79067# 0.00361f
C2051 programmable_folded_cascode_0.programmable_nfet$3_0.transmission_gate$21_0.out programmable_folded_cascode_0.programmable_nfet$2_0.transmission_gate$20_1.out 0.05879f
C2052 programmable_5tOTA_0.ena_bar<0> scan_chain_0.D_ff1_3.D_latch1$1_1.NAND2$2_2.B 0.04442f
C2053 programmable_folded_cascode_0.programmable_pfet_1.transmission_gate$16_0.out programmable_folded_cascode_0.programmable_pfet_0.g 0.2358f
C2054 IN_CS OUT_CS 3.25926f
C2055 programmable_telescopic_cascode_0.programmable_nfet$5_0.transmission_gate$25_0.out programmable_telescopic_cascode_0.programmable_nfet$6_0.d 0.8245f
C2056 a_64301_79067# SCAN_OUT 0
C2057 programmable_telescopic_cascode_0.EN0 programmable_telescopic_cascode_0.programmable_nfet$4_0.g 0.02057f
C2058 transmission_gate$2$1_3.out a_37353_79808# 0.16273f
C2059 programmable_common_source_0.EN0 CLK 0.28868f
C2060 programmable_folded_cascode_0.OUT programmable_folded_cascode_0.programmable_nfet_0.transmission_gate$18_1.out 0.04751f
C2061 transmission_gate$2$1_5.out programmable_telescopic_cascode_0.programmable_nfet$5_1.transmission_gate$25_0.out 0.3816f
C2062 scan_chain_0.D_ff1_4.D_latch1$1_0.D scan_chain_0.D_ff1_4.inv1$4_0.Y 0.01122f
C2063 transmission_gate$2$1_2.out programmable_5tOTA_0.programmable_pfet$4_1.transmission_gate$27_1.out 0
C2064 programmable_telescopic_cascode_0.EN1 programmable_telescopic_cascode_0.programmable_pfet$3_0.d 0
C2065 a_51271_79808# VDD 0.00189f
C2066 programmable_folded_cascode_0.EN0 programmable_telescopic_cascode_0.programmable_pfet$3_1.transmission_gate$23_1.out 0.05007f
C2067 scan_chain_0.D_ff1_3.D_latch1$1_1.NAND2$2_0.A a_47416_79067# 0.02432f
C2068 programmable_telescopic_cascode_0.programmable_nfet$4_0.s INP_5T 0.20665f
C2069 scan_chain_0.D_ff1_4.D_latch1$1_1.NAND2$2_0.A scan_chain_0.D_ff1_4.D_latch1$1_0.D 0.41823f
C2070 scan_chain_0.D_ff1_7.inv1$4_0.Y programmable_telescopic_cascode_0.programmable_pfet$3_0.g 0.00167f
C2071 programmable_telescopic_cascode_0.programmable_nfet$4_0.g INN_TELESCOPIC 0.06784f
C2072 a_5065_79808# a_5065_79067# 0
C2073 a_43570_79067# a_45053_79067# 0.00361f
C2074 a_39715_79067# VDD 0.00984f
C2075 programmable_folded_cascode_0.OUT INP_FOLDED 0.04049f
C2076 programmable_common_source_0.EN1 IBIAS 0.31569f
C2077 programmable_telescopic_cascode_0.EN1 PROG_ENA 0.05978f
C2078 scan_chain_0.D_ff1_6.D_latch1$1_0.D a_12766_79067# 0
C2079 scan_chain_0.D_ff1_4.inv1$4_0.Y programmable_common_source_0.EN1 0.01266f
C2080 programmable_5tOTA_0.ena_bar<0> scan_chain_0.D_ff1_2.D_latch1$1_1.inv1$3_0.Y 0.03432f
C2081 transmission_gate$2$1_4.out a_29652_79808# 0.16273f
C2082 transmission_gate$2$1_7.out transmission_gate$2$1_5.out 0.47415f
C2083 programmable_common_source_0.EN0 scan_chain_0.D_ff1_0.inv1$4_0.Y 0.01934f
C2084 scan_chain_0.D_ff1_0.D_latch1$1_0.inv1$3_0.Y scan_chain_0.D_ff1_0.D_latch1$1_0.NAND2$2_2.B 0.44289f
C2085 scan_chain_0.D_ff1_4.D_latch1$1_0.NAND2$2_2.B transmission_gate$2$1_7.ena 0
C2086 programmable_telescopic_cascode_0.programmable_nfet$5_1.transmission_gate$25_1.out programmable_telescopic_cascode_0.programmable_nfet$5_1.transmission_gate$25_0.out 0.00434f
C2087 transmission_gate$2$1_6.out IBIAS 0.17689f
C2088 programmable_5tOTA_0.ena_bar<1> a_48899_79067# 0
C2089 a_33497_79067# PROG_ENA 0
C2090 scan_chain_0.D_ff1_1.inv1$4_0.Y transmission_gate$2$1_7.ena 0.00353f
C2091 scan_chain_0.D_ff1_3.inv1$4_0.Y a_52755_79808# 0
C2092 a_47416_79067# CLK 0.00479f
C2093 scan_chain_0.D_ff1_0.D_latch1$1_0.D CLK 0.00529f
C2094 programmable_5tOTA_0.ena_bar<1> VDD 7.69938f
C2095 transmission_gate$2$1_4.out a_32014_79067# 0
C2096 transmission_gate$2$1_6.out programmable_folded_cascode_0.programmable_nfet_1.transmission_gate$18_0.out 0.00102f
C2097 scan_chain_0.D_ff1_0.D_latch1$1_1.NAND2$2_0.A scan_chain_0.D_ff1_0.D_latch1$1_1.Q_bar 0.02095f
C2098 programmable_folded_cascode_0.EN1 programmable_folded_cascode_0.programmable_nfet$3_0.transmission_gate$21_0.out 0
C2099 programmable_telescopic_cascode_0.EN0 scan_chain_0.D_ff1_2.D_latch1$1_1.inv1$3_0.Y 0
C2100 scan_chain_0.D_ff1_5.D_latch1$1_0.inv1$3_0.Y a_2693_79067# 0
C2101 transmission_gate$2$1_7.out programmable_telescopic_cascode_0.programmable_nfet$5_1.transmission_gate$25_1.out 0.01591f
C2102 transmission_gate$2$1_5.out programmable_telescopic_cascode_0.programmable_nfet$6_0.transmission_gate$26_0.out 0
C2103 scan_chain_0.D_ff1_8.D_latch1$1_0.NAND2$2_2.B VDD 1.10258f
C2104 programmable_5tOTA_0.ena_bar<1> scan_chain_0.D_ff1_0.Q_bar 0.03831f
C2105 scan_chain_0.D_ff1_3.D_latch1$1_0.inv1$3_0.Y transmission_gate$2$1_7.ena 0
C2106 transmission_gate$2$1_5.out scan_chain_0.D_ff1_8.D_latch1$1_1.NAND2$2_2.B 0.0025f
C2107 a_8911_79808# scan_chain_0.D_ff1_6.D_latch1$1_0.D 0
C2108 scan_chain_0.D_ff1_7.D_latch1$1_0.NAND2$2_0.A scan_chain_0.D_ff1_7.D_latch1$1_0.inv1$3_0.Y 0
C2109 programmable_telescopic_cascode_0.programmable_pfet$2_0.transmission_gate$22_0.out INN_FOLDED 0.05166f
C2110 programmable_5tOTA_0.ena_bar<0> programmable_5tOTA_0.programmable_nfet$7_1.transmission_gate$28_0.out 0.09954f
C2111 programmable_telescopic_cascode_0.EN1 scan_chain_0.D_ff1_1.D_latch1$1_0.inv1$3_0.Y 0
C2112 programmable_folded_cascode_0.EN0 CLK 0.07181f
C2113 programmable_5tOTA_0.ena_bar<0> scan_chain_0.D_ff1_0.inv1$4_0.Y 0.02526f
C2114 programmable_folded_cascode_0.programmable_nfet$2_0.transmission_gate$20_0.out programmable_folded_cascode_0.programmable_nfet$2_0.transmission_gate$20_1.out 0.00448f
C2115 programmable_telescopic_cascode_0.programmable_pfet$3_0.g OUT_TELESCOPIC 1.32405f
C2116 a_60456_79808# programmable_common_source_0.EN1 0.01093f
C2117 a_25797_79808# a_25796_79067# 0
C2118 programmable_5tOTA_0.ena_bar<1> programmable_common_source_0.EN0 0.03063f
C2119 programmable_5tOTA_0.ena_bar<0> scan_chain_0.D_ff1_0.D_latch1$1_1.NAND2$2_0.A 0
C2120 transmission_gate$2$1_6.out programmable_telescopic_cascode_0.programmable_nfet$4_1.transmission_gate$24_1.out 0.00452f
C2121 programmable_folded_cascode_0.programmable_nfet_0.transmission_gate$18_0.out INP_5T 0.06048f
C2122 scan_chain_0.D_ff1_1.D_latch1$1_0.NAND2$2_2.B CLK 0.01135f
C2123 programmable_common_source_0.EN0 OUT_CS 0.23301f
C2124 a_52755_79808# CLK 0
C2125 programmable_telescopic_cascode_0.programmable_nfet$5_0.transmission_gate$25_1.out programmable_telescopic_cascode_0.programmable_nfet$5_0.transmission_gate$25_0.out 0.00434f
C2126 scan_chain_0.D_ff1_1.D_latch1$1_0.inv1$3_0.Y a_33497_79067# 0
C2127 a_62818_79067# SCAN_OUT 0
C2128 scan_chain_0.D_ff1_4.D_latch1$1_0.D a_58972_79808# 0.0043f
C2129 scan_chain_0.D_ff1_7.D_latch1$1_0.inv1$3_0.Y VDD 0.38286f
C2130 programmable_folded_cascode_0.programmable_pfet$1_0.transmission_gate$17_0.out programmable_folded_cascode_0.programmable_pfet$1_0.transmission_gate$17_1.out 0.00142f
C2131 scan_chain_0.D_ff1_4.D_latch1$1_1.NAND2$2_0.A a_55117_79808# 0.23035f
C2132 scan_chain_0.D_ff1_2.D_latch1$1_0.D transmission_gate$2$1_7.ena 0
C2133 transmission_gate$2$1_5.out programmable_telescopic_cascode_0.programmable_pfet$2_1.transmission_gate$22_1.out 0.87082f
C2134 programmable_telescopic_cascode_0.EN1 programmable_5tOTA_0.ena_bar<0> 0
C2135 scan_chain_0.D_ff1_7.D_latch1$1_1.Q_bar scan_chain_0.D_ff1_7.D_latch1$1_1.NAND2$2_2.B 0.13783f
C2136 programmable_common_source_0.EN1 scan_chain_0.D_ff1_0.D_latch1$1_1.NAND2$2_2.B 0.00262f
C2137 transmission_gate$2$1_6.out programmable_folded_cascode_0.programmable_nfet$2_1.transmission_gate$20_0.out 0.00231f
C2138 a_29652_79808# PROG_ENA 0
C2139 transmission_gate$2$1_7.out programmable_telescopic_cascode_0.programmable_nfet$6_0.transmission_gate$26_1.out 0.02266f
C2140 scan_chain_0.D_ff1_8.D_latch1$1_0.inv1$3_0.Y CLK 0.00358f
C2141 scan_chain_0.D_ff1_0.D_latch1$1_0.inv1$3_0.Y a_64301_79067# 0
C2142 a_58972_79808# programmable_common_source_0.EN1 0
C2143 transmission_gate$2$1_2.out transmission_gate$2$1_7.ena 0.0131f
C2144 programmable_telescopic_cascode_0.EN0 programmable_telescopic_cascode_0.EN1 9.07065f
C2145 programmable_5tOTA_0.ena_bar<1> a_47416_79067# 0
C2146 programmable_5tOTA_0.ena_bar<1> scan_chain_0.D_ff1_0.D_latch1$1_0.D 0.08155f
C2147 programmable_folded_cascode_0.EN1 scan_chain_0.D_ff1_7.D_latch1$1_1.NAND2$2_0.A 0
C2148 programmable_telescopic_cascode_0.programmable_pfet$2_0.transmission_gate$22_0.out programmable_telescopic_cascode_0.programmable_nfet$4_0.g 0.00242f
C2149 programmable_telescopic_cascode_0.programmable_pfet$2_0.g programmable_telescopic_cascode_0.programmable_nfet$4_0.transmission_gate$24_0.out 0.03789f
C2150 programmable_5tOTA_0.ena_bar<0> OUT_CS 0.14499f
C2151 a_32014_79067# PROG_ENA 0
C2152 a_45054_79808# VDD 0.0019f
C2153 a_51271_79808# a_52755_79808# 0.00361f
C2154 programmable_5tOTA_0.programmable_pfet$4_0.transmission_gate$27_1.out IBIAS 0.03508f
C2155 a_62818_79808# CLK 0.00415f
C2156 scan_chain_0.D_ff1_0.D_latch1$1_1.NAND2$2_0.A a_64302_79808# 0.00428f
C2157 programmable_folded_cascode_0.EN1 programmable_folded_cascode_0.programmable_nfet$2_0.transmission_gate$20_0.out 0
C2158 programmable_telescopic_cascode_0.EN1 INN_TELESCOPIC 0.0089f
C2159 programmable_folded_cascode_0.programmable_pfet_0.g programmable_folded_cascode_0.programmable_pfet_0.transmission_gate$16_1.out 0.36351f
C2160 scan_chain_0.D_ff1_5.inv1$4_0.Y CLK 0.32366f
C2161 programmable_folded_cascode_0.EN1 programmable_folded_cascode_0.programmable_pfet$1_0.transmission_gate$17_0.out 0
C2162 scan_chain_0.D_ff1_5.D_latch1$1_1.NAND2$2_0.A CLK 0.22611f
C2163 programmable_telescopic_cascode_0.programmable_nfet$6_0.transmission_gate$26_1.out programmable_telescopic_cascode_0.programmable_nfet$6_0.transmission_gate$26_0.out 0.00408f
C2164 transmission_gate$2$1_3.out scan_chain_0.D_ff1_4.D_latch1$1_1.Q_bar 0.00634f
C2165 programmable_5tOTA_0.ena_bar<1> a_68157_79808# 0.01415f
C2166 a_45053_79067# transmission_gate$2$1_7.ena 0
C2167 programmable_5tOTA_0.programmable_nfet$8_0.transmission_gate$29_1.out programmable_5tOTA_0.programmable_nfet$8_0.transmission_gate$29_0.out 0.00448f
C2168 transmission_gate$2$1_7.out programmable_telescopic_cascode_0.programmable_pfet$3_0.transmission_gate$23_0.out 0.01443f
C2169 programmable_telescopic_cascode_0.EN1 a_29651_79067# 0.16279f
C2170 transmission_gate$2$1_3.out scan_chain_0.D_ff1_0.D_latch1$1_0.NAND2$2_2.B 0.00915f
C2171 programmable_telescopic_cascode_0.programmable_pfet$3_0.g programmable_telescopic_cascode_0.programmable_nfet$4_1.transmission_gate$24_0.out 0.03816f
C2172 a_6549_79808# CLK 0
C2173 programmable_telescopic_cascode_0.programmable_pfet$3_1.transmission_gate$23_0.out programmable_telescopic_cascode_0.programmable_pfet$3_0.transmission_gate$23_1.out 0.0297f
C2174 scan_chain_0.D_ff1_4.D_latch1$1_0.NAND2$2_0.A scan_chain_0.D_ff1_4.D_latch1$1_0.NAND2$2_2.B 0.01576f
C2175 scan_chain_0.D_ff1_7.D_latch1$1_0.NAND2$2_2.B PROG_ENA 0.00233f
C2176 scan_chain_0.D_ff1_4.D_latch1$1_0.D scan_chain_0.D_ff1_4.D_latch1$1_1.NAND2$2_2.B 0.01594f
C2177 programmable_telescopic_cascode_0.EN0 programmable_telescopic_cascode_0.programmable_nfet$4_0.s 0
C2178 programmable_5tOTA_0.ena_bar<1> a_52755_79808# 0.01415f
C2179 scan_chain_0.D_ff1_4.D_latch1$1_1.NAND2$2_0.A a_56600_79067# 0
C2180 programmable_folded_cascode_0.programmable_pfet_0.g programmable_folded_cascode_0.programmable_nfet$1_0.g 0.2105f
C2181 programmable_folded_cascode_0.programmable_pfet_0.g INP_5T 0.13509f
C2182 a_14249_79067# VDD 0.01944f
C2183 programmable_telescopic_cascode_0.programmable_nfet$4_0.s INN_TELESCOPIC 0.34984f
C2184 programmable_telescopic_cascode_0.programmable_pfet$3_1.transmission_gate$23_0.out programmable_telescopic_cascode_0.programmable_pfet$3_1.d 8.08076f
C2185 programmable_folded_cascode_0.EN1 OUT_TELESCOPIC 0.13983f
C2186 INP_TELESCOPIC INN_FOLDED 0.75442f
C2187 scan_chain_0.D_ff1_4.D_latch1$1_1.Q_bar a_58972_79067# 0
C2188 programmable_common_source_0.EN0 programmable_common_source_0.programmable_nfet$9_0.transmission_gate$31_0.out 0.22536f
C2189 scan_chain_0.D_ff1_6.D_latch1$1_0.inv1$3_0.Y PROG_ENA 0.00134f
C2190 a_21950_79067# CLK 0
C2191 transmission_gate$2$1_2.out a_68156_79067# 0
C2192 programmable_5tOTA_0.ena_bar<1> a_62818_79808# 0.01312f
C2193 scan_chain_0.D_ff1_8.D_latch1$1_0.inv1$3_0.Y scan_chain_0.D_ff1_8.D_latch1$1_0.NAND2$2_2.B 0.44289f
C2194 programmable_telescopic_cascode_0.programmable_pfet$3_0.transmission_gate$23_0.out programmable_telescopic_cascode_0.programmable_pfet$2_1.transmission_gate$22_1.out 0.13347f
C2195 scan_chain_0.D_ff1_6.D_latch1$1_0.D VDD 1.65646f
C2196 programmable_common_source_0.EN1 programmable_common_source_0.programmable_pfet$5_0.transmission_gate$30_1.out 0.00989f
C2197 transmission_gate$2$1_7.ena programmable_telescopic_cascode_0.programmable_pfet$2_0.transmission_gate$22_1.out 0
C2198 scan_chain_0.D_ff1_8.inv1$4_0.Y programmable_telescopic_cascode_0.programmable_pfet$2_0.g 0
C2199 programmable_common_source_0.EN1 VDD 4.45818f
C2200 programmable_5tOTA_0.programmable_nfet$8_0.transmission_gate$29_1.out INP_5T 0
C2201 transmission_gate$2$1_3.out a_56601_79808# 0
C2202 programmable_telescopic_cascode_0.programmable_pfet$2_0.g programmable_telescopic_cascode_0.programmable_pfet$3_1.d 3.75772f
C2203 a_43570_79067# transmission_gate$2$1_7.ena 0
C2204 scan_chain_0.D_ff1_4.D_latch1$1_0.inv1$3_0.Y scan_chain_0.D_ff1_4.D_latch1$1_0.NAND2$2_2.B 0.44289f
C2205 transmission_gate$2$1_6.out VDD 25.3926f
C2206 a_29652_79808# a_29651_79067# 0
C2207 transmission_gate$2$1_7.out programmable_telescopic_cascode_0.programmable_pfet$3_0.g 0.23063f
C2208 a_48899_79067# IBIAS 0
C2209 transmission_gate$2$1_4.out programmable_telescopic_cascode_0.programmable_nfet$4_0.transmission_gate$24_0.out 0.15362f
C2210 programmable_telescopic_cascode_0.EN1 programmable_telescopic_cascode_0.programmable_pfet$2_0.transmission_gate$22_0.out 0.00778f
C2211 transmission_gate$2$1_3.out a_64301_79067# 0.02046f
C2212 programmable_common_source_0.EN1 scan_chain_0.D_ff1_0.Q_bar 0
C2213 programmable_telescopic_cascode_0.programmable_pfet$3_1.transmission_gate$23_1.out programmable_telescopic_cascode_0.programmable_pfet$3_1.transmission_gate$23_0.out 0.00238f
C2214 transmission_gate$2$1_2.out scan_chain_0.D_ff1_4.D_latch1$1_0.NAND2$2_0.A 0.0131f
C2215 programmable_5tOTA_0.programmable_nfet$7_0.transmission_gate$28_1.out INN_5T 0.27737f
C2216 transmission_gate$2$1_7.out programmable_folded_cascode_0.programmable_pfet_1.transmission_gate$16_1.out 0.37092f
C2217 VDD IBIAS 20.2733f
C2218 scan_chain_0.D_ff1_4.D_latch1$1_1.NAND2$2_0.A a_55117_79067# 0.02432f
C2219 programmable_telescopic_cascode_0.EN0 scan_chain_0.D_ff1_7.D_latch1$1_0.NAND2$2_2.B 0.1395f
C2220 programmable_common_source_0.EN0 programmable_common_source_0.EN1 10.0413f
C2221 programmable_folded_cascode_0.programmable_nfet_1.transmission_gate$18_0.out VDD 0.17797f
C2222 a_2694_79808# scan_chain_0.D_ff1_5.D_latch1$1_1.Q_bar 0.01093f
C2223 a_12766_79067# VDD 0.01327f
C2224 programmable_telescopic_cascode_0.programmable_nfet$4_0.transmission_gate$24_0.out INP_5T 0.0483f
C2225 programmable_folded_cascode_0.programmable_pfet$1_1.transmission_gate$17_0.out INP_FOLDED 0.04179f
C2226 programmable_folded_cascode_0.EN1 programmable_telescopic_cascode_0.programmable_nfet$4_1.transmission_gate$24_0.out 0.02192f
C2227 scan_chain_0.D_ff1_4.inv1$4_0.Y PROG_ENA 0.44521f
C2228 programmable_5tOTA_0.programmable_pfet$4_0.g programmable_5tOTA_0.programmable_nfet$8_0.transmission_gate$29_1.out 0.00118f
C2229 scan_chain_0.D_ff1_5.D_latch1$1_1.Q_bar transmission_gate$2$1_7.ena 0
C2230 scan_chain_0.D_ff1_1.D_latch1$1_1.NAND2$2_2.B transmission_gate$2$1_7.ena 0
C2231 programmable_5tOTA_0.programmable_nfet$7_0.transmission_gate$28_1.out OUT_5T 1.09622f
C2232 a_20467_79067# CLK 0
C2233 transmission_gate$2$1_6.out programmable_folded_cascode_0.programmable_nfet$3_0.g 0.12292f
C2234 a_6548_79067# PROG_ENA 0
C2235 programmable_telescopic_cascode_0.programmable_nfet$5_1.d INP_FOLDED 0.42644f
C2236 transmission_gate$2$1_2.out a_66673_79067# 0
C2237 programmable_telescopic_cascode_0.programmable_nfet$4_1.transmission_gate$24_1.out VDD 0.29771f
C2238 programmable_common_source_0.EN0 IBIAS 0.29698f
C2239 programmable_common_source_0.EN0 scan_chain_0.D_ff1_4.inv1$4_0.Y 0.0214f
C2240 transmission_gate$2$1_2.out programmable_5tOTA_0.programmable_nfet$7_0.transmission_gate$28_1.out 0.289f
C2241 programmable_folded_cascode_0.programmable_nfet$3_0.g IBIAS 0.01711f
C2242 transmission_gate$2$1_7.out programmable_folded_cascode_0.programmable_nfet$2_0.transmission_gate$20_1.out 0.00238f
C2243 scan_chain_0.D_ff1_1.D_latch1$1_1.Q_bar scan_chain_0.D_ff1_1.D_latch1$1_0.NAND2$2_0.A 0
C2244 scan_chain_0.D_ff1_8.D_latch1$1_1.NAND2$2_2.B a_25796_79067# 0.00415f
C2245 programmable_common_source_0.EN0 scan_chain_0.D_ff1_4.D_latch1$1_1.NAND2$2_0.A 0.44675f
C2246 scan_chain_0.D_ff1_6.D_latch1$1_1.Q_bar CLK 0.00483f
C2247 transmission_gate$2$1_4.out programmable_telescopic_cascode_0.programmable_nfet$5_0.transmission_gate$25_0.out 0.1502f
C2248 scan_chain_0.D_ff1_5.D_latch1$1_1.NAND2$2_2.B VDD 1.14111f
C2249 scan_chain_0.D_ff1_8.D_latch1$1_1.inv1$3_0.Y transmission_gate$2$1_7.ena 0
C2250 a_8911_79808# VDD 0.01041f
C2251 transmission_gate$2$1_7.out programmable_folded_cascode_0.programmable_pfet$1_0.transmission_gate$17_1.out 0.00418f
C2252 programmable_common_source_0.EN1 scan_chain_0.D_ff1_0.D_latch1$1_0.D 0
C2253 programmable_telescopic_cascode_0.programmable_pfet$3_0.g programmable_telescopic_cascode_0.programmable_pfet$2_1.transmission_gate$22_1.out 0.02689f
C2254 a_60456_79808# VDD 0.0078f
C2255 scan_chain_0.D_ff1_4.D_latch1$1_0.D CLK 0.00906f
C2256 programmable_folded_cascode_0.programmable_nfet$2_1.transmission_gate$20_0.out VDD 0.22976f
C2257 scan_chain_0.D_ff1_6.D_latch1$1_1.NAND2$2_2.B CLK 0.40703f
C2258 scan_chain_0.D_ff1_8.D_latch1$1_0.D scan_chain_0.D_ff1_8.inv1$4_0.Y 0.01122f
C2259 scan_chain_0.D_ff1_0.D_latch1$1_0.NAND2$2_0.A a_68156_79067# 0
C2260 scan_chain_0.D_ff1_0.inv1$4_0.Y scan_chain_0.D_ff1_0.D_latch1$1_0.NAND2$2_2.B 0.40109f
C2261 scan_chain_0.D_ff1_4.D_latch1$1_1.NAND2$2_2.B a_56600_79067# 0.00415f
C2262 programmable_folded_cascode_0.EN1 programmable_telescopic_cascode_0.programmable_nfet$5_1.transmission_gate$25_0.out 0.0274f
C2263 transmission_gate$2$1_2.out scan_chain_0.D_ff1_4.D_latch1$1_0.inv1$3_0.Y 0
C2264 scan_chain_0.D_ff1_8.D_latch1$1_1.NAND2$2_0.A scan_chain_0.D_ff1_8.D_latch1$1_0.D 0.41823f
C2265 programmable_telescopic_cascode_0.programmable_nfet$4_0.transmission_gate$24_0.out PROG_ENA 0
C2266 programmable_common_source_0.EN1 programmable_common_source_0.programmable_nfet$9_0.transmission_gate$31_1.out 0.2905f
C2267 scan_chain_0.D_ff1_0.D_latch1$1_1.NAND2$2_2.B VDD 1.10482f
C2268 transmission_gate$2$1_3.out a_62818_79067# 0.02046f
C2269 programmable_5tOTA_0.programmable_pfet$4_0.transmission_gate$27_1.out VDD 2.57076f
C2270 transmission_gate$2$1_4.out programmable_telescopic_cascode_0.programmable_pfet$3_0.transmission_gate$23_1.out 0.09481f
C2271 programmable_common_source_0.EN1 CLK 0.20611f
C2272 programmable_5tOTA_0.ena_bar<0> scan_chain_0.D_ff1_4.inv1$4_0.Y 0.02526f
C2273 programmable_5tOTA_0.ena_bar<0> scan_chain_0.D_ff1_4.D_latch1$1_1.NAND2$2_0.A 0
C2274 programmable_5tOTA_0.programmable_pfet$4_0.transmission_gate$27_0.out INP_5T 0
C2275 scan_chain_0.D_ff1_8.inv1$4_0.Y transmission_gate$2$1_4.out 0.0129f
C2276 scan_chain_0.D_ff1_7.D_latch1$1_1.NAND2$2_0.A scan_chain_0.D_ff1_7.D_latch1$1_1.Q_bar 0.02095f
C2277 programmable_folded_cascode_0.EN0 transmission_gate$2$1_6.out 1.34456f
C2278 transmission_gate$2$1_7.out programmable_folded_cascode_0.EN1 0.947f
C2279 transmission_gate$2$1_4.out programmable_telescopic_cascode_0.programmable_pfet$3_1.d 0.27669f
C2280 programmable_common_source_0.programmable_nfet$9_0.transmission_gate$31_1.out IBIAS 0.22626f
C2281 programmable_telescopic_cascode_0.programmable_pfet$3_0.transmission_gate$23_1.out INP_5T 0.03163f
C2282 programmable_5tOTA_0.ena_bar<0> programmable_5tOTA_0.programmable_nfet$8_0.transmission_gate$29_1.out 0
C2283 scan_chain_0.D_ff1_4.D_latch1$1_1.inv1$3_0.Y VDD 0.37659f
C2284 transmission_gate$2$1_3.out scan_chain_0.D_ff1_3.D_latch1$1_0.NAND2$2_2.B 0.00915f
C2285 programmable_folded_cascode_0.EN0 IBIAS 0.11065f
C2286 programmable_common_source_0.EN0 scan_chain_0.D_ff1_0.D_latch1$1_1.NAND2$2_2.B 0
C2287 programmable_telescopic_cascode_0.EN1 INP_TELESCOPIC 0.0089f
C2288 programmable_5tOTA_0.programmable_nfet$7_0.transmission_gate$28_0.out INP_5T 0
C2289 programmable_folded_cascode_0.programmable_pfet$1_0.transmission_gate$17_0.out INN_FOLDED 0.02518f
C2290 transmission_gate$2$1_6.out programmable_folded_cascode_0.programmable_nfet$2_0.g 0.72923f
C2291 a_5065_79067# PROG_ENA 0
C2292 programmable_telescopic_cascode_0.programmable_pfet$3_0.transmission_gate$23_0.out programmable_folded_cascode_0.OUT 0.05226f
C2293 programmable_folded_cascode_0.EN0 programmable_folded_cascode_0.programmable_nfet_1.transmission_gate$18_0.out 0.05063f
C2294 transmission_gate$2$1_6.out programmable_folded_cascode_0.programmable_pfet$1_0.g 0.224f
C2295 a_52755_79808# IBIAS 0
C2296 programmable_telescopic_cascode_0.programmable_pfet$3_1.d INP_5T 0.53226f
C2297 scan_chain_0.D_ff1_8.D_latch1$1_1.NAND2$2_2.B a_24313_79067# 0.16593f
C2298 programmable_folded_cascode_0.EN1 programmable_telescopic_cascode_0.programmable_nfet$6_0.transmission_gate$26_0.out 0.05481f
C2299 programmable_telescopic_cascode_0.programmable_nfet$5_0.transmission_gate$25_0.out PROG_ENA 0
C2300 scan_chain_0.D_ff1_0.D_latch1$1_1.inv1$3_0.Y CLK 0.02415f
C2301 a_10395_79808# CLK 0
C2302 scan_chain_0.D_ff1_1.D_latch1$1_1.Q_bar PROG_ENA 0.00175f
C2303 programmable_5tOTA_0.programmable_pfet$4_0.transmission_gate$27_0.out programmable_5tOTA_0.programmable_pfet$4_0.g 3.92021f
C2304 scan_chain_0.D_ff1_2.D_latch1$1_0.D scan_chain_0.D_ff1_2.D_latch1$1_1.Q_bar 1.69947f
C2305 programmable_folded_cascode_0.programmable_pfet$1_0.g IBIAS 1.06945f
C2306 scan_chain_0.D_ff1_5.D_latch1$1_0.D scan_chain_0.D_ff1_5.D_latch1$1_0.inv1$3_0.Y 0.29948f
C2307 a_18095_79067# transmission_gate$2$1_7.ena 0
C2308 programmable_5tOTA_0.ena_bar<1> scan_chain_0.D_ff1_4.D_latch1$1_0.D 0.08155f
C2309 programmable_folded_cascode_0.programmable_pfet$1_0.g programmable_folded_cascode_0.programmable_nfet_1.transmission_gate$18_0.out 0.19778f
C2310 a_55117_79808# CLK 0.00415f
C2311 programmable_common_source_0.EN0 scan_chain_0.D_ff1_4.D_latch1$1_1.inv1$3_0.Y 0
C2312 programmable_folded_cascode_0.EN0 programmable_telescopic_cascode_0.programmable_nfet$4_1.transmission_gate$24_1.out 0.05354f
C2313 transmission_gate$2$1_3.out scan_chain_0.D_ff1_2.D_latch1$1_0.inv1$3_0.Y 0.01532f
C2314 programmable_common_source_0.programmable_pfet$5_0.transmission_gate$30_1.out IN_CS 0.23756f
C2315 scan_chain_0.D_ff1_0.D_latch1$1_0.D scan_chain_0.D_ff1_0.D_latch1$1_1.NAND2$2_2.B 0.01594f
C2316 scan_chain_0.D_ff1_4.D_latch1$1_1.NAND2$2_2.B a_55117_79067# 0.16593f
C2317 programmable_telescopic_cascode_0.programmable_pfet$3_0.transmission_gate$23_1.out programmable_telescopic_cascode_0.programmable_pfet$3_0.d 3.39314f
C2318 scan_chain_0.D_ff1_0.D_latch1$1_0.NAND2$2_0.A a_66673_79067# 0.02432f
C2319 scan_chain_0.D_ff1_8.D_latch1$1_0.D a_28168_79808# 0.0043f
C2320 scan_chain_0.D_ff1_0.D_latch1$1_1.NAND2$2_0.A a_64301_79067# 0
C2321 programmable_telescopic_cascode_0.programmable_nfet$4_0.s INP_TELESCOPIC 5.71085f
C2322 transmission_gate$2$1_3.out scan_chain_0.D_ff1_3.D_latch1$1_1.Q_bar 0.00634f
C2323 transmission_gate$2$1_2.out a_52754_79067# 0
C2324 scan_chain_0.D_ff1_8.D_latch1$1_1.NAND2$2_0.A a_24313_79808# 0.23035f
C2325 programmable_folded_cascode_0.EN1 programmable_telescopic_cascode_0.programmable_pfet$2_1.transmission_gate$22_1.out 0.0137f
C2326 OUT_TELESCOPIC INN_FOLDED 0.42635f
C2327 scan_chain_0.D_ff1_7.D_latch1$1_0.inv1$3_0.Y a_20467_79067# 0.00457f
C2328 programmable_telescopic_cascode_0.programmable_pfet$2_1.transmission_gate$22_0.out OUT_TELESCOPIC 7.86675f
C2329 programmable_5tOTA_0.ena_bar<1> programmable_common_source_0.EN1 0.08175f
C2330 scan_chain_0.D_ff1_5.D_latch1$1_1.Q_bar scan_chain_0.D_ff1_5.D_latch1$1_0.NAND2$2_2.B 0.00216f
C2331 programmable_folded_cascode_0.programmable_pfet_1.transmission_gate$16_1.out programmable_folded_cascode_0.programmable_pfet_0.transmission_gate$16_0.out 0.09548f
C2332 transmission_gate$2$1_7.out scan_chain_0.D_ff1_6.D_latch1$1_1.NAND2$2_0.A 0.44675f
C2333 programmable_folded_cascode_0.EN1 scan_chain_0.D_ff1_7.D_latch1$1_1.inv1$3_0.Y 0
C2334 programmable_telescopic_cascode_0.programmable_pfet$3_0.transmission_gate$23_1.out PROG_ENA 0
C2335 scan_chain_0.D_ff1_7.D_latch1$1_0.NAND2$2_0.A VDD 0.80183f
C2336 programmable_folded_cascode_0.EN0 programmable_folded_cascode_0.programmable_nfet$2_1.transmission_gate$20_0.out 0.05076f
C2337 programmable_5tOTA_0.programmable_nfet$7_0.transmission_gate$28_0.out programmable_5tOTA_0.programmable_pfet$4_1.transmission_gate$27_0.out 0.0453f
C2338 transmission_gate$2$1_4.out programmable_telescopic_cascode_0.programmable_pfet$3_1.transmission_gate$23_1.out 0
C2339 programmable_telescopic_cascode_0.EN0 programmable_telescopic_cascode_0.programmable_nfet$4_0.transmission_gate$24_0.out 0.0018f
C2340 scan_chain_0.D_ff1_8.inv1$4_0.Y PROG_ENA 0.44521f
C2341 programmable_telescopic_cascode_0.programmable_pfet$3_1.d programmable_telescopic_cascode_0.programmable_pfet$3_0.d 0.93732f
C2342 a_28168_79808# transmission_gate$2$1_4.out 0
C2343 scan_chain_0.D_ff1_4.D_latch1$1_1.NAND2$2_2.B PROG_ENA 0.00233f
C2344 programmable_folded_cascode_0.programmable_pfet_0.g programmable_folded_cascode_0.programmable_pfet$1_1.transmission_gate$17_1.out 0.06527f
C2345 scan_chain_0.D_ff1_1.D_latch1$1_1.Q_bar scan_chain_0.D_ff1_1.D_latch1$1_0.inv1$3_0.Y 0.00416f
C2346 scan_chain_0.D_ff1_7.D_latch1$1_1.NAND2$2_0.A a_18096_79808# 0.00428f
C2347 scan_chain_0.D_ff1_2.D_latch1$1_0.NAND2$2_0.A scan_chain_0.D_ff1_2.inv1$4_0.Y 0.22611f
C2348 programmable_folded_cascode_0.programmable_nfet$2_0.g programmable_folded_cascode_0.programmable_nfet$2_1.transmission_gate$20_0.out 0.68193f
C2349 programmable_telescopic_cascode_0.programmable_nfet$4_0.transmission_gate$24_0.out INN_TELESCOPIC 0.14111f
C2350 scan_chain_0.D_ff1_3.D_latch1$1_0.inv1$3_0.Y a_51271_79067# 0.00457f
C2351 programmable_telescopic_cascode_0.programmable_pfet$3_1.transmission_gate$23_1.out INP_5T 0.03163f
C2352 a_48899_79067# VDD 0.01219f
C2353 programmable_folded_cascode_0.programmable_pfet$1_0.g programmable_folded_cascode_0.programmable_nfet$2_1.transmission_gate$20_0.out 0.22434f
C2354 programmable_common_source_0.EN0 scan_chain_0.D_ff1_4.D_latch1$1_1.NAND2$2_2.B 0.02525f
C2355 programmable_telescopic_cascode_0.programmable_pfet$3_0.g programmable_folded_cascode_0.OUT 0.32742f
C2356 programmable_5tOTA_0.ena_bar<1> scan_chain_0.D_ff1_0.D_latch1$1_1.inv1$3_0.Y 0
C2357 scan_chain_0.D_ff1_3.D_latch1$1_0.NAND2$2_0.A scan_chain_0.D_ff1_3.D_latch1$1_0.inv1$3_0.Y 0
C2358 a_56600_79067# CLK 0
C2359 transmission_gate$2$1_6.out programmable_telescopic_cascode_0.programmable_nfet$6_0.d 0.14339f
C2360 scan_chain_0.D_ff1_3.D_latch1$1_1.inv1$3_0.Y PROG_ENA 0.00134f
C2361 programmable_folded_cascode_0.programmable_pfet_1.transmission_gate$16_1.out programmable_folded_cascode_0.OUT 0.10379f
C2362 programmable_telescopic_cascode_0.programmable_nfet$4_0.g OUT_TELESCOPIC 4.08125f
C2363 scan_chain_0.D_ff1_8.D_latch1$1_0.D CLK 0.00906f
C2364 programmable_5tOTA_0.ena_bar<1> a_55117_79808# 0.01312f
C2365 a_33498_79808# PROG_ENA 0
C2366 scan_chain_0.D_ff1_2.D_latch1$1_0.D a_41199_79808# 0.16273f
C2367 programmable_5tOTA_0.ena_bar<0> programmable_5tOTA_0.programmable_pfet$4_0.transmission_gate$27_0.out 0.23105f
C2368 scan_chain_0.D_ff1_0.Q_bar VDD 0.80867f
C2369 a_16612_79067# transmission_gate$2$1_7.ena 0
C2370 scan_chain_0.D_ff1_5.D_latch1$1_1.NAND2$2_0.A scan_chain_0.D_ff1_5.D_latch1$1_1.NAND2$2_2.B 0.01576f
C2371 programmable_telescopic_cascode_0.programmable_nfet$6_0.d IBIAS 1.17604f
C2372 programmable_telescopic_cascode_0.EN0 programmable_telescopic_cascode_0.programmable_nfet$5_0.transmission_gate$25_0.out 0.00185f
C2373 scan_chain_0.D_ff1_1.D_latch1$1_0.NAND2$2_0.A CLK 0.00408f
C2374 programmable_common_source_0.EN0 programmable_common_source_0.programmable_pfet$5_0.transmission_gate$30_1.out 0.70347f
C2375 transmission_gate$2$1_3.out a_37352_79067# 0.03302f
C2376 programmable_common_source_0.EN0 VDD 3.82235f
C2377 scan_chain_0.D_ff1_3.D_latch1$1_1.Q_bar scan_chain_0.D_ff1_3.D_latch1$1_1.NAND2$2_2.B 0.13783f
C2378 scan_chain_0.D_ff1_0.D_latch1$1_1.NAND2$2_0.A a_62818_79067# 0.02432f
C2379 transmission_gate$2$1_2.out a_51271_79067# 0
C2380 scan_chain_0.D_ff1_1.D_latch1$1_1.NAND2$2_0.A scan_chain_0.D_ff1_1.D_latch1$1_1.inv1$3_0.Y 0
C2381 transmission_gate$2$1_4.out CLK 0.09253f
C2382 programmable_telescopic_cascode_0.programmable_nfet$4_1.transmission_gate$24_0.out INN_FOLDED 0.04788f
C2383 programmable_folded_cascode_0.programmable_nfet$3_0.g VDD 9.44386f
C2384 transmission_gate$2$1_3.out a_48900_79808# 0
C2385 programmable_5tOTA_0.ena_bar<0> programmable_5tOTA_0.programmable_nfet$7_0.transmission_gate$28_0.out 0.02473f
C2386 a_16612_79067# a_18095_79067# 0.00361f
C2387 programmable_5tOTA_0.ena_bar<0> scan_chain_0.D_ff1_4.D_latch1$1_1.NAND2$2_2.B 0.04436f
C2388 programmable_folded_cascode_0.programmable_nfet$2_0.transmission_gate$20_0.out programmable_folded_cascode_0.programmable_nfet$1_0.transmission_gate$19_1.out 0.06403f
C2389 transmission_gate$2$1_6.out programmable_telescopic_cascode_0.programmable_nfet$4_0.transmission_gate$24_1.out 0.00548f
C2390 scan_chain_0.D_ff1_2.D_latch1$1_0.NAND2$2_0.A scan_chain_0.D_ff1_2.D_latch1$1_0.NAND2$2_2.B 0.01576f
C2391 scan_chain_0.D_ff1_2.D_latch1$1_1.NAND2$2_0.A a_41198_79067# 0
C2392 scan_chain_0.D_ff1_2.D_latch1$1_0.D scan_chain_0.D_ff1_2.D_latch1$1_1.NAND2$2_2.B 0.01594f
C2393 scan_chain_0.D_ff1_5.D_latch1$1_0.NAND2$2_2.B transmission_gate$2$1_7.ena 0
C2394 transmission_gate$2$1_5.out programmable_telescopic_cascode_0.programmable_nfet$5_1.d 0.02703f
C2395 programmable_telescopic_cascode_0.programmable_pfet$3_1.transmission_gate$23_1.out PROG_ENA 0
C2396 programmable_common_source_0.EN0 scan_chain_0.D_ff1_0.Q_bar 0
C2397 transmission_gate$2$1_2.out scan_chain_0.D_ff1_3.D_latch1$1_0.NAND2$2_0.A 0.0131f
C2398 transmission_gate$2$1_5.out programmable_telescopic_cascode_0.programmable_pfet$2_0.transmission_gate$22_1.out 0.86561f
C2399 programmable_folded_cascode_0.EN1 programmable_folded_cascode_0.programmable_pfet_0.transmission_gate$16_0.out 0.02904f
C2400 programmable_telescopic_cascode_0.EN0 programmable_telescopic_cascode_0.programmable_pfet$3_0.transmission_gate$23_1.out 0.00875f
C2401 programmable_5tOTA_0.ena_bar<1> programmable_5tOTA_0.programmable_nfet$8_0.transmission_gate$29_0.out 0.00686f
C2402 programmable_folded_cascode_0.programmable_pfet$1_0.transmission_gate$17_1.out programmable_folded_cascode_0.OUT 4.26055f
C2403 programmable_telescopic_cascode_0.EN0 scan_chain_0.D_ff1_8.inv1$4_0.Y 0
C2404 scan_chain_0.D_ff1_2.D_latch1$1_0.NAND2$2_0.A a_43570_79808# 0.23035f
C2405 scan_chain_0.D_ff1_2.inv1$4_0.Y CLK 0.32366f
C2406 scan_chain_0.D_ff1_2.D_latch1$1_1.NAND2$2_0.A CLK 0.22611f
C2407 a_47416_79067# a_48899_79067# 0.00361f
C2408 programmable_telescopic_cascode_0.EN0 scan_chain_0.D_ff1_8.D_latch1$1_1.NAND2$2_0.A 0
C2409 programmable_5tOTA_0.ena_bar<0> programmable_common_source_0.programmable_pfet$5_0.transmission_gate$30_1.out 0.01023f
C2410 scan_chain_0.D_ff1_2.D_latch1$1_1.Q_bar a_43570_79067# 0
C2411 scan_chain_0.D_ff1_3.D_latch1$1_0.D scan_chain_0.D_ff1_3.inv1$4_0.Y 0.01122f
C2412 a_47416_79067# VDD 0.00984f
C2413 scan_chain_0.D_ff1_0.D_latch1$1_0.D VDD 1.57404f
C2414 programmable_telescopic_cascode_0.programmable_pfet$3_0.transmission_gate$23_1.out INN_TELESCOPIC 0.02549f
C2415 scan_chain_0.D_ff1_6.D_latch1$1_0.NAND2$2_0.A programmable_folded_cascode_0.EN1 0.02095f
C2416 scan_chain_0.D_ff1_3.inv1$4_0.Y PROG_ENA 0.44521f
C2417 scan_chain_0.D_ff1_3.D_latch1$1_1.NAND2$2_0.A scan_chain_0.D_ff1_3.D_latch1$1_0.D 0.41823f
C2418 programmable_telescopic_cascode_0.EN0 programmable_telescopic_cascode_0.programmable_pfet$3_1.d 0
C2419 programmable_5tOTA_0.ena_bar<0> scan_chain_0.D_ff1_3.D_latch1$1_1.inv1$3_0.Y 0.03323f
C2420 programmable_telescopic_cascode_0.programmable_nfet$5_1.transmission_gate$25_1.out programmable_telescopic_cascode_0.programmable_nfet$5_1.d 0.40373f
C2421 programmable_5tOTA_0.ena_bar<1> a_56600_79067# 0
C2422 scan_chain_0.D_ff1_1.D_latch1$1_0.D a_35869_79067# 0
C2423 programmable_telescopic_cascode_0.programmable_nfet$4_0.g programmable_telescopic_cascode_0.programmable_nfet$4_1.transmission_gate$24_0.out 0.31869f
C2424 scan_chain_0.D_ff1_6.D_latch1$1_0.D scan_chain_0.D_ff1_6.D_latch1$1_1.Q_bar 1.69947f
C2425 a_55117_79067# CLK 0.00479f
C2426 a_41198_79067# PROG_ENA 0
C2427 programmable_telescopic_cascode_0.programmable_pfet$3_1.d INN_TELESCOPIC 0.39218f
C2428 a_24313_79808# CLK 0.00415f
C2429 a_39715_79808# a_41199_79808# 0.00361f
C2430 programmable_folded_cascode_0.EN1 programmable_folded_cascode_0.programmable_nfet$1_0.transmission_gate$19_0.out 0
C2431 programmable_common_source_0.programmable_nfet$9_0.transmission_gate$31_1.out VDD 0.36927f
C2432 transmission_gate$2$1_6.out programmable_telescopic_cascode_0.programmable_nfet$5_0.transmission_gate$25_1.out 0.01127f
C2433 scan_chain_0.D_ff1_3.inv1$4_0.Y programmable_common_source_0.EN0 0.01266f
C2434 a_68157_79808# VDD 0.00582f
C2435 programmable_5tOTA_0.ena_bar<0> scan_chain_0.D_ff1_2.D_latch1$1_0.NAND2$2_0.A 0
C2436 scan_chain_0.D_ff1_8.inv1$4_0.Y a_29651_79067# 0
C2437 scan_chain_0.D_ff1_8.D_latch1$1_0.D scan_chain_0.D_ff1_8.D_latch1$1_0.NAND2$2_2.B 0.00115f
C2438 programmable_folded_cascode_0.EN0 VDD 24.4278f
C2439 programmable_common_source_0.EN0 scan_chain_0.D_ff1_0.D_latch1$1_0.D 0
C2440 scan_chain_0.D_ff1_6.D_latch1$1_0.NAND2$2_0.A scan_chain_0.D_ff1_6.D_latch1$1_0.NAND2$2_2.B 0.01576f
C2441 scan_chain_0.D_ff1_6.D_latch1$1_1.inv1$3_0.Y a_6548_79067# 0
C2442 programmable_folded_cascode_0.EN1 programmable_folded_cascode_0.OUT 0.10754f
C2443 scan_chain_0.D_ff1_1.D_latch1$1_0.NAND2$2_2.B VDD 1.0632f
C2444 scan_chain_0.D_ff1_6.D_latch1$1_1.NAND2$2_0.A a_10394_79067# 0
C2445 scan_chain_0.D_ff1_6.D_latch1$1_0.D scan_chain_0.D_ff1_6.D_latch1$1_1.NAND2$2_2.B 0.01594f
C2446 scan_chain_0.D_ff1_4.D_latch1$1_0.inv1$3_0.Y transmission_gate$2$1_7.ena 0
C2447 scan_chain_0.D_ff1_4.D_latch1$1_1.NAND2$2_0.A scan_chain_0.D_ff1_4.D_latch1$1_1.Q_bar 0.02095f
C2448 a_52755_79808# VDD 0.0019f
C2449 CLK PROG_ENA 28.9291f
C2450 scan_chain_0.D_ff1_3.D_latch1$1_0.D CLK 0.00906f
C2451 transmission_gate$2$1_7.out INN_FOLDED 0.46652f
C2452 transmission_gate$2$1_2.out programmable_common_source_0.programmable_pfet$5_0.transmission_gate$30_0.out 0.01968f
C2453 transmission_gate$2$1_7.out programmable_telescopic_cascode_0.programmable_pfet$2_1.transmission_gate$22_0.out 0.01121f
C2454 programmable_folded_cascode_0.programmable_nfet$2_0.g VDD 1.8301f
C2455 a_68157_79808# scan_chain_0.D_ff1_0.Q_bar 0.01093f
C2456 transmission_gate$2$1_4.out scan_chain_0.D_ff1_8.D_latch1$1_0.NAND2$2_2.B 0.01636f
C2457 programmable_telescopic_cascode_0.EN1 OUT_TELESCOPIC 0
C2458 scan_chain_0.D_ff1_2.D_latch1$1_0.NAND2$2_2.B CLK 0.00592f
C2459 programmable_folded_cascode_0.programmable_pfet$1_0.g VDD 8.91131f
C2460 transmission_gate$2$1_6.out programmable_telescopic_cascode_0.programmable_pfet$3_1.transmission_gate$23_0.out 0.01167f
C2461 programmable_common_source_0.EN0 programmable_common_source_0.programmable_nfet$9_0.transmission_gate$31_1.out 0.24446f
C2462 scan_chain_0.D_ff1_2.D_latch1$1_1.NAND2$2_0.A a_39715_79067# 0.02432f
C2463 programmable_5tOTA_0.ena_bar<1> INP_5T 0.10428f
C2464 scan_chain_0.D_ff1_6.D_latch1$1_1.Q_bar a_12766_79067# 0
C2465 scan_chain_0.D_ff1_2.D_latch1$1_1.inv1$3_0.Y a_37352_79067# 0
C2466 programmable_common_source_0.EN1 programmable_common_source_0.EN1 2.08549f
C2467 programmable_5tOTA_0.ena_bar<1> IN_CS 0.10624f
C2468 scan_chain_0.D_ff1_6.D_latch1$1_0.NAND2$2_0.A scan_chain_0.D_ff1_6.inv1$4_0.Y 0.22611f
C2469 programmable_common_source_0.EN0 CLK 0.36705f
C2470 programmable_folded_cascode_0.EN0 programmable_folded_cascode_0.programmable_nfet$3_0.g 0.30006f
C2471 programmable_5tOTA_0.ena_bar<0> scan_chain_0.D_ff1_3.inv1$4_0.Y 0.03744f
C2472 scan_chain_0.D_ff1_8.D_latch1$1_0.inv1$3_0.Y VDD 0.42979f
C2473 programmable_telescopic_cascode_0.EN0 programmable_telescopic_cascode_0.programmable_pfet$3_1.transmission_gate$23_1.out 0.00672f
C2474 scan_chain_0.D_ff1_2.inv1$4_0.Y programmable_5tOTA_0.ena_bar<1> 0
C2475 transmission_gate$2$1_5.out scan_chain_0.D_ff1_8.D_latch1$1_1.inv1$3_0.Y 0.31206f
C2476 transmission_gate$2$1_7.out programmable_folded_cascode_0.programmable_nfet_1.transmission_gate$18_1.out 0
C2477 programmable_5tOTA_0.ena_bar<0> scan_chain_0.D_ff1_3.D_latch1$1_1.NAND2$2_0.A 0
C2478 scan_chain_0.D_ff1_0.D_latch1$1_1.Q_bar CLK 0
C2479 a_52755_79808# programmable_common_source_0.EN0 0.01093f
C2480 transmission_gate$2$1_6.out programmable_folded_cascode_0.programmable_pfet_1.transmission_gate$16_0.out 0.04024f
C2481 programmable_5tOTA_0.ena_bar<0> a_41198_79067# 0.0119f
C2482 a_62818_79808# VDD 0.01744f
C2483 scan_chain_0.D_ff1_3.D_latch1$1_0.D a_51271_79808# 0.0043f
C2484 programmable_telescopic_cascode_0.programmable_pfet$3_1.transmission_gate$23_1.out INN_TELESCOPIC 0.02559f
C2485 scan_chain_0.D_ff1_3.D_latch1$1_1.NAND2$2_0.A a_47416_79808# 0.23035f
C2486 programmable_common_source_0.EN1 IBIAS 0.09558f
C2487 scan_chain_0.D_ff1_1.D_latch1$1_0.inv1$3_0.Y CLK 0.03916f
C2488 a_66673_79067# a_68156_79067# 0.00361f
C2489 programmable_folded_cascode_0.programmable_pfet_1.transmission_gate$16_0.out IBIAS 0
C2490 scan_chain_0.D_ff1_6.D_latch1$1_0.NAND2$2_0.A a_14250_79808# 0.00428f
C2491 programmable_folded_cascode_0.programmable_pfet$1_0.g programmable_folded_cascode_0.programmable_nfet$3_0.g 0.06869f
C2492 scan_chain_0.D_ff1_5.inv1$4_0.Y VDD 1.00438f
C2493 transmission_gate$2$1_7.out programmable_telescopic_cascode_0.programmable_nfet$4_0.g 0.10919f
C2494 scan_chain_0.D_ff1_5.D_latch1$1_1.NAND2$2_0.A VDD 0.7996f
C2495 programmable_5tOTA_0.ena_bar<1> a_55117_79067# 0
C2496 scan_chain_0.D_ff1_4.D_latch1$1_0.NAND2$2_2.B SCAN_OUT 0.07079f
C2497 programmable_5tOTA_0.ena_bar<1> programmable_5tOTA_0.programmable_pfet$4_0.g 0.88977f
C2498 a_39715_79067# PROG_ENA 0
C2499 programmable_telescopic_cascode_0.programmable_nfet$4_0.s OUT_TELESCOPIC 0.2634f
C2500 scan_chain_0.D_ff1_6.D_latch1$1_0.D a_10395_79808# 0.16273f
C2501 programmable_telescopic_cascode_0.programmable_pfet$2_1.transmission_gate$22_1.out programmable_telescopic_cascode_0.programmable_pfet$2_1.transmission_gate$22_0.out 0.00104f
C2502 programmable_common_source_0.EN1 scan_chain_0.D_ff1_0.D_latch1$1_1.inv1$3_0.Y 0
C2503 scan_chain_0.D_ff1_8.inv1$4_0.Y a_28168_79067# 0.00477f
C2504 scan_chain_0.D_ff1_7.D_latch1$1_0.D transmission_gate$2$1_7.ena 0
C2505 a_51271_79808# programmable_common_source_0.EN0 0
C2506 programmable_telescopic_cascode_0.programmable_pfet$2_1.transmission_gate$22_1.out INN_FOLDED 0.02583f
C2507 programmable_5tOTA_0.ena_bar<0> CLK 0.29358f
C2508 transmission_gate$2$1_6.out programmable_telescopic_cascode_0.programmable_pfet$2_0.g 0.02774f
C2509 a_6549_79808# VDD 0.00376f
C2510 programmable_5tOTA_0.ena_bar<1> scan_chain_0.D_ff1_3.D_latch1$1_0.D 0.08155f
C2511 programmable_5tOTA_0.ena_bar<1> programmable_5tOTA_0.programmable_pfet$4_1.transmission_gate$27_0.out 0.00686f
C2512 programmable_5tOTA_0.ena_bar<1> PROG_ENA 0.00839f
C2513 a_47416_79808# CLK 0.00415f
C2514 programmable_telescopic_cascode_0.programmable_pfet$2_0.g IBIAS 0.01356f
C2515 transmission_gate$2$1_7.out programmable_folded_cascode_0.programmable_nfet$2_1.transmission_gate$20_1.out 0
C2516 a_52754_79067# transmission_gate$2$1_7.ena 0
C2517 scan_chain_0.D_ff1_2.D_latch1$1_1.Q_bar transmission_gate$2$1_7.ena 0
C2518 scan_chain_0.D_ff1_6.D_latch1$1_1.NAND2$2_0.A a_8911_79067# 0.02432f
C2519 scan_chain_0.D_ff1_7.D_latch1$1_0.NAND2$2_0.A a_21950_79067# 0
C2520 scan_chain_0.D_ff1_7.inv1$4_0.Y scan_chain_0.D_ff1_7.D_latch1$1_0.NAND2$2_2.B 0.40095f
C2521 scan_chain_0.D_ff1_4.D_latch1$1_1.NAND2$2_0.A a_56601_79808# 0.00428f
C2522 programmable_5tOTA_0.ena_bar<1> scan_chain_0.D_ff1_2.D_latch1$1_0.NAND2$2_2.B 0.13967f
C2523 programmable_telescopic_cascode_0.EN1 programmable_telescopic_cascode_0.programmable_nfet$4_1.transmission_gate$24_0.out 0.04318f
C2524 scan_chain_0.D_ff1_7.D_latch1$1_0.D a_18095_79067# 0.02982f
C2525 transmission_gate$2$1_5.out transmission_gate$2$1_7.ena 0.07521f
C2526 programmable_telescopic_cascode_0.EN0 CLK 0.05986f
C2527 scan_chain_0.D_ff1_8.D_latch1$1_0.NAND2$2_2.B PROG_ENA 0.00233f
C2528 programmable_telescopic_cascode_0.programmable_nfet$6_0.d VDD 0.94565f
C2529 programmable_5tOTA_0.ena_bar<1> programmable_common_source_0.EN0 0.08159f
C2530 programmable_common_source_0.EN1 a_60456_79808# 0.16273f
C2531 a_21950_79067# VDD 0.01909f
C2532 scan_chain_0.D_ff1_6.D_latch1$1_0.NAND2$2_0.A a_12766_79808# 0.23035f
C2533 programmable_folded_cascode_0.EN0 programmable_folded_cascode_0.programmable_nfet$2_0.g 0.06635f
C2534 programmable_5tOTA_0.ena_bar<1> scan_chain_0.D_ff1_0.D_latch1$1_1.Q_bar 0.03071f
C2535 scan_chain_0.D_ff1_2.inv1$4_0.Y a_45054_79808# 0
C2536 programmable_telescopic_cascode_0.programmable_pfet$2_0.g programmable_telescopic_cascode_0.programmable_nfet$4_1.transmission_gate$24_1.out 0.01971f
C2537 transmission_gate$2$1_7.ena programmable_telescopic_cascode_0.programmable_nfet$5_1.transmission_gate$25_1.out 0
C2538 programmable_folded_cascode_0.EN0 programmable_folded_cascode_0.programmable_pfet$1_0.g 0.12246f
C2539 programmable_common_source_0.EN1 scan_chain_0.D_ff1_0.D_latch1$1_1.NAND2$2_2.B 0.00337f
C2540 a_64302_79808# CLK 0
C2541 a_62818_79808# scan_chain_0.D_ff1_0.D_latch1$1_0.D 0
C2542 scan_chain_0.D_ff1_4.D_latch1$1_0.NAND2$2_0.A scan_chain_0.D_ff1_4.D_latch1$1_0.inv1$3_0.Y 0
C2543 scan_chain_0.D_ff1_7.D_latch1$1_0.inv1$3_0.Y PROG_ENA 0.00134f
C2544 programmable_5tOTA_0.ena_bar<0> a_39715_79067# 0.01195f
C2545 a_29651_79067# CLK 0
C2546 a_5065_79808# VDD 0.01932f
C2547 programmable_folded_cascode_0.programmable_pfet$1_0.g programmable_folded_cascode_0.programmable_nfet$2_0.g 0.59433f
C2548 programmable_telescopic_cascode_0.programmable_nfet$4_0.transmission_gate$24_1.out VDD 0.52579f
C2549 transmission_gate$2$1_7.out programmable_folded_cascode_0.programmable_nfet$1_0.transmission_gate$19_1.out 0.0026f
C2550 a_8911_79808# a_10395_79808# 0.00361f
C2551 transmission_gate$2$1_2.out SCAN_OUT 0.14008f
C2552 scan_chain_0.D_ff1_1.D_latch1$1_1.inv1$3_0.Y scan_chain_0.D_ff1_1.D_latch1$1_1.NAND2$2_2.B 0.44307f
C2553 programmable_telescopic_cascode_0.programmable_nfet$5_0.transmission_gate$25_0.out INP_TELESCOPIC 0.21184f
C2554 programmable_telescopic_cascode_0.programmable_pfet$3_0.g programmable_telescopic_cascode_0.programmable_nfet$5_1.d 0.51336f
C2555 programmable_telescopic_cascode_0.EN1 programmable_telescopic_cascode_0.programmable_nfet$5_1.transmission_gate$25_0.out 0.04335f
C2556 programmable_5tOTA_0.programmable_nfet$8_0.transmission_gate$29_0.out IBIAS 0.4608f
C2557 programmable_5tOTA_0.ena_bar<0> programmable_5tOTA_0.ena_bar<1> 0.87292f
C2558 a_37353_79808# CLK 0
C2559 programmable_telescopic_cascode_0.programmable_pfet$3_0.g programmable_telescopic_cascode_0.programmable_pfet$2_0.transmission_gate$22_1.out 3.2811f
C2560 a_28168_79808# a_28168_79067# 0
C2561 scan_chain_0.D_ff1_4.D_latch1$1_1.Q_bar scan_chain_0.D_ff1_4.D_latch1$1_1.NAND2$2_2.B 0.13783f
C2562 scan_chain_0.D_ff1_5.inv1$4_0.Y programmable_folded_cascode_0.EN0 0.00231f
C2563 programmable_folded_cascode_0.programmable_pfet_0.transmission_gate$16_0.out INN_FOLDED 0.05037f
C2564 a_45054_79808# PROG_ENA 0
C2565 programmable_5tOTA_0.ena_bar<1> a_47416_79808# 0.01312f
C2566 a_51271_79067# transmission_gate$2$1_7.ena 0
C2567 scan_chain_0.D_ff1_0.D_latch1$1_1.inv1$3_0.Y scan_chain_0.D_ff1_0.D_latch1$1_1.NAND2$2_2.B 0.44307f
C2568 transmission_gate$2$1_7.out programmable_telescopic_cascode_0.EN1 0.00104f
C2569 transmission_gate$2$1_6.out programmable_folded_cascode_0.programmable_pfet_0.transmission_gate$16_1.out 2.43217f
C2570 scan_chain_0.D_ff1_7.D_latch1$1_0.NAND2$2_0.A a_20467_79067# 0.02432f
C2571 transmission_gate$2$1_7.ena programmable_telescopic_cascode_0.programmable_nfet$6_0.transmission_gate$26_1.out 0
C2572 a_21951_79808# CLK 0
C2573 a_6549_79808# programmable_folded_cascode_0.EN0 0.01093f
C2574 programmable_folded_cascode_0.programmable_pfet_0.transmission_gate$16_1.out IBIAS 0.00319f
C2575 programmable_telescopic_cascode_0.EN0 scan_chain_0.D_ff1_8.D_latch1$1_0.NAND2$2_2.B 0
C2576 transmission_gate$2$1_6.out transmission_gate$2$1_4.out 0.00288f
C2577 programmable_telescopic_cascode_0.programmable_nfet$5_0.transmission_gate$25_1.out VDD 0.13625f
C2578 programmable_telescopic_cascode_0.programmable_nfet$5_1.transmission_gate$25_0.out programmable_telescopic_cascode_0.programmable_nfet$4_0.s 0.04299f
C2579 a_20467_79067# VDD 0.01501f
C2580 a_43570_79808# a_45054_79808# 0.00361f
C2581 scan_chain_0.D_ff1_2.D_latch1$1_1.NAND2$2_2.B transmission_gate$2$1_7.ena 0
C2582 programmable_5tOTA_0.ena_bar<1> a_64302_79808# 0.01415f
C2583 programmable_telescopic_cascode_0.EN1 programmable_telescopic_cascode_0.programmable_nfet$6_0.transmission_gate$26_0.out 0.05248f
C2584 programmable_common_source_0.EN1 IN_CS 0.15215f
C2585 transmission_gate$2$1_4.out IBIAS 0.21035f
C2586 scan_chain_0.D_ff1_6.D_latch1$1_1.Q_bar VDD 0.90531f
C2587 programmable_folded_cascode_0.EN0 programmable_telescopic_cascode_0.programmable_nfet$6_0.d 0.07781f
C2588 transmission_gate$2$1_6.out programmable_folded_cascode_0.programmable_nfet$1_0.g 0.73453f
C2589 a_14249_79067# PROG_ENA 0
C2590 transmission_gate$2$1_7.ena programmable_telescopic_cascode_0.programmable_pfet$3_0.transmission_gate$23_0.out 0
C2591 transmission_gate$2$1_6.out INP_5T 0.62977f
C2592 a_28168_79067# CLK 0
C2593 programmable_folded_cascode_0.OUT INN_FOLDED 0.17045f
C2594 programmable_telescopic_cascode_0.programmable_pfet$2_1.transmission_gate$22_0.out programmable_folded_cascode_0.OUT 0.05105f
C2595 scan_chain_0.D_ff1_4.D_latch1$1_0.D VDD 1.54271f
C2596 transmission_gate$2$1_7.out programmable_telescopic_cascode_0.programmable_nfet$4_0.s 0.0925f
C2597 IBIAS INP_5T 0.90822f
C2598 scan_chain_0.D_ff1_8.D_latch1$1_0.NAND2$2_2.B a_29651_79067# 0.00415f
C2599 scan_chain_0.D_ff1_5.D_latch1$1_0.D scan_chain_0.D_ff1_5.D_latch1$1_0.NAND2$2_0.A 0.44673f
C2600 programmable_telescopic_cascode_0.programmable_pfet$3_1.transmission_gate$23_0.out VDD 10.4736f
C2601 IBIAS IN_CS 0.11842f
C2602 scan_chain_0.D_ff1_6.D_latch1$1_1.NAND2$2_2.B VDD 1.11905f
C2603 programmable_folded_cascode_0.programmable_nfet$1_0.g programmable_folded_cascode_0.programmable_nfet_1.transmission_gate$18_0.out 0.02825f
C2604 scan_chain_0.D_ff1_2.inv1$4_0.Y IBIAS 0.00195f
C2605 programmable_5tOTA_0.ena_bar<0> a_45054_79808# 0
C2606 scan_chain_0.D_ff1_1.D_latch1$1_1.inv1$3_0.Y transmission_gate$2$1_7.ena 0
C2607 programmable_folded_cascode_0.OUT programmable_folded_cascode_0.programmable_nfet_1.transmission_gate$18_1.out 0.09138f
C2608 programmable_telescopic_cascode_0.EN1 programmable_telescopic_cascode_0.programmable_pfet$2_1.transmission_gate$22_1.out 0.00662f
C2609 transmission_gate$2$1_4.out programmable_telescopic_cascode_0.programmable_nfet$4_1.transmission_gate$24_1.out 0.09806f
C2610 scan_chain_0.D_ff1_5.inv1$4_0.Y a_6549_79808# 0
C2611 programmable_folded_cascode_0.EN0 programmable_telescopic_cascode_0.programmable_nfet$4_0.transmission_gate$24_1.out 0.05031f
C2612 programmable_folded_cascode_0.programmable_pfet_1.transmission_gate$16_0.out VDD 12.0356f
C2613 programmable_common_source_0.EN1 VDD 14.6362f
C2614 scan_chain_0.D_ff1_5.D_latch1$1_0.NAND2$2_0.A transmission_gate$2$1_7.out 0.41823f
C2615 scan_chain_0.D_ff1_4.D_latch1$1_0.NAND2$2_2.B a_60455_79067# 0.00415f
C2616 scan_chain_0.D_ff1_6.D_latch1$1_0.D PROG_ENA 0.00152f
C2617 scan_chain_0.D_ff1_7.D_latch1$1_1.NAND2$2_2.B CLK 0.40703f
C2618 scan_chain_0.D_ff1_0.D_latch1$1_0.NAND2$2_0.A SCAN_OUT 0.41822f
C2619 programmable_folded_cascode_0.EN1 programmable_telescopic_cascode_0.programmable_nfet$5_1.d 0.1536f
C2620 transmission_gate$2$1_2.out scan_chain_0.D_ff1_0.D_latch1$1_0.inv1$3_0.Y 0
C2621 programmable_common_source_0.EN0 scan_chain_0.D_ff1_4.D_latch1$1_0.D 0
C2622 programmable_common_source_0.EN1 PROG_ENA 0.05149f
C2623 a_16612_79808# a_16612_79067# 0
C2624 programmable_folded_cascode_0.EN1 programmable_telescopic_cascode_0.programmable_pfet$2_0.transmission_gate$22_1.out 0.0137f
C2625 transmission_gate$2$1_6.out programmable_telescopic_cascode_0.programmable_pfet$3_0.d 0.06756f
C2626 programmable_telescopic_cascode_0.programmable_nfet$4_1.transmission_gate$24_1.out INP_5T 0.02415f
C2627 programmable_common_source_0.EN1 scan_chain_0.D_ff1_0.Q_bar 0.00156f
C2628 programmable_5tOTA_0.programmable_pfet$4_0.g IBIAS 0.30531f
C2629 programmable_telescopic_cascode_0.programmable_nfet$4_0.g programmable_folded_cascode_0.OUT 0.14001f
C2630 transmission_gate$2$1_6.out PROG_ENA 0.18518f
C2631 programmable_common_source_0.EN0 programmable_common_source_0.EN1 2.00108f
C2632 scan_chain_0.D_ff1_6.D_latch1$1_1.inv1$3_0.Y CLK 0.02415f
C2633 scan_chain_0.D_ff1_1.D_latch1$1_0.D scan_chain_0.D_ff1_1.inv1$4_0.Y 0.01122f
C2634 programmable_common_source_0.EN0 programmable_common_source_0.EN1 0.1237f
C2635 programmable_telescopic_cascode_0.programmable_pfet$2_0.g VDD 20.4365f
C2636 scan_chain_0.D_ff1_1.D_latch1$1_1.NAND2$2_0.A scan_chain_0.D_ff1_1.D_latch1$1_0.D 0.41823f
C2637 programmable_folded_cascode_0.programmable_nfet$1_0.g programmable_folded_cascode_0.programmable_nfet$2_1.transmission_gate$20_0.out 0
C2638 IBIAS PROG_ENA 0.07171f
C2639 scan_chain_0.D_ff1_3.D_latch1$1_0.D IBIAS 0.01854f
C2640 programmable_folded_cascode_0.EN1 programmable_folded_cascode_0.programmable_nfet$1_1.transmission_gate$19_0.out 0
C2641 scan_chain_0.D_ff1_0.D_latch1$1_1.inv1$3_0.Y VDD 0.38063f
C2642 transmission_gate$2$1_7.out programmable_folded_cascode_0.programmable_nfet_0.transmission_gate$18_0.out 0.45642f
C2643 a_10395_79808# VDD 0.00501f
C2644 programmable_common_source_0.EN1 scan_chain_0.D_ff1_0.D_latch1$1_1.Q_bar 0
C2645 transmission_gate$2$1_3.out scan_chain_0.D_ff1_4.D_latch1$1_0.NAND2$2_2.B 0.00915f
C2646 scan_chain_0.D_ff1_4.D_latch1$1_1.Q_bar CLK 0.00483f
C2647 a_12766_79067# PROG_ENA 0
C2648 transmission_gate$2$1_7.ena programmable_telescopic_cascode_0.programmable_pfet$3_0.g 0
C2649 programmable_folded_cascode_0.EN0 programmable_telescopic_cascode_0.programmable_nfet$5_0.transmission_gate$25_1.out 0.0469f
C2650 a_5065_79808# scan_chain_0.D_ff1_5.inv1$4_0.Y 0.00415f
C2651 programmable_5tOTA_0.programmable_pfet$4_0.transmission_gate$27_1.out INP_5T 0
C2652 a_55117_79808# VDD 0.00189f
C2653 scan_chain_0.D_ff1_8.D_latch1$1_0.NAND2$2_2.B a_28168_79067# 0.12535f
C2654 programmable_telescopic_cascode_0.programmable_nfet$4_1.transmission_gate$24_1.out programmable_telescopic_cascode_0.programmable_pfet$3_0.d 0.00166f
C2655 scan_chain_0.D_ff1_1.inv1$4_0.Y transmission_gate$2$1_3.out 0.01266f
C2656 programmable_common_source_0.EN0 IBIAS 0.38889f
C2657 scan_chain_0.D_ff1_8.D_latch1$1_1.NAND2$2_0.A scan_chain_0.D_ff1_8.D_latch1$1_1.Q_bar 0.02095f
C2658 programmable_telescopic_cascode_0.programmable_nfet$4_0.transmission_gate$24_0.out OUT_TELESCOPIC 0.04951f
C2659 a_25796_79067# transmission_gate$2$1_7.ena 0
C2660 programmable_telescopic_cascode_0.programmable_nfet$4_1.transmission_gate$24_1.out PROG_ENA 0
C2661 programmable_common_source_0.EN1 scan_chain_0.D_ff1_0.D_latch1$1_0.D 0
C2662 transmission_gate$2$1_3.out scan_chain_0.D_ff1_3.D_latch1$1_0.inv1$3_0.Y 0.01532f
C2663 programmable_5tOTA_0.ena_bar<0> programmable_common_source_0.EN1 0.0387f
C2664 a_5065_79808# a_6549_79808# 0.00361f
C2665 programmable_common_source_0.EN0 scan_chain_0.D_ff1_0.D_latch1$1_1.inv1$3_0.Y 0
C2666 scan_chain_0.D_ff1_5.D_latch1$1_1.NAND2$2_2.B PROG_ENA 0.01015f
C2667 programmable_folded_cascode_0.EN0 programmable_telescopic_cascode_0.programmable_pfet$3_1.transmission_gate$23_0.out 0.07234f
C2668 scan_chain_0.D_ff1_4.D_latch1$1_0.NAND2$2_2.B a_58972_79067# 0.12535f
C2669 a_60456_79808# PROG_ENA 0
C2670 programmable_folded_cascode_0.EN0 scan_chain_0.D_ff1_6.D_latch1$1_1.NAND2$2_2.B 0.00218f
C2671 transmission_gate$2$1_3.out INN_5T 0.20919f
C2672 transmission_gate$2$1_2.out a_60455_79067# 0
C2673 scan_chain_0.D_ff1_8.D_latch1$1_1.inv1$3_0.Y a_24313_79067# 0.00457f
C2674 programmable_5tOTA_0.programmable_pfet$4_0.g programmable_5tOTA_0.programmable_pfet$4_0.transmission_gate$27_1.out 1.52141f
C2675 programmable_folded_cascode_0.programmable_nfet$1_0.transmission_gate$19_0.out programmable_folded_cascode_0.programmable_nfet$1_0.transmission_gate$19_1.out 0.00448f
C2676 programmable_5tOTA_0.programmable_nfet$8_0.transmission_gate$29_0.out VDD 0.11431f
C2677 programmable_common_source_0.EN1 programmable_common_source_0.programmable_nfet$9_0.transmission_gate$31_1.out 0.16062f
C2678 programmable_common_source_0.EN1 a_68157_79808# 0
C2679 programmable_folded_cascode_0.EN0 programmable_folded_cascode_0.programmable_pfet_1.transmission_gate$16_0.out 0.06693f
C2680 programmable_folded_cascode_0.OUT programmable_folded_cascode_0.programmable_nfet$1_0.transmission_gate$19_1.out 0.33982f
C2681 transmission_gate$2$1_3.out scan_chain_0.D_ff1_2.D_latch1$1_0.D 0.05004f
C2682 programmable_5tOTA_0.ena_bar<0> IBIAS 0.49814f
C2683 transmission_gate$2$1_3.out OUT_5T 0.03672f
C2684 programmable_common_source_0.EN0 a_60456_79808# 0
C2685 scan_chain_0.D_ff1_1.inv1$4_0.Y programmable_telescopic_cascode_0.programmable_nfet$4_0.g 0
C2686 scan_chain_0.D_ff1_0.D_latch1$1_0.NAND2$2_0.A scan_chain_0.D_ff1_0.D_latch1$1_0.inv1$3_0.Y 0
C2687 a_2693_79067# CLK 0
C2688 scan_chain_0.D_ff1_1.D_latch1$1_0.D a_35869_79808# 0.0043f
C2689 scan_chain_0.D_ff1_4.D_latch1$1_1.inv1$3_0.Y a_55117_79067# 0.00457f
C2690 scan_chain_0.D_ff1_1.D_latch1$1_1.NAND2$2_0.A a_32014_79808# 0.23035f
C2691 transmission_gate$2$1_6.out programmable_telescopic_cascode_0.EN0 0
C2692 a_56600_79067# VDD 0.01219f
C2693 programmable_telescopic_cascode_0.programmable_pfet$3_0.g INP_FOLDED 0.31057f
C2694 scan_chain_0.D_ff1_8.D_latch1$1_0.D VDD 1.59389f
C2695 transmission_gate$2$1_3.out transmission_gate$2$1_2.out 13.0871f
C2696 transmission_gate$2$1_3.out programmable_5tOTA_0.programmable_nfet$7_1.transmission_gate$28_1.out 0
C2697 programmable_telescopic_cascode_0.EN0 IBIAS 0.0078f
C2698 scan_chain_0.D_ff1_5.D_latch1$1_1.Q_bar scan_chain_0.D_ff1_5.D_latch1$1_0.inv1$3_0.Y 0.00416f
C2699 programmable_folded_cascode_0.programmable_pfet_0.transmission_gate$16_1.out VDD 21.6776f
C2700 programmable_5tOTA_0.ena_bar<1> scan_chain_0.D_ff1_4.D_latch1$1_1.Q_bar 0.03071f
C2701 a_56601_79808# CLK 0
C2702 programmable_common_source_0.EN0 scan_chain_0.D_ff1_0.D_latch1$1_1.NAND2$2_2.B 0.00199f
C2703 transmission_gate$2$1_7.ena SCAN_OUT 0.00132f
C2704 transmission_gate$2$1_7.out programmable_folded_cascode_0.programmable_pfet_0.g 0.67084f
C2705 programmable_folded_cascode_0.programmable_pfet_1.transmission_gate$16_1.out INP_FOLDED 0.15555f
C2706 transmission_gate$2$1_6.out INN_TELESCOPIC 0.01067f
C2707 programmable_5tOTA_0.ena_bar<1> scan_chain_0.D_ff1_0.D_latch1$1_0.NAND2$2_2.B 0
C2708 scan_chain_0.D_ff1_1.D_latch1$1_0.NAND2$2_0.A VDD 0.7749f
C2709 programmable_folded_cascode_0.EN0 programmable_telescopic_cascode_0.programmable_pfet$2_0.g 0.04825f
C2710 a_35869_79808# transmission_gate$2$1_3.out 0
C2711 a_64301_79067# CLK 0
C2712 scan_chain_0.D_ff1_0.D_latch1$1_1.Q_bar scan_chain_0.D_ff1_0.D_latch1$1_1.NAND2$2_2.B 0.13783f
C2713 scan_chain_0.D_ff1_4.D_latch1$1_1.inv1$3_0.Y PROG_ENA 0.00134f
C2714 INP_FOLDED VSS 33.39599f
C2715 OUT_5T VSS 34.43106f
C2716 INN_FOLDED VSS 25.95719f
C2717 INN_5T VSS 32.24116f
C2718 INP_5T VSS 52.31865f
C2719 OUT_TELESCOPIC VSS 90.68315f
C2720 INP_TELESCOPIC VSS 68.9337f
C2721 INN_TELESCOPIC VSS 27.2463f
C2722 PROG_ENA VSS 16.79801f
C2723 OUT_CS VSS 29.95878f
C2724 IN_CS VSS 16.86704f
C2725 SCAN_OUT VSS 7.60066f
C2726 CLK VSS 33.71075f
C2727 SCAN_IN VSS 1.93428f
C2728 IBIAS VSS 0.10469p
C2729 VDD VSS 5.53693p
C2730 programmable_folded_cascode_0.programmable_nfet$2_1.transmission_gate$20_1.out VSS 2.61213f
C2731 programmable_folded_cascode_0.programmable_nfet$2_1.transmission_gate$20_0.out VSS 1.69003f
C2732 programmable_folded_cascode_0.programmable_nfet$1_1.transmission_gate$19_1.out VSS 1.14102f
C2733 programmable_folded_cascode_0.programmable_nfet$1_1.transmission_gate$19_0.out VSS 0.91497f
C2734 programmable_folded_cascode_0.programmable_nfet_1.transmission_gate$18_1.out VSS 1.63431f
C2735 programmable_folded_cascode_0.programmable_nfet_1.transmission_gate$18_0.out VSS 1.17372f
C2736 programmable_folded_cascode_0.programmable_pfet$1_1.transmission_gate$17_1.out VSS 1.91536f
C2737 programmable_folded_cascode_0.programmable_pfet$1_1.transmission_gate$17_0.out VSS 1.33406f
C2738 programmable_folded_cascode_0.programmable_nfet$1_0.transmission_gate$19_1.out VSS 1.13883f
C2739 programmable_folded_cascode_0.programmable_nfet$1_0.g VSS 8.2727f
C2740 programmable_folded_cascode_0.programmable_nfet$1_0.transmission_gate$19_0.out VSS 0.93587f
C2741 programmable_folded_cascode_0.programmable_nfet$2_0.transmission_gate$20_1.out VSS 2.61574f
C2742 programmable_folded_cascode_0.programmable_nfet$2_0.g VSS 20.00731f
C2743 programmable_folded_cascode_0.programmable_nfet$2_0.transmission_gate$20_0.out VSS 1.73648f
C2744 programmable_folded_cascode_0.programmable_nfet$3_0.transmission_gate$21_1.out VSS 4.66949f
C2745 programmable_folded_cascode_0.programmable_nfet$3_0.g VSS 18.42864f
C2746 programmable_folded_cascode_0.programmable_nfet$3_0.transmission_gate$21_0.out VSS 2.60439f
C2747 programmable_folded_cascode_0.programmable_nfet_0.transmission_gate$18_1.out VSS 1.61103f
C2748 programmable_folded_cascode_0.programmable_nfet_0.transmission_gate$18_0.out VSS 1.18864f
C2749 programmable_5tOTA_0.programmable_pfet$4_1.transmission_gate$27_1.out VSS 1.41341f
C2750 programmable_5tOTA_0.programmable_pfet$4_1.transmission_gate$27_0.out VSS 2.26271f
C2751 programmable_5tOTA_0.programmable_nfet$7_0.transmission_gate$28_0.out VSS 1.57848f
C2752 programmable_5tOTA_0.programmable_nfet$7_0.transmission_gate$28_1.out VSS 2.07018f
C2753 programmable_common_source_0.programmable_nfet$9_0.transmission_gate$31_0.out VSS 2.07868f
C2754 programmable_common_source_0.programmable_nfet$9_0.transmission_gate$31_1.out VSS 3.1253f
C2755 programmable_5tOTA_0.programmable_nfet$7_1.transmission_gate$28_0.out VSS 1.44801f
C2756 programmable_5tOTA_0.programmable_nfet$7_1.transmission_gate$28_1.out VSS 1.92379f
C2757 programmable_5tOTA_0.programmable_nfet$8_0.transmission_gate$29_0.out VSS 3.24323f
C2758 programmable_5tOTA_0.programmable_nfet$8_0.transmission_gate$29_1.out VSS 6.18702f
C2759 programmable_folded_cascode_0.OUT VSS 30.89972f
C2760 programmable_folded_cascode_0.programmable_pfet$1_0.transmission_gate$17_1.out VSS 1.92928f
C2761 programmable_folded_cascode_0.programmable_pfet$1_0.g VSS 19.70216f
C2762 programmable_folded_cascode_0.programmable_pfet$1_0.transmission_gate$17_0.out VSS 1.33755f
C2763 programmable_5tOTA_0.programmable_pfet$4_0.transmission_gate$27_1.out VSS 1.23154f
C2764 programmable_5tOTA_0.programmable_pfet$4_0.g VSS 14.67751f
C2765 programmable_5tOTA_0.programmable_pfet$4_0.transmission_gate$27_0.out VSS 2.01098f
C2766 programmable_folded_cascode_0.programmable_pfet_0.transmission_gate$16_1.out VSS 4.01857f
C2767 programmable_folded_cascode_0.programmable_pfet_0.transmission_gate$16_0.out VSS 2.23702f
C2768 programmable_folded_cascode_0.programmable_pfet_1.transmission_gate$16_1.out VSS 3.8224f
C2769 programmable_folded_cascode_0.programmable_pfet_0.g VSS 14.67361f
C2770 programmable_telescopic_cascode_0.programmable_nfet$6_0.d VSS 55.48182f
C2771 programmable_telescopic_cascode_0.programmable_nfet$4_0.s VSS 0.18391p
C2772 programmable_telescopic_cascode_0.programmable_nfet$5_1.d VSS 0.1802p
C2773 programmable_telescopic_cascode_0.programmable_pfet$3_0.d VSS 13.76798f
C2774 programmable_telescopic_cascode_0.programmable_pfet$3_1.d VSS 16.78874f
C2775 programmable_folded_cascode_0.programmable_pfet_1.transmission_gate$16_0.out VSS 2.26679f
C2776 programmable_telescopic_cascode_0.programmable_nfet$6_0.transmission_gate$26_0.out VSS 4.67161f
C2777 programmable_telescopic_cascode_0.programmable_nfet$6_0.transmission_gate$26_1.out VSS 2.60805f
C2778 programmable_telescopic_cascode_0.programmable_nfet$5_0.transmission_gate$25_0.out VSS 1.13988f
C2779 programmable_telescopic_cascode_0.programmable_nfet$5_0.transmission_gate$25_1.out VSS 1.13259f
C2780 programmable_telescopic_cascode_0.programmable_nfet$5_1.transmission_gate$25_0.out VSS 1.1392f
C2781 programmable_telescopic_cascode_0.programmable_nfet$5_1.transmission_gate$25_1.out VSS 0.84616f
C2782 programmable_telescopic_cascode_0.programmable_nfet$4_0.transmission_gate$24_0.out VSS 4.24629f
C2783 programmable_telescopic_cascode_0.programmable_nfet$4_0.transmission_gate$24_1.out VSS 2.19753f
C2784 programmable_telescopic_cascode_0.programmable_nfet$4_1.transmission_gate$24_0.out VSS 3.31551f
C2785 programmable_telescopic_cascode_0.programmable_nfet$4_0.g VSS 29.19634f
C2786 programmable_telescopic_cascode_0.programmable_nfet$4_1.transmission_gate$24_1.out VSS 2.46069f
C2787 programmable_telescopic_cascode_0.programmable_pfet$2_0.transmission_gate$22_0.out VSS 1.8625f
C2788 programmable_telescopic_cascode_0.programmable_pfet$2_0.transmission_gate$22_1.out VSS 1.96894f
C2789 programmable_telescopic_cascode_0.programmable_pfet$2_1.transmission_gate$22_0.out VSS 2.08386f
C2790 programmable_telescopic_cascode_0.programmable_pfet$2_0.g VSS 16.83557f
C2791 programmable_telescopic_cascode_0.programmable_pfet$2_1.transmission_gate$22_1.out VSS 1.60492f
C2792 programmable_telescopic_cascode_0.programmable_pfet$3_0.transmission_gate$23_0.out VSS 2.34567f
C2793 programmable_telescopic_cascode_0.programmable_pfet$3_0.transmission_gate$23_1.out VSS 1.61431f
C2794 programmable_telescopic_cascode_0.programmable_pfet$3_1.transmission_gate$23_0.out VSS 2.33597f
C2795 programmable_telescopic_cascode_0.programmable_pfet$3_0.g VSS 64.44261f
C2796 programmable_telescopic_cascode_0.programmable_pfet$3_1.transmission_gate$23_1.out VSS 1.60307f
C2797 transmission_gate$2$1_7.ena VSS 29.4756f
C2798 a_68156_79067# VSS 0.3951f
C2799 a_66673_79067# VSS 0.53108f
C2800 scan_chain_0.D_ff1_0.D_latch1$1_0.NAND2$2_2.B VSS 0.85969f
C2801 a_64301_79067# VSS 0.3975f
C2802 a_62818_79067# VSS 0.38886f
C2803 scan_chain_0.D_ff1_0.D_latch1$1_1.NAND2$2_2.B VSS 0.52206f
C2804 scan_chain_0.D_ff1_0.D_latch1$1_0.inv1$3_0.Y VSS 0.59894f
C2805 a_60455_79067# VSS 0.39189f
C2806 a_58972_79067# VSS 0.52793f
C2807 scan_chain_0.D_ff1_4.D_latch1$1_0.NAND2$2_2.B VSS 0.83732f
C2808 scan_chain_0.D_ff1_0.D_latch1$1_1.inv1$3_0.Y VSS 0.56821f
C2809 a_56600_79067# VSS 0.38807f
C2810 a_55117_79067# VSS 0.38816f
C2811 scan_chain_0.D_ff1_4.D_latch1$1_1.NAND2$2_2.B VSS 0.51413f
C2812 scan_chain_0.D_ff1_4.D_latch1$1_0.inv1$3_0.Y VSS 0.59792f
C2813 a_52754_79067# VSS 0.38805f
C2814 a_51271_79067# VSS 0.52793f
C2815 scan_chain_0.D_ff1_3.D_latch1$1_0.NAND2$2_2.B VSS 0.8359f
C2816 scan_chain_0.D_ff1_4.D_latch1$1_1.inv1$3_0.Y VSS 0.56524f
C2817 a_48899_79067# VSS 0.38807f
C2818 a_47416_79067# VSS 0.38816f
C2819 scan_chain_0.D_ff1_3.D_latch1$1_1.NAND2$2_2.B VSS 0.51413f
C2820 scan_chain_0.D_ff1_3.D_latch1$1_0.inv1$3_0.Y VSS 0.59792f
C2821 a_45053_79067# VSS 0.38805f
C2822 a_43570_79067# VSS 0.52793f
C2823 scan_chain_0.D_ff1_2.D_latch1$1_0.NAND2$2_2.B VSS 0.8359f
C2824 scan_chain_0.D_ff1_3.D_latch1$1_1.inv1$3_0.Y VSS 0.56524f
C2825 a_41198_79067# VSS 0.38807f
C2826 a_39715_79067# VSS 0.39232f
C2827 scan_chain_0.D_ff1_2.D_latch1$1_1.NAND2$2_2.B VSS 0.52745f
C2828 scan_chain_0.D_ff1_2.D_latch1$1_0.inv1$3_0.Y VSS 0.59792f
C2829 a_37352_79067# VSS 0.38852f
C2830 a_35869_79067# VSS 0.54637f
C2831 scan_chain_0.D_ff1_1.D_latch1$1_0.NAND2$2_2.B VSS 0.87408f
C2832 scan_chain_0.D_ff1_2.D_latch1$1_1.inv1$3_0.Y VSS 0.59271f
C2833 a_33497_79067# VSS 0.39318f
C2834 a_32014_79067# VSS 0.39532f
C2835 scan_chain_0.D_ff1_1.D_latch1$1_1.NAND2$2_2.B VSS 0.54456f
C2836 scan_chain_0.D_ff1_1.D_latch1$1_0.inv1$3_0.Y VSS 0.61553f
C2837 a_29651_79067# VSS 0.40312f
C2838 a_28168_79067# VSS 0.53082f
C2839 scan_chain_0.D_ff1_8.D_latch1$1_0.NAND2$2_2.B VSS 0.86907f
C2840 scan_chain_0.D_ff1_1.D_latch1$1_1.inv1$3_0.Y VSS 0.56885f
C2841 a_25796_79067# VSS 0.4006f
C2842 a_24313_79067# VSS 0.39032f
C2843 scan_chain_0.D_ff1_8.D_latch1$1_1.NAND2$2_2.B VSS 0.52403f
C2844 scan_chain_0.D_ff1_8.D_latch1$1_0.inv1$3_0.Y VSS 0.60165f
C2845 a_21950_79067# VSS 0.3927f
C2846 a_20467_79067# VSS 0.53335f
C2847 scan_chain_0.D_ff1_7.D_latch1$1_0.NAND2$2_2.B VSS 0.84722f
C2848 scan_chain_0.D_ff1_8.D_latch1$1_1.inv1$3_0.Y VSS 0.57564f
C2849 a_18095_79067# VSS 0.38919f
C2850 a_16612_79067# VSS 0.40469f
C2851 scan_chain_0.D_ff1_7.D_latch1$1_1.NAND2$2_2.B VSS 0.55171f
C2852 scan_chain_0.D_ff1_7.D_latch1$1_0.inv1$3_0.Y VSS 0.63593f
C2853 a_14249_79067# VSS 0.39238f
C2854 a_12766_79067# VSS 0.53901f
C2855 scan_chain_0.D_ff1_6.D_latch1$1_0.NAND2$2_2.B VSS 0.8696f
C2856 scan_chain_0.D_ff1_7.D_latch1$1_1.inv1$3_0.Y VSS 0.59212f
C2857 a_10394_79067# VSS 0.40037f
C2858 a_8911_79067# VSS 0.39203f
C2859 scan_chain_0.D_ff1_6.D_latch1$1_1.NAND2$2_2.B VSS 0.55111f
C2860 scan_chain_0.D_ff1_6.D_latch1$1_0.inv1$3_0.Y VSS 0.60252f
C2861 a_6548_79067# VSS 0.40348f
C2862 a_5065_79067# VSS 0.52934f
C2863 scan_chain_0.D_ff1_5.D_latch1$1_0.NAND2$2_2.B VSS 0.84625f
C2864 scan_chain_0.D_ff1_6.D_latch1$1_1.inv1$3_0.Y VSS 0.56792f
C2865 a_2693_79067# VSS 0.39325f
C2866 a_1210_79067# VSS 0.38978f
C2867 scan_chain_0.D_ff1_5.D_latch1$1_1.NAND2$2_2.B VSS 0.52243f
C2868 scan_chain_0.D_ff1_5.D_latch1$1_0.inv1$3_0.Y VSS 0.60774f
C2869 scan_chain_0.D_ff1_5.D_latch1$1_1.inv1$3_0.Y VSS 0.57686f
C2870 programmable_common_source_0.programmable_pfet$5_0.transmission_gate$30_0.out VSS 3.58999f
C2871 programmable_common_source_0.programmable_pfet$5_0.transmission_gate$30_1.out VSS 2.44584f
C2872 scan_chain_0.D_ff1_0.Q_bar VSS 0.83375f
C2873 a_68157_79808# VSS 0.42258f
C2874 scan_chain_0.D_ff1_0.inv1$4_0.Y VSS 1.94141f
C2875 a_66673_79808# VSS 0.41475f
C2876 scan_chain_0.D_ff1_0.D_latch1$1_0.NAND2$2_0.A VSS 0.78865f
C2877 scan_chain_0.D_ff1_0.D_latch1$1_1.Q_bar VSS 0.83049f
C2878 a_64302_79808# VSS 0.42733f
C2879 scan_chain_0.D_ff1_0.D_latch1$1_0.D VSS 2.02357f
C2880 a_62818_79808# VSS 0.41101f
C2881 scan_chain_0.D_ff1_0.D_latch1$1_1.NAND2$2_0.A VSS 0.77478f
C2882 programmable_common_source_0.EN1 VSS 11.08747f
C2883 a_60456_79808# VSS 0.4193f
C2884 programmable_common_source_0.EN1 VSS 9.49395f
C2885 scan_chain_0.D_ff1_4.inv1$4_0.Y VSS 1.94134f
C2886 a_58972_79808# VSS 0.41019f
C2887 scan_chain_0.D_ff1_4.D_latch1$1_0.NAND2$2_0.A VSS 0.77099f
C2888 scan_chain_0.D_ff1_4.D_latch1$1_1.Q_bar VSS 0.79523f
C2889 a_56601_79808# VSS 0.41376f
C2890 scan_chain_0.D_ff1_4.D_latch1$1_0.D VSS 1.98271f
C2891 a_55117_79808# VSS 0.40999f
C2892 scan_chain_0.D_ff1_4.D_latch1$1_1.NAND2$2_0.A VSS 0.76939f
C2893 programmable_common_source_0.EN0 VSS 10.50464f
C2894 a_52755_79808# VSS 0.41375f
C2895 programmable_common_source_0.EN0 VSS 11.13395f
C2896 scan_chain_0.D_ff1_3.inv1$4_0.Y VSS 1.9409f
C2897 a_51271_79808# VSS 0.41019f
C2898 scan_chain_0.D_ff1_3.D_latch1$1_0.NAND2$2_0.A VSS 0.76977f
C2899 scan_chain_0.D_ff1_3.D_latch1$1_1.Q_bar VSS 0.79523f
C2900 a_48900_79808# VSS 0.41376f
C2901 scan_chain_0.D_ff1_3.D_latch1$1_0.D VSS 1.98271f
C2902 a_47416_79808# VSS 0.40999f
C2903 scan_chain_0.D_ff1_3.D_latch1$1_1.NAND2$2_0.A VSS 0.76939f
C2904 programmable_5tOTA_0.ena_bar<1> VSS 24.78062f
C2905 a_45054_79808# VSS 0.41375f
C2906 transmission_gate$2$1_2.out VSS 21.02174f
C2907 scan_chain_0.D_ff1_2.inv1$4_0.Y VSS 1.93821f
C2908 a_43570_79808# VSS 0.41019f
C2909 scan_chain_0.D_ff1_2.D_latch1$1_0.NAND2$2_0.A VSS 0.76977f
C2910 scan_chain_0.D_ff1_2.D_latch1$1_1.Q_bar VSS 0.79523f
C2911 a_41199_79808# VSS 0.41376f
C2912 scan_chain_0.D_ff1_2.D_latch1$1_0.D VSS 1.98352f
C2913 a_39715_79808# VSS 0.416f
C2914 scan_chain_0.D_ff1_2.D_latch1$1_1.NAND2$2_0.A VSS 0.78491f
C2915 programmable_5tOTA_0.ena_bar<0> VSS 20.26699f
C2916 a_37353_79808# VSS 0.41442f
C2917 transmission_gate$2$1_3.out VSS 18.46516f
C2918 scan_chain_0.D_ff1_1.inv1$4_0.Y VSS 2.01969f
C2919 a_35869_79808# VSS 0.42703f
C2920 scan_chain_0.D_ff1_1.D_latch1$1_0.NAND2$2_0.A VSS 0.80847f
C2921 scan_chain_0.D_ff1_1.D_latch1$1_1.Q_bar VSS 0.80088f
C2922 a_33498_79808# VSS 0.41886f
C2923 scan_chain_0.D_ff1_1.D_latch1$1_0.D VSS 2.00904f
C2924 a_32014_79808# VSS 0.41711f
C2925 scan_chain_0.D_ff1_1.D_latch1$1_1.NAND2$2_0.A VSS 0.80739f
C2926 programmable_telescopic_cascode_0.EN1 VSS 9.79755f
C2927 a_29652_79808# VSS 0.42716f
C2928 transmission_gate$2$1_4.out VSS 16.32534f
C2929 scan_chain_0.D_ff1_8.inv1$4_0.Y VSS 1.97473f
C2930 a_28168_79808# VSS 0.41308f
C2931 scan_chain_0.D_ff1_8.D_latch1$1_0.NAND2$2_0.A VSS 0.79579f
C2932 scan_chain_0.D_ff1_8.D_latch1$1_1.Q_bar VSS 0.85955f
C2933 a_25797_79808# VSS 0.42513f
C2934 scan_chain_0.D_ff1_8.D_latch1$1_0.D VSS 2.05009f
C2935 a_24313_79808# VSS 0.41216f
C2936 scan_chain_0.D_ff1_8.D_latch1$1_1.NAND2$2_0.A VSS 0.78097f
C2937 programmable_telescopic_cascode_0.EN0 VSS 12.0249f
C2938 a_21951_79808# VSS 0.41841f
C2939 transmission_gate$2$1_5.out VSS 13.2102f
C2940 scan_chain_0.D_ff1_7.inv1$4_0.Y VSS 2.01658f
C2941 a_20467_79808# VSS 0.41561f
C2942 scan_chain_0.D_ff1_7.D_latch1$1_0.NAND2$2_0.A VSS 0.78293f
C2943 scan_chain_0.D_ff1_7.D_latch1$1_1.Q_bar VSS 0.8074f
C2944 a_18096_79808# VSS 0.41488f
C2945 scan_chain_0.D_ff1_7.D_latch1$1_0.D VSS 2.05569f
C2946 a_16612_79808# VSS 0.42487f
C2947 scan_chain_0.D_ff1_7.D_latch1$1_1.NAND2$2_0.A VSS 0.80392f
C2948 programmable_folded_cascode_0.EN1 VSS 34.92574f
C2949 a_14250_79808# VSS 0.41807f
C2950 transmission_gate$2$1_6.out VSS 37.97243f
C2951 scan_chain_0.D_ff1_6.inv1$4_0.Y VSS 2.05116f
C2952 a_12766_79808# VSS 0.41959f
C2953 scan_chain_0.D_ff1_6.D_latch1$1_0.NAND2$2_0.A VSS 0.81012f
C2954 scan_chain_0.D_ff1_6.D_latch1$1_1.Q_bar VSS 0.82137f
C2955 a_10395_79808# VSS 0.42486f
C2956 scan_chain_0.D_ff1_6.D_latch1$1_0.D VSS 2.02223f
C2957 a_8911_79808# VSS 0.41386f
C2958 scan_chain_0.D_ff1_6.D_latch1$1_1.NAND2$2_0.A VSS 0.79964f
C2959 programmable_folded_cascode_0.EN0 VSS 30.00478f
C2960 a_6549_79808# VSS 0.42761f
C2961 transmission_gate$2$1_7.out VSS 33.44476f
C2962 scan_chain_0.D_ff1_5.inv1$4_0.Y VSS 2.00396f
C2963 a_5065_79808# VSS 0.4116f
C2964 scan_chain_0.D_ff1_5.D_latch1$1_0.NAND2$2_0.A VSS 0.78154f
C2965 scan_chain_0.D_ff1_5.D_latch1$1_1.Q_bar VSS 0.83235f
C2966 a_2694_79808# VSS 0.41895f
C2967 scan_chain_0.D_ff1_5.D_latch1$1_0.D VSS 2.0744f
C2968 a_1210_79808# VSS 0.40999f
C2969 scan_chain_0.D_ff1_5.D_latch1$1_1.NAND2$2_0.A VSS 0.77449f
C2970 INP_TELESCOPIC.t1 VSS 0.00301f
C2971 INP_TELESCOPIC.t3 VSS 0.00293f
C2972 INP_TELESCOPIC.n0 VSS 0.00991f
C2973 INP_TELESCOPIC.t2 VSS 0.00301f
C2974 INP_TELESCOPIC.t0 VSS 0.00293f
C2975 INP_TELESCOPIC.n1 VSS 0.0099f
C2976 INP_TELESCOPIC.n2 VSS 0.01199f
C2977 INP_TELESCOPIC.t4 VSS 0.19058f
C2978 INP_TELESCOPIC.n3 VSS 0.17597f
C2979 INP_TELESCOPIC.n4 VSS 0
C2980 INP_TELESCOPIC.n5 VSS 0.01892f
C2981 INP_TELESCOPIC.n6 VSS 0
C2982 INP_TELESCOPIC.n7 VSS 0.00815f
C2983 INP_TELESCOPIC.n8 VSS 0.0185f
C2984 INP_TELESCOPIC.n9 VSS 0.02048f
C2985 INP_TELESCOPIC.n10 VSS 0.00787f
C2986 INP_TELESCOPIC.n11 VSS 0.00787f
C2987 INP_TELESCOPIC.n12 VSS 0.00862f
C2988 INP_TELESCOPIC.n13 VSS 0.0185f
C2989 INP_TELESCOPIC.n14 VSS 0.01797f
C2990 INP_TELESCOPIC.n15 VSS 3.2961f
C2991 INP_TELESCOPIC.n16 VSS 0.0153f
C2992 INP_TELESCOPIC.n17 VSS 0.01046f
C2993 INP_TELESCOPIC.n18 VSS 0.02096f
C2994 INP_TELESCOPIC.n19 VSS 0.01591f
C2995 INP_TELESCOPIC.n20 VSS 0.01631f
C2996 INP_TELESCOPIC.n21 VSS 0
C2997 INP_TELESCOPIC.n22 VSS 0.01549f
C2998 INP_TELESCOPIC.n23 VSS 0.00552f
C2999 INP_TELESCOPIC.n24 VSS 0.01389f
C3000 INP_TELESCOPIC.n25 VSS 0.02466f
C3001 INP_TELESCOPIC.n26 VSS 0.01565f
C3002 INP_TELESCOPIC.n27 VSS 3.29627f
C3003 INP_TELESCOPIC.n28 VSS 0.00552f
C3004 INP_TELESCOPIC.n29 VSS 12.2633f
C3005 INP_TELESCOPIC.n30 VSS 5.74481f
C3006 programmable_folded_cascode_0.programmable_pfet$1_0.transmission_gate$17_0.out.t1 VSS 0.00912f
C3007 programmable_folded_cascode_0.programmable_pfet$1_0.transmission_gate$17_0.out.t3 VSS 0.78285f
C3008 programmable_folded_cascode_0.programmable_pfet$1_0.transmission_gate$17_0.out.t6 VSS 0.80508f
C3009 programmable_folded_cascode_0.programmable_pfet$1_0.transmission_gate$17_0.out.t4 VSS 0.80515f
C3010 programmable_folded_cascode_0.programmable_pfet$1_0.transmission_gate$17_0.out.t5 VSS 0.80515f
C3011 programmable_folded_cascode_0.programmable_pfet$1_0.transmission_gate$17_0.out.t7 VSS 0.61076f
C3012 programmable_folded_cascode_0.programmable_pfet$1_0.transmission_gate$17_0.out.t2 VSS 0.0573f
C3013 programmable_folded_cascode_0.programmable_pfet$1_0.transmission_gate$17_0.out.n0 VSS 0.42118f
C3014 programmable_folded_cascode_0.programmable_pfet$1_0.transmission_gate$17_0.out.n1 VSS 0.06367f
C3015 programmable_folded_cascode_0.programmable_pfet$1_0.transmission_gate$17_0.out.t0 VSS 0.00942f
C3016 programmable_telescopic_cascode_0.programmable_pfet$2_0.transmission_gate$22_0.out.t0 VSS 0.01294f
C3017 programmable_telescopic_cascode_0.programmable_pfet$2_0.transmission_gate$22_0.out.t1 VSS 0.01255f
C3018 programmable_telescopic_cascode_0.programmable_pfet$2_0.transmission_gate$22_0.out.t12 VSS 1.70308f
C3019 programmable_telescopic_cascode_0.programmable_pfet$2_0.transmission_gate$22_0.out.t5 VSS 1.73361f
C3020 programmable_telescopic_cascode_0.programmable_pfet$2_0.transmission_gate$22_0.out.t7 VSS 1.73361f
C3021 programmable_telescopic_cascode_0.programmable_pfet$2_0.transmission_gate$22_0.out.t11 VSS 1.73361f
C3022 programmable_telescopic_cascode_0.programmable_pfet$2_0.transmission_gate$22_0.out.t3 VSS 1.3206f
C3023 programmable_telescopic_cascode_0.programmable_pfet$2_0.transmission_gate$22_0.out.t6 VSS 1.70308f
C3024 programmable_telescopic_cascode_0.programmable_pfet$2_0.transmission_gate$22_0.out.t9 VSS 1.73361f
C3025 programmable_telescopic_cascode_0.programmable_pfet$2_0.transmission_gate$22_0.out.t10 VSS 1.73361f
C3026 programmable_telescopic_cascode_0.programmable_pfet$2_0.transmission_gate$22_0.out.t4 VSS 1.73361f
C3027 programmable_telescopic_cascode_0.programmable_pfet$2_0.transmission_gate$22_0.out.t8 VSS 1.30906f
C3028 programmable_telescopic_cascode_0.programmable_pfet$2_0.transmission_gate$22_0.out.n0 VSS 0.91097f
C3029 programmable_telescopic_cascode_0.programmable_pfet$2_0.transmission_gate$22_0.out.t2 VSS 0.08037f
C3030 programmable_telescopic_cascode_0.programmable_pfet$2_0.transmission_gate$22_0.out.n1 VSS 0.23201f
C3031 programmable_telescopic_cascode_0.programmable_pfet$2_0.transmission_gate$22_0.out.n2 VSS 0.07237f
C3032 INP_5T.t6 VSS 0.13169f
C3033 INP_5T.t5 VSS 0.13907f
C3034 INP_5T.t4 VSS 0.10864f
C3035 INP_5T.t3 VSS 0.00402f
C3036 INP_5T.t2 VSS 0.00411f
C3037 INP_5T.n0 VSS 0.01386f
C3038 INP_5T.t1 VSS 0.00402f
C3039 INP_5T.t0 VSS 0.00412f
C3040 INP_5T.n1 VSS 0.01395f
C3041 INP_5T.n2 VSS 0.01122f
C3042 INP_5T.n3 VSS 0.20909f
C3043 INP_5T.n4 VSS 0.01098f
C3044 INP_5T.n5 VSS 0.02452f
C3045 INP_5T.n6 VSS 0
C3046 INP_5T.n7 VSS 0.01118f
C3047 INP_5T.n8 VSS 0.03816f
C3048 INP_5T.n9 VSS 0.04491f
C3049 INP_5T.n10 VSS 0.0108f
C3050 INP_5T.n11 VSS 0.0108f
C3051 INP_5T.n12 VSS 0.01778f
C3052 INP_5T.n13 VSS 0.03816f
C3053 INP_5T.n14 VSS 0.02465f
C3054 INP_5T.n15 VSS 16.9927f
C3055 INP_5T.n16 VSS 16.996f
C3056 INP_5T.n17 VSS 0.01689f
C3057 INP_5T.n18 VSS 0.01026f
C3058 INP_5T.n19 VSS 0.00397f
C3059 INP_5T.n20 VSS 0.01122f
C3060 INP_5T.n21 VSS 0.90208f
C3061 INP_5T.n22 VSS 0.66277f
C3062 SCAN_OUT.t2 VSS 0.06927f
C3063 SCAN_OUT.t1 VSS 0.06556f
C3064 SCAN_OUT.n0 VSS 0.25224f
C3065 SCAN_OUT.t0 VSS 0.0653f
C3066 SCAN_OUT.n1 VSS 0.20075f
C3067 SCAN_OUT.n2 VSS 2.13794f
C3068 SCAN_OUT.t4 VSS 0.02614f
C3069 SCAN_OUT.n3 VSS 0.06293f
C3070 SCAN_OUT.t3 VSS 0.02741f
C3071 programmable_telescopic_cascode_0.programmable_pfet$3_1.transmission_gate$23_0.out.t0 VSS 0.01319f
C3072 programmable_telescopic_cascode_0.programmable_pfet$3_1.transmission_gate$23_0.out.t1 VSS 0.01278f
C3073 programmable_telescopic_cascode_0.programmable_pfet$3_1.transmission_gate$23_0.out.t13 VSS 1.47815f
C3074 programmable_telescopic_cascode_0.programmable_pfet$3_1.transmission_gate$23_0.out.t8 VSS 1.50926f
C3075 programmable_telescopic_cascode_0.programmable_pfet$3_1.transmission_gate$23_0.out.t14 VSS 1.50926f
C3076 programmable_telescopic_cascode_0.programmable_pfet$3_1.transmission_gate$23_0.out.t5 VSS 1.50926f
C3077 programmable_telescopic_cascode_0.programmable_pfet$3_1.transmission_gate$23_0.out.t7 VSS 1.50926f
C3078 programmable_telescopic_cascode_0.programmable_pfet$3_1.transmission_gate$23_0.out.t3 VSS 1.14096f
C3079 programmable_telescopic_cascode_0.programmable_pfet$3_1.transmission_gate$23_0.out.t4 VSS 1.47815f
C3080 programmable_telescopic_cascode_0.programmable_pfet$3_1.transmission_gate$23_0.out.t12 VSS 1.50926f
C3081 programmable_telescopic_cascode_0.programmable_pfet$3_1.transmission_gate$23_0.out.t6 VSS 1.50926f
C3082 programmable_telescopic_cascode_0.programmable_pfet$3_1.transmission_gate$23_0.out.t10 VSS 1.50926f
C3083 programmable_telescopic_cascode_0.programmable_pfet$3_1.transmission_gate$23_0.out.t11 VSS 1.50926f
C3084 programmable_telescopic_cascode_0.programmable_pfet$3_1.transmission_gate$23_0.out.t9 VSS 1.15279f
C3085 programmable_telescopic_cascode_0.programmable_pfet$3_1.transmission_gate$23_0.out.n0 VSS 0.81188f
C3086 programmable_telescopic_cascode_0.programmable_pfet$3_1.transmission_gate$23_0.out.t2 VSS 0.0815f
C3087 programmable_telescopic_cascode_0.programmable_pfet$3_1.transmission_gate$23_0.out.n1 VSS 0.24084f
C3088 programmable_telescopic_cascode_0.programmable_pfet$3_1.transmission_gate$23_0.out.n2 VSS 0.07352f
C3089 a_58284_41264.t7 VSS 0.32652f
C3090 a_58284_41264.t2 VSS 0.06867f
C3091 a_58284_41264.t1 VSS 0.06867f
C3092 a_58284_41264.n0 VSS 0.31853f
C3093 a_58284_41264.t4 VSS 0.49152f
C3094 a_58284_41264.n1 VSS 0.12047f
C3095 a_58284_41264.n2 VSS 0.22866f
C3096 a_58284_41264.t5 VSS 0.11575f
C3097 a_58284_41264.n3 VSS 0.18087f
C3098 a_58284_41264.t6 VSS 0.24676f
C3099 a_58284_41264.n4 VSS 0.05929f
C3100 a_58284_41264.t3 VSS 0.25023f
C3101 a_58284_41264.n5 VSS 0.07728f
C3102 a_58284_41264.t0 VSS 0.24678f
C3103 programmable_5tOTA_0.ena_bar<0>.t7 VSS 0.03032f
C3104 programmable_5tOTA_0.ena_bar<0>.t4 VSS 0.02891f
C3105 programmable_5tOTA_0.ena_bar<0>.n0 VSS 0.29296f
C3106 programmable_5tOTA_0.ena_bar<0>.t0 VSS 0.07568f
C3107 programmable_5tOTA_0.ena_bar<0>.t1 VSS 0.07251f
C3108 programmable_5tOTA_0.ena_bar<0>.n1 VSS 0.13817f
C3109 programmable_5tOTA_0.ena_bar<0>.t2 VSS 0.07345f
C3110 programmable_5tOTA_0.ena_bar<0>.n2 VSS 0.14238f
C3111 programmable_5tOTA_0.ena_bar<0>.t10 VSS 0.07365f
C3112 programmable_5tOTA_0.ena_bar<0>.t3 VSS 0.03012f
C3113 programmable_5tOTA_0.ena_bar<0>.n3 VSS 0.05317f
C3114 programmable_5tOTA_0.ena_bar<0>.n4 VSS 0.9233f
C3115 programmable_5tOTA_0.ena_bar<0>.t11 VSS 0.03012f
C3116 programmable_5tOTA_0.ena_bar<0>.n5 VSS 0.03514f
C3117 programmable_5tOTA_0.ena_bar<0>.t8 VSS 0.03012f
C3118 programmable_5tOTA_0.ena_bar<0>.n6 VSS 0.03514f
C3119 programmable_5tOTA_0.ena_bar<0>.n7 VSS 0.35108f
C3120 programmable_5tOTA_0.ena_bar<0>.n8 VSS 1.08825f
C3121 programmable_5tOTA_0.ena_bar<0>.t6 VSS 0.03153f
C3122 programmable_5tOTA_0.ena_bar<0>.t5 VSS 0.03012f
C3123 programmable_5tOTA_0.ena_bar<0>.n9 VSS 0.05269f
C3124 programmable_5tOTA_0.ena_bar<0>.n10 VSS 0.4305f
C3125 programmable_5tOTA_0.ena_bar<0>.t12 VSS 0.03153f
C3126 programmable_5tOTA_0.ena_bar<0>.t9 VSS 0.03012f
C3127 programmable_5tOTA_0.ena_bar<0>.n11 VSS 0.05269f
C3128 programmable_5tOTA_0.ena_bar<0>.n12 VSS 0.392f
C3129 programmable_5tOTA_0.ena_bar<0>.n13 VSS 0.34785f
C3130 programmable_5tOTA_0.ena_bar<0>.n14 VSS 19.9462f
C3131 programmable_5tOTA_0.ena_bar<0>.n15 VSS 17.3245f
C3132 programmable_telescopic_cascode_0.programmable_nfet$4_0.transmission_gate$24_1.out.t2 VSS 0.01036f
C3133 programmable_telescopic_cascode_0.programmable_nfet$4_0.transmission_gate$24_1.out.t1 VSS 0.02984f
C3134 programmable_telescopic_cascode_0.programmable_nfet$4_0.transmission_gate$24_1.out.t5 VSS 1.0393f
C3135 programmable_telescopic_cascode_0.programmable_nfet$4_0.transmission_gate$24_1.out.t4 VSS 1.05326f
C3136 programmable_telescopic_cascode_0.programmable_nfet$4_0.transmission_gate$24_1.out.t7 VSS 1.05326f
C3137 programmable_telescopic_cascode_0.programmable_nfet$4_0.transmission_gate$24_1.out.t3 VSS 1.05326f
C3138 programmable_telescopic_cascode_0.programmable_nfet$4_0.transmission_gate$24_1.out.t6 VSS 1.05326f
C3139 programmable_telescopic_cascode_0.programmable_nfet$4_0.transmission_gate$24_1.out.t8 VSS 0.79986f
C3140 programmable_telescopic_cascode_0.programmable_nfet$4_0.transmission_gate$24_1.out.n0 VSS 0.39533f
C3141 programmable_telescopic_cascode_0.programmable_nfet$4_0.transmission_gate$24_1.out.t0 VSS 0.00969f
C3142 programmable_telescopic_cascode_0.programmable_nfet$4_0.transmission_gate$24_1.out.n1 VSS 0.05914f
C3143 programmable_common_source_0.EN1.t6 VSS 0.03215f
C3144 programmable_common_source_0.EN1.n0 VSS 0.05838f
C3145 programmable_common_source_0.EN1.t5 VSS 0.03215f
C3146 programmable_common_source_0.EN1.n1 VSS 0.03348f
C3147 programmable_common_source_0.EN1.t3 VSS 0.07223f
C3148 programmable_common_source_0.EN1.n2 VSS 0.41059f
C3149 programmable_common_source_0.EN1.n3 VSS 7.07502f
C3150 programmable_common_source_0.EN1.t4 VSS 0.03236f
C3151 programmable_common_source_0.EN1.t7 VSS 0.03085f
C3152 programmable_common_source_0.EN1.n4 VSS 0.31133f
C3153 programmable_common_source_0.EN1.n5 VSS 6.70312f
C3154 programmable_common_source_0.EN1.t2 VSS 0.08077f
C3155 programmable_common_source_0.EN1.t1 VSS 0.07738f
C3156 programmable_common_source_0.EN1.n6 VSS 0.14746f
C3157 programmable_common_source_0.EN1.t0 VSS 0.07839f
C3158 programmable_common_source_0.EN1.n7 VSS 0.177f
C3159 programmable_5tOTA_0.programmable_pfet$4_1.transmission_gate$27_0.out.t0 VSS 0.01108f
C3160 programmable_5tOTA_0.programmable_pfet$4_1.transmission_gate$27_0.out.t1 VSS 0.01075f
C3161 programmable_5tOTA_0.programmable_pfet$4_1.transmission_gate$27_0.out.t4 VSS 1.55066f
C3162 programmable_5tOTA_0.programmable_pfet$4_1.transmission_gate$27_0.out.t6 VSS 1.20669f
C3163 programmable_5tOTA_0.programmable_pfet$4_1.transmission_gate$27_0.out.t2 VSS 0.01528f
C3164 programmable_5tOTA_0.programmable_pfet$4_1.transmission_gate$27_0.out.t5 VSS 1.55066f
C3165 programmable_5tOTA_0.programmable_pfet$4_1.transmission_gate$27_0.out.t3 VSS 1.20153f
C3166 programmable_5tOTA_0.programmable_pfet$4_1.transmission_gate$27_0.out.n0 VSS 0.59706f
C3167 programmable_5tOTA_0.programmable_pfet$4_1.transmission_gate$27_0.out.n1 VSS 0.6221f
C3168 programmable_5tOTA_0.programmable_pfet$4_1.transmission_gate$27_0.out.n2 VSS 0.09892f
C3169 programmable_folded_cascode_0.programmable_nfet$3_0.transmission_gate$21_1.out.t0 VSS 0.01479f
C3170 programmable_folded_cascode_0.programmable_nfet$3_0.transmission_gate$21_1.out.t6 VSS 0.52583f
C3171 programmable_folded_cascode_0.programmable_nfet$3_0.transmission_gate$21_1.out.t4 VSS 0.4293f
C3172 programmable_folded_cascode_0.programmable_nfet$3_0.transmission_gate$21_1.out.n0 VSS 0.1706f
C3173 programmable_folded_cascode_0.programmable_nfet$3_0.transmission_gate$21_1.out.t5 VSS 0.52583f
C3174 programmable_folded_cascode_0.programmable_nfet$3_0.transmission_gate$21_1.out.t3 VSS 0.42927f
C3175 programmable_folded_cascode_0.programmable_nfet$3_0.transmission_gate$21_1.out.n1 VSS 0.14703f
C3176 programmable_folded_cascode_0.programmable_nfet$3_0.transmission_gate$21_1.out.t2 VSS 0.00439f
C3177 programmable_folded_cascode_0.programmable_nfet$3_0.transmission_gate$21_1.out.n2 VSS 0.02858f
C3178 programmable_folded_cascode_0.programmable_nfet$3_0.transmission_gate$21_1.out.t1 VSS 0.00469f
C3179 programmable_telescopic_cascode_0.programmable_pfet$2_0.g.t5 VSS 0.01852f
C3180 programmable_telescopic_cascode_0.programmable_pfet$2_0.g.t9 VSS 0.01793f
C3181 programmable_telescopic_cascode_0.programmable_pfet$2_0.g.n0 VSS 0.05995f
C3182 programmable_telescopic_cascode_0.programmable_pfet$2_0.g.t7 VSS 0.01852f
C3183 programmable_telescopic_cascode_0.programmable_pfet$2_0.g.t3 VSS 0.01794f
C3184 programmable_telescopic_cascode_0.programmable_pfet$2_0.g.n1 VSS 0.06002f
C3185 programmable_telescopic_cascode_0.programmable_pfet$2_0.g.n2 VSS 0.08854f
C3186 programmable_telescopic_cascode_0.programmable_pfet$2_0.g.t4 VSS 0.01852f
C3187 programmable_telescopic_cascode_0.programmable_pfet$2_0.g.t8 VSS 0.01793f
C3188 programmable_telescopic_cascode_0.programmable_pfet$2_0.g.n3 VSS 0.05995f
C3189 programmable_telescopic_cascode_0.programmable_pfet$2_0.g.t6 VSS 0.01852f
C3190 programmable_telescopic_cascode_0.programmable_pfet$2_0.g.t2 VSS 0.01794f
C3191 programmable_telescopic_cascode_0.programmable_pfet$2_0.g.n4 VSS 0.06002f
C3192 programmable_telescopic_cascode_0.programmable_pfet$2_0.g.n5 VSS 0.08854f
C3193 programmable_telescopic_cascode_0.programmable_pfet$2_0.g.t14 VSS 2.43633f
C3194 programmable_telescopic_cascode_0.programmable_pfet$2_0.g.t18 VSS 2.47999f
C3195 programmable_telescopic_cascode_0.programmable_pfet$2_0.g.t20 VSS 2.47999f
C3196 programmable_telescopic_cascode_0.programmable_pfet$2_0.g.t13 VSS 2.47999f
C3197 programmable_telescopic_cascode_0.programmable_pfet$2_0.g.t17 VSS 1.87266f
C3198 programmable_telescopic_cascode_0.programmable_pfet$2_0.g.n6 VSS 0.82656f
C3199 programmable_telescopic_cascode_0.programmable_pfet$2_0.g.t0 VSS 0.06756f
C3200 programmable_telescopic_cascode_0.programmable_pfet$2_0.g.t10 VSS 6.74802f
C3201 programmable_telescopic_cascode_0.programmable_pfet$2_0.g.n7 VSS 0.82961f
C3202 programmable_telescopic_cascode_0.programmable_pfet$2_0.g.t1 VSS 0.11397f
C3203 programmable_telescopic_cascode_0.programmable_pfet$2_0.g.n8 VSS 4.6861f
C3204 programmable_telescopic_cascode_0.programmable_pfet$2_0.g.n9 VSS 6.11406f
C3205 programmable_telescopic_cascode_0.programmable_pfet$2_0.g.t12 VSS 2.43633f
C3206 programmable_telescopic_cascode_0.programmable_pfet$2_0.g.t16 VSS 2.47999f
C3207 programmable_telescopic_cascode_0.programmable_pfet$2_0.g.t19 VSS 2.47999f
C3208 programmable_telescopic_cascode_0.programmable_pfet$2_0.g.t11 VSS 2.47999f
C3209 programmable_telescopic_cascode_0.programmable_pfet$2_0.g.t15 VSS 1.87266f
C3210 programmable_telescopic_cascode_0.programmable_pfet$2_0.g.n10 VSS 0.83959f
C3211 programmable_common_source_0.EN1.t4 VSS 0.07545f
C3212 programmable_common_source_0.EN1.t3 VSS 0.0742f
C3213 programmable_common_source_0.EN1.n0 VSS 0.37713f
C3214 programmable_common_source_0.EN1.t11 VSS 0.05456f
C3215 programmable_common_source_0.EN1.t10 VSS 0.09305f
C3216 programmable_common_source_0.EN1.n1 VSS 0.15557f
C3217 programmable_common_source_0.EN1.t5 VSS 0.05422f
C3218 programmable_common_source_0.EN1.n2 VSS 0.16004f
C3219 programmable_common_source_0.EN1.t13 VSS 0.05422f
C3220 programmable_common_source_0.EN1.n3 VSS 0.10846f
C3221 programmable_common_source_0.EN1.t7 VSS 0.11682f
C3222 programmable_common_source_0.EN1.n4 VSS 0.63605f
C3223 programmable_common_source_0.EN1.n5 VSS 11.8236f
C3224 programmable_common_source_0.EN1.t6 VSS 0.05686f
C3225 programmable_common_source_0.EN1.t8 VSS 0.05422f
C3226 programmable_common_source_0.EN1.n6 VSS 0.1952f
C3227 programmable_common_source_0.EN1.n7 VSS 10.7867f
C3228 programmable_common_source_0.EN1.t9 VSS 0.05686f
C3229 programmable_common_source_0.EN1.t12 VSS 0.05422f
C3230 programmable_common_source_0.EN1.n8 VSS 0.14489f
C3231 programmable_common_source_0.EN1.n9 VSS 0.32692f
C3232 programmable_common_source_0.EN1.n10 VSS 0.59972f
C3233 programmable_common_source_0.EN1.t1 VSS 0.14371f
C3234 programmable_common_source_0.EN1.t2 VSS 0.13601f
C3235 programmable_common_source_0.EN1.n11 VSS 0.52334f
C3236 programmable_common_source_0.EN1.t0 VSS 0.13548f
C3237 programmable_common_source_0.EN1.n12 VSS 0.4165f
C3238 PROG_ENA.t9 VSS 0.02146f
C3239 PROG_ENA.t3 VSS 0.01259f
C3240 PROG_ENA.n0 VSS 0.00392f
C3241 PROG_ENA.n1 VSS 0.112f
C3242 PROG_ENA.n2 VSS 0
C3243 PROG_ENA.n3 VSS 0.04825f
C3244 PROG_ENA.n4 VSS 0.10952f
C3245 PROG_ENA.n5 VSS 0.12206f
C3246 PROG_ENA.n6 VSS 0.0466f
C3247 PROG_ENA.n7 VSS 0.0466f
C3248 PROG_ENA.n8 VSS 0.05104f
C3249 PROG_ENA.n9 VSS 0.10952f
C3250 PROG_ENA.n10 VSS 0.10638f
C3251 PROG_ENA.n11 VSS 0.25324f
C3252 PROG_ENA.n12 VSS 0.09056f
C3253 PROG_ENA.n13 VSS 0.06195f
C3254 PROG_ENA.n14 VSS 0.1241f
C3255 PROG_ENA.n15 VSS 0.0942f
C3256 PROG_ENA.n16 VSS 0.09655f
C3257 PROG_ENA.n17 VSS 0.00392f
C3258 PROG_ENA.n18 VSS 0.09168f
C3259 PROG_ENA.n19 VSS 0.03271f
C3260 PROG_ENA.n20 VSS 0.08226f
C3261 PROG_ENA.n21 VSS 0.14757f
C3262 PROG_ENA.n22 VSS 0.09263f
C3263 PROG_ENA.n23 VSS 0.25423f
C3264 PROG_ENA.n24 VSS 0.03271f
C3265 PROG_ENA.n25 VSS 13.1748f
C3266 PROG_ENA.t0 VSS 0.01303f
C3267 PROG_ENA.t6 VSS 0.01303f
C3268 PROG_ENA.n26 VSS 1.69658f
C3269 PROG_ENA.t5 VSS 0.01303f
C3270 PROG_ENA.n27 VSS 1.45386f
C3271 PROG_ENA.t2 VSS 0.01303f
C3272 PROG_ENA.n28 VSS 1.45386f
C3273 PROG_ENA.t4 VSS 0.01303f
C3274 PROG_ENA.n29 VSS 1.45386f
C3275 PROG_ENA.t1 VSS 0.01303f
C3276 PROG_ENA.n30 VSS 1.45386f
C3277 PROG_ENA.t7 VSS 0.01303f
C3278 PROG_ENA.n31 VSS 1.45386f
C3279 PROG_ENA.t8 VSS 0.01303f
C3280 PROG_ENA.n32 VSS 1.33156f
C3281 PROG_ENA.n33 VSS 6.85817f
C3282 PROG_ENA.n34 VSS 0.10347f
C3283 programmable_5tOTA_0.programmable_pfet$4_0.transmission_gate$27_1.out.t1 VSS 0.00766f
C3284 programmable_5tOTA_0.programmable_pfet$4_0.transmission_gate$27_1.out.t2 VSS 0.02902f
C3285 programmable_5tOTA_0.programmable_pfet$4_0.transmission_gate$27_1.out.t4 VSS 1.10736f
C3286 programmable_5tOTA_0.programmable_pfet$4_0.transmission_gate$27_1.out.t3 VSS 0.86193f
C3287 programmable_5tOTA_0.programmable_pfet$4_0.transmission_gate$27_1.out.n0 VSS 0.48653f
C3288 programmable_5tOTA_0.programmable_pfet$4_0.transmission_gate$27_1.out.n1 VSS 0.07411f
C3289 programmable_5tOTA_0.programmable_pfet$4_0.transmission_gate$27_1.out.t0 VSS 0.00791f
C3290 programmable_telescopic_cascode_0.programmable_pfet$3_0.transmission_gate$23_0.out.t0 VSS 0.01297f
C3291 programmable_telescopic_cascode_0.programmable_pfet$3_0.transmission_gate$23_0.out.t1 VSS 0.01257f
C3292 programmable_telescopic_cascode_0.programmable_pfet$3_0.transmission_gate$23_0.out.t10 VSS 1.45431f
C3293 programmable_telescopic_cascode_0.programmable_pfet$3_0.transmission_gate$23_0.out.t6 VSS 1.48492f
C3294 programmable_telescopic_cascode_0.programmable_pfet$3_0.transmission_gate$23_0.out.t13 VSS 1.48492f
C3295 programmable_telescopic_cascode_0.programmable_pfet$3_0.transmission_gate$23_0.out.t4 VSS 1.48492f
C3296 programmable_telescopic_cascode_0.programmable_pfet$3_0.transmission_gate$23_0.out.t5 VSS 1.48492f
C3297 programmable_telescopic_cascode_0.programmable_pfet$3_0.transmission_gate$23_0.out.t3 VSS 1.12256f
C3298 programmable_telescopic_cascode_0.programmable_pfet$3_0.transmission_gate$23_0.out.t7 VSS 1.45431f
C3299 programmable_telescopic_cascode_0.programmable_pfet$3_0.transmission_gate$23_0.out.t14 VSS 1.48492f
C3300 programmable_telescopic_cascode_0.programmable_pfet$3_0.transmission_gate$23_0.out.t8 VSS 1.48492f
C3301 programmable_telescopic_cascode_0.programmable_pfet$3_0.transmission_gate$23_0.out.t11 VSS 1.48492f
C3302 programmable_telescopic_cascode_0.programmable_pfet$3_0.transmission_gate$23_0.out.t12 VSS 1.48492f
C3303 programmable_telescopic_cascode_0.programmable_pfet$3_0.transmission_gate$23_0.out.t9 VSS 1.1342f
C3304 programmable_telescopic_cascode_0.programmable_pfet$3_0.transmission_gate$23_0.out.n0 VSS 0.79879f
C3305 programmable_telescopic_cascode_0.programmable_pfet$3_0.transmission_gate$23_0.out.t2 VSS 0.08018f
C3306 programmable_telescopic_cascode_0.programmable_pfet$3_0.transmission_gate$23_0.out.n1 VSS 0.23695f
C3307 programmable_telescopic_cascode_0.programmable_pfet$3_0.transmission_gate$23_0.out.n2 VSS 0.07234f
C3308 programmable_folded_cascode_0.programmable_nfet$3_0.g.t6 VSS 0.00801f
C3309 programmable_folded_cascode_0.programmable_nfet$3_0.g.t0 VSS 0.00818f
C3310 programmable_folded_cascode_0.programmable_nfet$3_0.g.t8 VSS 0.00801f
C3311 programmable_folded_cascode_0.programmable_nfet$3_0.g.t7 VSS 0.0082f
C3312 programmable_folded_cascode_0.programmable_nfet$3_0.g.n0 VSS 0.02778f
C3313 programmable_folded_cascode_0.programmable_nfet$3_0.g.t11 VSS 0.9218f
C3314 programmable_folded_cascode_0.programmable_nfet$3_0.g.t12 VSS 0.74352f
C3315 programmable_folded_cascode_0.programmable_nfet$3_0.g.t9 VSS 0.96574f
C3316 programmable_folded_cascode_0.programmable_nfet$3_0.g.t1 VSS 1.07045f
C3317 programmable_folded_cascode_0.programmable_nfet$3_0.g.t4 VSS 0.43424f
C3318 programmable_folded_cascode_0.programmable_nfet$3_0.g.n1 VSS 0.70184f
C3319 programmable_folded_cascode_0.programmable_nfet$3_0.g.t2 VSS 0.43424f
C3320 programmable_folded_cascode_0.programmable_nfet$3_0.g.n2 VSS 0.49251f
C3321 programmable_folded_cascode_0.programmable_nfet$3_0.g.t3 VSS 1.07045f
C3322 programmable_folded_cascode_0.programmable_nfet$3_0.g.t5 VSS 0.43424f
C3323 programmable_folded_cascode_0.programmable_nfet$3_0.g.n3 VSS 0.67279f
C3324 programmable_folded_cascode_0.programmable_nfet$3_0.g.n4 VSS 0.43095f
C3325 programmable_folded_cascode_0.programmable_nfet$3_0.g.t10 VSS 0.52509f
C3326 programmable_folded_cascode_0.programmable_nfet$3_0.g.n5 VSS 0.77203f
C3327 programmable_folded_cascode_0.programmable_nfet$3_0.g.n6 VSS 1.08663f
C3328 programmable_folded_cascode_0.programmable_nfet$3_0.g.n7 VSS 1.25755f
C3329 programmable_folded_cascode_0.programmable_nfet$3_0.g.n8 VSS 0.02233f
C3330 programmable_folded_cascode_0.programmable_nfet$3_0.g.n9 VSS 0.0276f
C3331 programmable_telescopic_cascode_0.programmable_pfet$2_1.transmission_gate$22_1.out.t2 VSS 0.00937f
C3332 programmable_telescopic_cascode_0.programmable_pfet$2_1.transmission_gate$22_1.out.t0 VSS 0.00909f
C3333 programmable_telescopic_cascode_0.programmable_pfet$2_1.transmission_gate$22_1.out.t7 VSS 1.23269f
C3334 programmable_telescopic_cascode_0.programmable_pfet$2_1.transmission_gate$22_1.out.t4 VSS 1.25478f
C3335 programmable_telescopic_cascode_0.programmable_pfet$2_1.transmission_gate$22_1.out.t5 VSS 1.25478f
C3336 programmable_telescopic_cascode_0.programmable_pfet$2_1.transmission_gate$22_1.out.t6 VSS 1.25478f
C3337 programmable_telescopic_cascode_0.programmable_pfet$2_1.transmission_gate$22_1.out.t3 VSS 0.94759f
C3338 programmable_telescopic_cascode_0.programmable_pfet$2_1.transmission_gate$22_1.out.t1 VSS 0.06073f
C3339 programmable_telescopic_cascode_0.programmable_pfet$2_1.transmission_gate$22_1.out.n0 VSS 0.49328f
C3340 programmable_telescopic_cascode_0.programmable_pfet$2_1.transmission_gate$22_1.out.n1 VSS 0.05308f
C3341 programmable_telescopic_cascode_0.programmable_pfet$3_1.transmission_gate$23_1.out.t2 VSS 0.01206f
C3342 programmable_telescopic_cascode_0.programmable_pfet$3_1.transmission_gate$23_1.out.t0 VSS 0.01169f
C3343 programmable_telescopic_cascode_0.programmable_pfet$3_1.transmission_gate$23_1.out.t7 VSS 1.35142f
C3344 programmable_telescopic_cascode_0.programmable_pfet$3_1.transmission_gate$23_1.out.t6 VSS 1.37986f
C3345 programmable_telescopic_cascode_0.programmable_pfet$3_1.transmission_gate$23_1.out.t8 VSS 1.37986f
C3346 programmable_telescopic_cascode_0.programmable_pfet$3_1.transmission_gate$23_1.out.t4 VSS 1.37986f
C3347 programmable_telescopic_cascode_0.programmable_pfet$3_1.transmission_gate$23_1.out.t5 VSS 1.37986f
C3348 programmable_telescopic_cascode_0.programmable_pfet$3_1.transmission_gate$23_1.out.t3 VSS 1.04345f
C3349 programmable_telescopic_cascode_0.programmable_pfet$3_1.transmission_gate$23_1.out.t1 VSS 0.07465f
C3350 programmable_telescopic_cascode_0.programmable_pfet$3_1.transmission_gate$23_1.out.n0 VSS 0.58107f
C3351 programmable_telescopic_cascode_0.programmable_pfet$3_1.transmission_gate$23_1.out.n1 VSS 0.06783f
C3352 transmission_gate$2$1_5.out.t1 VSS 0.0545f
C3353 transmission_gate$2$1_5.out.t2 VSS 0.05158f
C3354 transmission_gate$2$1_5.out.n0 VSS 0.19845f
C3355 transmission_gate$2$1_5.out.t4 VSS 0.05137f
C3356 transmission_gate$2$1_5.out.n1 VSS 0.15794f
C3357 transmission_gate$2$1_5.out.t23 VSS 0.02069f
C3358 transmission_gate$2$1_5.out.t21 VSS 0.03529f
C3359 transmission_gate$2$1_5.out.n2 VSS 0.05899f
C3360 transmission_gate$2$1_5.out.t14 VSS 0.02156f
C3361 transmission_gate$2$1_5.out.t16 VSS 0.02056f
C3362 transmission_gate$2$1_5.out.n3 VSS 0.07402f
C3363 transmission_gate$2$1_5.out.n4 VSS 0.09741f
C3364 transmission_gate$2$1_5.out.t18 VSS 0.02056f
C3365 transmission_gate$2$1_5.out.n5 VSS 0.02293f
C3366 transmission_gate$2$1_5.out.t9 VSS 0.02056f
C3367 transmission_gate$2$1_5.out.n6 VSS 0.08588f
C3368 transmission_gate$2$1_5.out.n7 VSS 0.85964f
C3369 transmission_gate$2$1_5.out.t7 VSS 0.02056f
C3370 transmission_gate$2$1_5.out.n8 VSS 0.08588f
C3371 transmission_gate$2$1_5.out.n9 VSS 0.65142f
C3372 transmission_gate$2$1_5.out.t8 VSS 0.02056f
C3373 transmission_gate$2$1_5.out.n10 VSS 0.02417f
C3374 transmission_gate$2$1_5.out.n11 VSS 0.68196f
C3375 transmission_gate$2$1_5.out.t6 VSS 0.02056f
C3376 transmission_gate$2$1_5.out.n12 VSS 0.02417f
C3377 transmission_gate$2$1_5.out.n13 VSS 0.36136f
C3378 transmission_gate$2$1_5.out.t10 VSS 0.02327f
C3379 transmission_gate$2$1_5.out.t12 VSS 0.02056f
C3380 transmission_gate$2$1_5.out.n14 VSS 0.05315f
C3381 transmission_gate$2$1_5.out.n15 VSS 0.38953f
C3382 transmission_gate$2$1_5.out.n16 VSS 1.12484f
C3383 transmission_gate$2$1_5.out.t13 VSS 0.02327f
C3384 transmission_gate$2$1_5.out.t20 VSS 0.02056f
C3385 transmission_gate$2$1_5.out.n17 VSS 0.05315f
C3386 transmission_gate$2$1_5.out.n18 VSS 0.38954f
C3387 transmission_gate$2$1_5.out.n19 VSS 0.78778f
C3388 transmission_gate$2$1_5.out.t5 VSS 0.02325f
C3389 transmission_gate$2$1_5.out.t22 VSS 0.02056f
C3390 transmission_gate$2$1_5.out.n20 VSS 0.03892f
C3391 transmission_gate$2$1_5.out.n21 VSS 0.37536f
C3392 transmission_gate$2$1_5.out.n22 VSS 0.44604f
C3393 transmission_gate$2$1_5.out.t19 VSS 0.02325f
C3394 transmission_gate$2$1_5.out.t17 VSS 0.02056f
C3395 transmission_gate$2$1_5.out.n23 VSS 0.03892f
C3396 transmission_gate$2$1_5.out.n24 VSS 0.52656f
C3397 transmission_gate$2$1_5.out.n25 VSS 1.20042f
C3398 transmission_gate$2$1_5.out.n26 VSS 0.61148f
C3399 transmission_gate$2$1_5.out.t11 VSS 0.02156f
C3400 transmission_gate$2$1_5.out.t15 VSS 0.02056f
C3401 transmission_gate$2$1_5.out.n27 VSS 0.05361f
C3402 transmission_gate$2$1_5.out.n28 VSS 0.01601f
C3403 transmission_gate$2$1_5.out.n29 VSS 0.22741f
C3404 transmission_gate$2$1_5.out.t0 VSS 0.02814f
C3405 transmission_gate$2$1_5.out.n30 VSS 0.14301f
C3406 transmission_gate$2$1_5.out.t3 VSS 0.02861f
C3407 INP_FOLDED.t2 VSS 0.01114f
C3408 INP_FOLDED.t3 VSS 0.01088f
C3409 INP_FOLDED.n0 VSS 0.03774f
C3410 INP_FOLDED.t0 VSS 0.01112f
C3411 INP_FOLDED.t1 VSS 0.01088f
C3412 INP_FOLDED.n1 VSS 0.03751f
C3413 INP_FOLDED.n2 VSS 0.03855f
C3414 INP_FOLDED.n3 VSS 0.69085f
C3415 INP_FOLDED.t4 VSS 0.49017f
C3416 INP_FOLDED.t5 VSS 0.69881f
C3417 INP_FOLDED.n4 VSS 0.48236f
C3418 INP_FOLDED.n5 VSS 0.77269f
C3419 INP_FOLDED.n6 VSS 0
C3420 INP_FOLDED.n7 VSS 0.03025f
C3421 INP_FOLDED.n8 VSS 0.06866f
C3422 INP_FOLDED.n9 VSS 0.08221f
C3423 INP_FOLDED.n10 VSS 0.02921f
C3424 INP_FOLDED.n11 VSS 0.02921f
C3425 INP_FOLDED.n12 VSS 0.03137f
C3426 INP_FOLDED.n13 VSS 0.06866f
C3427 INP_FOLDED.n14 VSS 0.06669f
C3428 INP_FOLDED.n15 VSS 23.0085f
C3429 INP_FOLDED.n16 VSS 9.86034f
C3430 IN_CS.t2 VSS 0.01522f
C3431 IN_CS.t1 VSS 0.0158f
C3432 IN_CS.n0 VSS 0.04939f
C3433 IN_CS.t0 VSS 0.01522f
C3434 IN_CS.t3 VSS 0.0158f
C3435 IN_CS.n1 VSS 0.04857f
C3436 IN_CS.n2 VSS 2.07528f
C3437 IN_CS.t10 VSS 0.83747f
C3438 IN_CS.t4 VSS 0.91849f
C3439 IN_CS.t13 VSS 0.91849f
C3440 IN_CS.t8 VSS 0.91849f
C3441 IN_CS.t5 VSS 0.91849f
C3442 IN_CS.t11 VSS 0.91849f
C3443 IN_CS.t6 VSS 0.91849f
C3444 IN_CS.t12 VSS 0.91849f
C3445 IN_CS.t9 VSS 0.91849f
C3446 IN_CS.t7 VSS 0.75707f
C3447 IN_CS.n3 VSS 0.28404f
C3448 programmable_folded_cascode_0.programmable_pfet$1_1.transmission_gate$17_0.out.t0 VSS 0.00942f
C3449 programmable_folded_cascode_0.programmable_pfet$1_1.transmission_gate$17_0.out.t1 VSS 0.00912f
C3450 programmable_folded_cascode_0.programmable_pfet$1_1.transmission_gate$17_0.out.t7 VSS 0.78285f
C3451 programmable_folded_cascode_0.programmable_pfet$1_1.transmission_gate$17_0.out.t5 VSS 0.80508f
C3452 programmable_folded_cascode_0.programmable_pfet$1_1.transmission_gate$17_0.out.t3 VSS 0.80515f
C3453 programmable_folded_cascode_0.programmable_pfet$1_1.transmission_gate$17_0.out.t6 VSS 0.80515f
C3454 programmable_folded_cascode_0.programmable_pfet$1_1.transmission_gate$17_0.out.t4 VSS 0.61076f
C3455 programmable_folded_cascode_0.programmable_pfet$1_1.transmission_gate$17_0.out.t2 VSS 0.0573f
C3456 programmable_folded_cascode_0.programmable_pfet$1_1.transmission_gate$17_0.out.n0 VSS 0.42118f
C3457 programmable_folded_cascode_0.programmable_pfet$1_1.transmission_gate$17_0.out.n1 VSS 0.06367f
C3458 programmable_telescopic_cascode_0.EN0.t7 VSS 0.03498f
C3459 programmable_telescopic_cascode_0.EN0.t3 VSS 0.03335f
C3460 programmable_telescopic_cascode_0.EN0.n0 VSS 0.33795f
C3461 programmable_telescopic_cascode_0.EN0.t2 VSS 0.0873f
C3462 programmable_telescopic_cascode_0.EN0.t1 VSS 0.08364f
C3463 programmable_telescopic_cascode_0.EN0.n1 VSS 0.15939f
C3464 programmable_telescopic_cascode_0.EN0.t0 VSS 0.08473f
C3465 programmable_telescopic_cascode_0.EN0.n2 VSS 0.17259f
C3466 programmable_telescopic_cascode_0.EN0.t5 VSS 0.08865f
C3467 programmable_telescopic_cascode_0.EN0.t17 VSS 0.03475f
C3468 programmable_telescopic_cascode_0.EN0.n3 VSS 0.05408f
C3469 programmable_telescopic_cascode_0.EN0.t10 VSS 0.08856f
C3470 programmable_telescopic_cascode_0.EN0.t15 VSS 0.03475f
C3471 programmable_telescopic_cascode_0.EN0.n4 VSS 0.0541f
C3472 programmable_telescopic_cascode_0.EN0.n5 VSS 1.35326f
C3473 programmable_telescopic_cascode_0.EN0.t13 VSS 0.08856f
C3474 programmable_telescopic_cascode_0.EN0.t11 VSS 0.03475f
C3475 programmable_telescopic_cascode_0.EN0.n6 VSS 0.05435f
C3476 programmable_telescopic_cascode_0.EN0.n7 VSS 1.02789f
C3477 programmable_telescopic_cascode_0.EN0.t16 VSS 0.08912f
C3478 programmable_telescopic_cascode_0.EN0.t8 VSS 0.03475f
C3479 programmable_telescopic_cascode_0.EN0.n8 VSS 0.0541f
C3480 programmable_telescopic_cascode_0.EN0.n9 VSS 0.95784f
C3481 programmable_telescopic_cascode_0.EN0.t12 VSS 0.08912f
C3482 programmable_telescopic_cascode_0.EN0.t9 VSS 0.03475f
C3483 programmable_telescopic_cascode_0.EN0.n10 VSS 0.0541f
C3484 programmable_telescopic_cascode_0.EN0.n11 VSS 0.66368f
C3485 programmable_telescopic_cascode_0.EN0.t18 VSS 0.03475f
C3486 programmable_telescopic_cascode_0.EN0.n12 VSS 0.03595f
C3487 programmable_telescopic_cascode_0.EN0.n13 VSS 1.2617f
C3488 programmable_telescopic_cascode_0.EN0.t4 VSS 0.03475f
C3489 programmable_telescopic_cascode_0.EN0.n14 VSS 0.03597f
C3490 programmable_telescopic_cascode_0.EN0.n15 VSS 1.34122f
C3491 programmable_telescopic_cascode_0.EN0.t6 VSS 0.03475f
C3492 programmable_telescopic_cascode_0.EN0.n16 VSS 0.0362f
C3493 programmable_telescopic_cascode_0.EN0.n17 VSS 1.03273f
C3494 programmable_telescopic_cascode_0.EN0.t14 VSS 0.03475f
C3495 programmable_telescopic_cascode_0.EN0.n18 VSS 0.03623f
C3496 programmable_telescopic_cascode_0.EN0.n19 VSS 1.40762f
C3497 programmable_telescopic_cascode_0.EN0.n20 VSS 0.52759f
C3498 programmable_common_source_0.EN0.t3 VSS 0.07881f
C3499 programmable_common_source_0.EN0.t6 VSS 0.03223f
C3500 programmable_common_source_0.EN0.n0 VSS 0.05642f
C3501 programmable_common_source_0.EN0.t5 VSS 0.03223f
C3502 programmable_common_source_0.EN0.n1 VSS 0.03761f
C3503 programmable_common_source_0.EN0.n2 VSS 8.84445f
C3504 programmable_common_source_0.EN0.t7 VSS 0.03244f
C3505 programmable_common_source_0.EN0.t4 VSS 0.03093f
C3506 programmable_common_source_0.EN0.n3 VSS 0.31218f
C3507 programmable_common_source_0.EN0.n4 VSS 8.42451f
C3508 programmable_common_source_0.EN0.t2 VSS 0.08099f
C3509 programmable_common_source_0.EN0.t1 VSS 0.07759f
C3510 programmable_common_source_0.EN0.n5 VSS 0.14786f
C3511 programmable_common_source_0.EN0.t0 VSS 0.0786f
C3512 programmable_common_source_0.EN0.n6 VSS 0.15993f
C3513 programmable_5tOTA_0.programmable_nfet$8_0.transmission_gate$29_1.out.t0 VSS 0.01168f
C3514 programmable_5tOTA_0.programmable_nfet$8_0.transmission_gate$29_1.out.t5 VSS 0.5324f
C3515 programmable_5tOTA_0.programmable_nfet$8_0.transmission_gate$29_1.out.t7 VSS 0.54896f
C3516 programmable_5tOTA_0.programmable_nfet$8_0.transmission_gate$29_1.out.t6 VSS 0.43064f
C3517 programmable_5tOTA_0.programmable_nfet$8_0.transmission_gate$29_1.out.n0 VSS 0.16557f
C3518 programmable_5tOTA_0.programmable_nfet$8_0.transmission_gate$29_1.out.t8 VSS 0.5324f
C3519 programmable_5tOTA_0.programmable_nfet$8_0.transmission_gate$29_1.out.t4 VSS 0.54896f
C3520 programmable_5tOTA_0.programmable_nfet$8_0.transmission_gate$29_1.out.t3 VSS 0.43057f
C3521 programmable_5tOTA_0.programmable_nfet$8_0.transmission_gate$29_1.out.n1 VSS 0.14779f
C3522 programmable_5tOTA_0.programmable_nfet$8_0.transmission_gate$29_1.out.t2 VSS 0.0039f
C3523 programmable_5tOTA_0.programmable_nfet$8_0.transmission_gate$29_1.out.n2 VSS 0.02546f
C3524 programmable_5tOTA_0.programmable_nfet$8_0.transmission_gate$29_1.out.t1 VSS 0.00417f
C3525 programmable_telescopic_cascode_0.programmable_pfet$3_0.transmission_gate$23_1.out.t2 VSS 0.01261f
C3526 programmable_telescopic_cascode_0.programmable_pfet$3_0.transmission_gate$23_1.out.t0 VSS 0.01223f
C3527 programmable_telescopic_cascode_0.programmable_pfet$3_0.transmission_gate$23_1.out.t3 VSS 1.41355f
C3528 programmable_telescopic_cascode_0.programmable_pfet$3_0.transmission_gate$23_1.out.t8 VSS 1.4433f
C3529 programmable_telescopic_cascode_0.programmable_pfet$3_0.transmission_gate$23_1.out.t4 VSS 1.4433f
C3530 programmable_telescopic_cascode_0.programmable_pfet$3_0.transmission_gate$23_1.out.t6 VSS 1.4433f
C3531 programmable_telescopic_cascode_0.programmable_pfet$3_0.transmission_gate$23_1.out.t7 VSS 1.4433f
C3532 programmable_telescopic_cascode_0.programmable_pfet$3_0.transmission_gate$23_1.out.t5 VSS 1.09142f
C3533 programmable_telescopic_cascode_0.programmable_pfet$3_0.transmission_gate$23_1.out.t1 VSS 0.07808f
C3534 programmable_telescopic_cascode_0.programmable_pfet$3_0.transmission_gate$23_1.out.n0 VSS 0.60779f
C3535 programmable_telescopic_cascode_0.programmable_pfet$3_0.transmission_gate$23_1.out.n1 VSS 0.07095f
C3536 programmable_5tOTA_0.programmable_nfet$8_0.transmission_gate$29_0.out.t0 VSS 0.01542f
C3537 programmable_5tOTA_0.programmable_nfet$8_0.transmission_gate$29_0.out.t3 VSS 0.63488f
C3538 programmable_5tOTA_0.programmable_nfet$8_0.transmission_gate$29_0.out.t5 VSS 0.65463f
C3539 programmable_5tOTA_0.programmable_nfet$8_0.transmission_gate$29_0.out.t4 VSS 0.51345f
C3540 programmable_5tOTA_0.programmable_nfet$8_0.transmission_gate$29_0.out.n0 VSS 0.22079f
C3541 programmable_5tOTA_0.programmable_nfet$8_0.transmission_gate$29_0.out.t1 VSS 0.00465f
C3542 programmable_5tOTA_0.programmable_nfet$8_0.transmission_gate$29_0.out.n1 VSS 0.03034f
C3543 programmable_5tOTA_0.programmable_nfet$8_0.transmission_gate$29_0.out.t2 VSS 0.00497f
C3544 a_55661_23626.t19 VSS 2.25352f
C3545 a_55661_23626.t18 VSS 0.96827f
C3546 a_55661_23626.n0 VSS 1.28968f
C3547 a_55661_23626.t7 VSS 2.25277f
C3548 a_55661_23626.t8 VSS 0.96827f
C3549 a_55661_23626.n1 VSS 1.28961f
C3550 a_55661_23626.n2 VSS 0.35237f
C3551 a_55661_23626.t1 VSS 2.25331f
C3552 a_55661_23626.t2 VSS 0.96827f
C3553 a_55661_23626.n3 VSS 1.25657f
C3554 a_55661_23626.n4 VSS 0.31575f
C3555 a_55661_23626.t17 VSS 1.73449f
C3556 a_55661_23626.t6 VSS 0.19771f
C3557 a_55661_23626.t11 VSS 0.19771f
C3558 a_55661_23626.n5 VSS 1.2419f
C3559 a_55661_23626.t10 VSS 0.19771f
C3560 a_55661_23626.t9 VSS 0.19771f
C3561 a_55661_23626.n6 VSS 0.39541f
C3562 a_55661_23626.n7 VSS 0.87546f
C3563 a_55661_23626.t12 VSS 1.58004f
C3564 a_55661_23626.t13 VSS 0.64304f
C3565 a_55661_23626.n8 VSS 1.00926f
C3566 a_55661_23626.n9 VSS 0.28402f
C3567 a_55661_23626.t16 VSS 0.64304f
C3568 a_55661_23626.n10 VSS 0.80937f
C3569 a_55661_23626.n11 VSS 0.89067f
C3570 a_55661_23626.t14 VSS 2.25352f
C3571 a_55661_23626.t15 VSS 0.96827f
C3572 a_55661_23626.n12 VSS 1.28968f
C3573 a_55661_23626.t5 VSS 2.25277f
C3574 a_55661_23626.t4 VSS 0.96827f
C3575 a_55661_23626.n13 VSS 1.28961f
C3576 a_55661_23626.n14 VSS 0.35237f
C3577 a_55661_23626.t20 VSS 2.25331f
C3578 a_55661_23626.t23 VSS 0.96827f
C3579 a_55661_23626.n15 VSS 1.25657f
C3580 a_55661_23626.n16 VSS 0.27685f
C3581 a_55661_23626.t22 VSS 2.37915f
C3582 a_55661_23626.t21 VSS 0.96827f
C3583 a_55661_23626.n17 VSS 1.06836f
C3584 a_55661_23626.n18 VSS 0.91993f
C3585 a_55661_23626.n19 VSS 1.31651f
C3586 a_55661_23626.n20 VSS 0.39583f
C3587 a_55661_23626.t0 VSS 0.96827f
C3588 a_55661_23626.n21 VSS 1.00914f
C3589 a_55661_23626.t3 VSS 2.37915f
C3590 programmable_folded_cascode_0.programmable_pfet$1_1.transmission_gate$17_1.out.t0 VSS 0.0121f
C3591 programmable_folded_cascode_0.programmable_pfet$1_1.transmission_gate$17_1.out.t1 VSS 0.01174f
C3592 programmable_folded_cascode_0.programmable_pfet$1_1.transmission_gate$17_1.out.t2 VSS 0.01669f
C3593 programmable_folded_cascode_0.programmable_pfet$1_1.transmission_gate$17_1.out.t12 VSS 1.0059f
C3594 programmable_folded_cascode_0.programmable_pfet$1_1.transmission_gate$17_1.out.t10 VSS 1.03447f
C3595 programmable_folded_cascode_0.programmable_pfet$1_1.transmission_gate$17_1.out.t9 VSS 1.03455f
C3596 programmable_folded_cascode_0.programmable_pfet$1_1.transmission_gate$17_1.out.t3 VSS 1.03454f
C3597 programmable_folded_cascode_0.programmable_pfet$1_1.transmission_gate$17_1.out.t11 VSS 0.78524f
C3598 programmable_folded_cascode_0.programmable_pfet$1_1.transmission_gate$17_1.out.n0 VSS 0.49216f
C3599 programmable_folded_cascode_0.programmable_pfet$1_1.transmission_gate$17_1.out.t5 VSS 1.0059f
C3600 programmable_folded_cascode_0.programmable_pfet$1_1.transmission_gate$17_1.out.t7 VSS 1.03447f
C3601 programmable_folded_cascode_0.programmable_pfet$1_1.transmission_gate$17_1.out.t4 VSS 1.03454f
C3602 programmable_folded_cascode_0.programmable_pfet$1_1.transmission_gate$17_1.out.t8 VSS 1.03454f
C3603 programmable_folded_cascode_0.programmable_pfet$1_1.transmission_gate$17_1.out.t6 VSS 0.78478f
C3604 programmable_folded_cascode_0.programmable_pfet$1_1.transmission_gate$17_1.out.n1 VSS 0.46712f
C3605 programmable_folded_cascode_0.programmable_pfet$1_1.transmission_gate$17_1.out.n2 VSS 0.07274f
C3606 programmable_folded_cascode_0.programmable_nfet$2_0.g.t0 VSS 0.00401f
C3607 programmable_folded_cascode_0.programmable_nfet$2_0.g.t6 VSS 0.00401f
C3608 programmable_folded_cascode_0.programmable_nfet$2_0.g.t8 VSS 0.00392f
C3609 programmable_folded_cascode_0.programmable_nfet$2_0.g.n0 VSS 0.01346f
C3610 programmable_folded_cascode_0.programmable_nfet$2_0.g.t7 VSS 0.00392f
C3611 programmable_folded_cascode_0.programmable_nfet$2_0.g.t5 VSS 0.00401f
C3612 programmable_folded_cascode_0.programmable_nfet$2_0.g.n1 VSS 0.01347f
C3613 programmable_folded_cascode_0.programmable_nfet$2_0.g.t4 VSS 0.00392f
C3614 programmable_folded_cascode_0.programmable_nfet$2_0.g.t1 VSS 0.00401f
C3615 programmable_folded_cascode_0.programmable_nfet$2_0.g.n2 VSS 0.01352f
C3616 programmable_folded_cascode_0.programmable_nfet$2_0.g.t17 VSS 0.36385f
C3617 programmable_folded_cascode_0.programmable_nfet$2_0.g.n3 VSS 0.15103f
C3618 programmable_folded_cascode_0.programmable_nfet$2_0.g.n4 VSS 0.09005f
C3619 programmable_folded_cascode_0.programmable_nfet$2_0.g.n5 VSS 0.09f
C3620 programmable_folded_cascode_0.programmable_nfet$2_0.g.t11 VSS 0.35529f
C3621 programmable_folded_cascode_0.programmable_nfet$2_0.g.t12 VSS 0.36783f
C3622 programmable_folded_cascode_0.programmable_nfet$2_0.g.t10 VSS 0.05982f
C3623 programmable_folded_cascode_0.programmable_nfet$2_0.g.t9 VSS 0.05982f
C3624 programmable_folded_cascode_0.programmable_nfet$2_0.g.n6 VSS 0.27745f
C3625 programmable_folded_cascode_0.programmable_nfet$2_0.g.t13 VSS 0.35028f
C3626 programmable_folded_cascode_0.programmable_nfet$2_0.g.t14 VSS 0.21795f
C3627 programmable_folded_cascode_0.programmable_nfet$2_0.g.t2 VSS 0.21495f
C3628 programmable_folded_cascode_0.programmable_nfet$2_0.g.n7 VSS 0.06732f
C3629 programmable_folded_cascode_0.programmable_nfet$2_0.g.t15 VSS 0.21494f
C3630 programmable_folded_cascode_0.programmable_nfet$2_0.g.n8 VSS 0.05164f
C3631 programmable_folded_cascode_0.programmable_nfet$2_0.g.t16 VSS 0.10082f
C3632 programmable_folded_cascode_0.programmable_nfet$2_0.g.n9 VSS 0.15733f
C3633 programmable_folded_cascode_0.programmable_nfet$2_0.g.n10 VSS 0.13179f
C3634 programmable_folded_cascode_0.programmable_nfet$2_0.g.n11 VSS 0.07182f
C3635 programmable_folded_cascode_0.programmable_nfet$2_0.g.n12 VSS 0.09546f
C3636 programmable_folded_cascode_0.programmable_nfet$2_0.g.n13 VSS 0.15304f
C3637 programmable_folded_cascode_0.programmable_nfet$2_0.g.n14 VSS 0.01392f
C3638 programmable_folded_cascode_0.programmable_nfet$2_0.g.n15 VSS 0.01352f
C3639 programmable_folded_cascode_0.programmable_nfet$2_0.g.t3 VSS 0.00392f
C3640 programmable_5tOTA_0.programmable_pfet$4_0.transmission_gate$27_0.out.t1 VSS 0.01246f
C3641 programmable_5tOTA_0.programmable_pfet$4_0.transmission_gate$27_0.out.t3 VSS 1.79786f
C3642 programmable_5tOTA_0.programmable_pfet$4_0.transmission_gate$27_0.out.t4 VSS 1.39907f
C3643 programmable_5tOTA_0.programmable_pfet$4_0.transmission_gate$27_0.out.t5 VSS 1.79786f
C3644 programmable_5tOTA_0.programmable_pfet$4_0.transmission_gate$27_0.out.t6 VSS 1.39308f
C3645 programmable_5tOTA_0.programmable_pfet$4_0.transmission_gate$27_0.out.t2 VSS 0.01772f
C3646 programmable_5tOTA_0.programmable_pfet$4_0.transmission_gate$27_0.out.n0 VSS 0.69224f
C3647 programmable_5tOTA_0.programmable_pfet$4_0.transmission_gate$27_0.out.n1 VSS 0.72127f
C3648 programmable_5tOTA_0.programmable_pfet$4_0.transmission_gate$27_0.out.n2 VSS 0.11469f
C3649 programmable_5tOTA_0.programmable_pfet$4_0.transmission_gate$27_0.out.t0 VSS 0.01285f
C3650 programmable_folded_cascode_0.programmable_pfet_1.transmission_gate$16_0.out.t0 VSS 0.00956f
C3651 programmable_folded_cascode_0.programmable_pfet_1.transmission_gate$16_0.out.t1 VSS 0.00926f
C3652 programmable_folded_cascode_0.programmable_pfet_1.transmission_gate$16_0.out.t2 VSS 0.05801f
C3653 programmable_folded_cascode_0.programmable_pfet_1.transmission_gate$16_0.out.t8 VSS 1.87091f
C3654 programmable_folded_cascode_0.programmable_pfet_1.transmission_gate$16_0.out.t9 VSS 1.91985f
C3655 programmable_folded_cascode_0.programmable_pfet_1.transmission_gate$16_0.out.t10 VSS 1.91998f
C3656 programmable_folded_cascode_0.programmable_pfet_1.transmission_gate$16_0.out.t3 VSS 1.91998f
C3657 programmable_folded_cascode_0.programmable_pfet_1.transmission_gate$16_0.out.t11 VSS 1.91985f
C3658 programmable_folded_cascode_0.programmable_pfet_1.transmission_gate$16_0.out.t6 VSS 1.91985f
C3659 programmable_folded_cascode_0.programmable_pfet_1.transmission_gate$16_0.out.t7 VSS 1.91985f
C3660 programmable_folded_cascode_0.programmable_pfet_1.transmission_gate$16_0.out.t4 VSS 1.91985f
C3661 programmable_folded_cascode_0.programmable_pfet_1.transmission_gate$16_0.out.t12 VSS 1.91985f
C3662 programmable_folded_cascode_0.programmable_pfet_1.transmission_gate$16_0.out.t5 VSS 1.46462f
C3663 programmable_folded_cascode_0.programmable_pfet_1.transmission_gate$16_0.out.n0 VSS 0.63768f
C3664 programmable_folded_cascode_0.programmable_pfet_1.transmission_gate$16_0.out.n1 VSS 0.06012f
C3665 programmable_folded_cascode_0.EN0.t8 VSS 0.02088f
C3666 programmable_folded_cascode_0.EN0.t21 VSS 0.0199f
C3667 programmable_folded_cascode_0.EN0.n0 VSS 0.20171f
C3668 programmable_folded_cascode_0.EN0.t0 VSS 0.05211f
C3669 programmable_folded_cascode_0.EN0.t1 VSS 0.04992f
C3670 programmable_folded_cascode_0.EN0.n1 VSS 0.09513f
C3671 programmable_folded_cascode_0.EN0.t2 VSS 0.05057f
C3672 programmable_folded_cascode_0.EN0.n2 VSS 0.10235f
C3673 programmable_folded_cascode_0.EN0.t3 VSS 0.02074f
C3674 programmable_folded_cascode_0.EN0.n3 VSS 0.05096f
C3675 programmable_folded_cascode_0.EN0.t9 VSS 0.02074f
C3676 programmable_folded_cascode_0.EN0.t14 VSS 0.04952f
C3677 programmable_folded_cascode_0.EN0.n4 VSS 0.72726f
C3678 programmable_folded_cascode_0.EN0.t13 VSS 0.04952f
C3679 programmable_folded_cascode_0.EN0.t19 VSS 0.02074f
C3680 programmable_folded_cascode_0.EN0.n5 VSS 0.03648f
C3681 programmable_folded_cascode_0.EN0.t15 VSS 0.02074f
C3682 programmable_folded_cascode_0.EN0.t16 VSS 0.04952f
C3683 programmable_folded_cascode_0.EN0.n6 VSS 0.03648f
C3684 programmable_folded_cascode_0.EN0.n7 VSS 0.47037f
C3685 programmable_folded_cascode_0.EN0.n8 VSS 0.80427f
C3686 programmable_folded_cascode_0.EN0.t5 VSS 0.04952f
C3687 programmable_folded_cascode_0.EN0.t7 VSS 0.02074f
C3688 programmable_folded_cascode_0.EN0.n9 VSS 0.03648f
C3689 programmable_folded_cascode_0.EN0.t4 VSS 0.02074f
C3690 programmable_folded_cascode_0.EN0.t17 VSS 0.04952f
C3691 programmable_folded_cascode_0.EN0.n10 VSS 0.03648f
C3692 programmable_folded_cascode_0.EN0.n11 VSS 0.47037f
C3693 programmable_folded_cascode_0.EN0.n12 VSS 0.79119f
C3694 programmable_folded_cascode_0.EN0.t6 VSS 0.04952f
C3695 programmable_folded_cascode_0.EN0.t11 VSS 0.02074f
C3696 programmable_folded_cascode_0.EN0.n13 VSS 0.03648f
C3697 programmable_folded_cascode_0.EN0.t10 VSS 0.02074f
C3698 programmable_folded_cascode_0.EN0.t20 VSS 0.04952f
C3699 programmable_folded_cascode_0.EN0.n14 VSS 0.03648f
C3700 programmable_folded_cascode_0.EN0.n15 VSS 0.47037f
C3701 programmable_folded_cascode_0.EN0.n16 VSS 0.84784f
C3702 programmable_folded_cascode_0.EN0.t22 VSS 0.02074f
C3703 programmable_folded_cascode_0.EN0.n17 VSS 0.02415f
C3704 programmable_folded_cascode_0.EN0.t18 VSS 0.02074f
C3705 programmable_folded_cascode_0.EN0.n18 VSS 0.02415f
C3706 programmable_folded_cascode_0.EN0.n19 VSS 0.46516f
C3707 programmable_folded_cascode_0.EN0.n20 VSS 0.94715f
C3708 programmable_folded_cascode_0.EN0.t12 VSS 0.02074f
C3709 programmable_folded_cascode_0.EN0.n21 VSS 5.25445f
C3710 programmable_folded_cascode_0.EN0.n22 VSS 13.3194f
C3711 programmable_folded_cascode_0.EN0.n23 VSS 21.2598f
C3712 programmable_folded_cascode_0.EN0.n24 VSS 11.9833f
C3713 IBIAS.t4 VSS 0.49533f
C3714 IBIAS.t5 VSS 0.26282f
C3715 IBIAS.n0 VSS 0.39702f
C3716 IBIAS.t11 VSS 0.00401f
C3717 IBIAS.t13 VSS 0.0041f
C3718 IBIAS.n1 VSS 0.01382f
C3719 IBIAS.t17 VSS 0.52574f
C3720 IBIAS.t14 VSS 0.54209f
C3721 IBIAS.t21 VSS 0.42055f
C3722 IBIAS.n2 VSS 0.25497f
C3723 IBIAS.t9 VSS 0.00401f
C3724 IBIAS.t7 VSS 0.0041f
C3725 IBIAS.n3 VSS 0.0139f
C3726 IBIAS.n4 VSS 0.9992f
C3727 IBIAS.t2 VSS 0.00401f
C3728 IBIAS.t1 VSS 0.0041f
C3729 IBIAS.n5 VSS 0.01374f
C3730 IBIAS.t3 VSS 0.00401f
C3731 IBIAS.t6 VSS 0.0041f
C3732 IBIAS.n6 VSS 0.0139f
C3733 IBIAS.n7 VSS 0.004f
C3734 IBIAS.t16 VSS 0.47695f
C3735 IBIAS.n8 VSS 0.58909f
C3736 IBIAS.n9 VSS 1.62847f
C3737 IBIAS.n10 VSS 0.21468f
C3738 IBIAS.t22 VSS 0.26249f
C3739 IBIAS.t8 VSS 0.00412f
C3740 IBIAS.t12 VSS 0.004f
C3741 IBIAS.n11 VSS 0.01355f
C3742 IBIAS.t10 VSS 0.00412f
C3743 IBIAS.t0 VSS 0.004f
C3744 IBIAS.n12 VSS 0.01354f
C3745 IBIAS.n13 VSS 0.01541f
C3746 IBIAS.t15 VSS 0.6244f
C3747 IBIAS.t18 VSS 0.49356f
C3748 IBIAS.n14 VSS 0.20284f
C3749 IBIAS.n15 VSS 1.25489f
C3750 IBIAS.n16 VSS 0.01116f
C3751 IBIAS.n17 VSS 0.01108f
C3752 IBIAS.n18 VSS 0.01076f
C3753 IBIAS.n19 VSS 0.01076f
C3754 IBIAS.n20 VSS 0.01076f
C3755 IBIAS.n21 VSS 0.01076f
C3756 IBIAS.n22 VSS 0.15455f
C3757 IBIAS.n23 VSS 0.01241f
C3758 IBIAS.n24 VSS 0.03262f
C3759 IBIAS.n25 VSS 0
C3760 IBIAS.n26 VSS 0
C3761 IBIAS.n27 VSS 0.03511f
C3762 IBIAS.n28 VSS 0.02331f
C3763 IBIAS.n29 VSS 0.21046f
C3764 IBIAS.n30 VSS 0.76237f
C3765 IBIAS.n31 VSS 6.35614f
C3766 IBIAS.t20 VSS 0.48402f
C3767 IBIAS.n32 VSS 5.84004f
C3768 IBIAS.t19 VSS 0.47695f
C3769 IBIAS.n33 VSS 0.16106f
C3770 programmable_telescopic_cascode_0.programmable_nfet$4_0.s.t26 VSS 0.31806f
C3771 programmable_telescopic_cascode_0.programmable_nfet$4_0.s.t27 VSS 0.31806f
C3772 programmable_telescopic_cascode_0.programmable_nfet$4_0.s.n0 VSS 1.23871f
C3773 programmable_telescopic_cascode_0.programmable_nfet$4_0.s.t15 VSS 2.79085f
C3774 programmable_telescopic_cascode_0.programmable_nfet$4_0.s.t21 VSS 3.61985f
C3775 programmable_telescopic_cascode_0.programmable_nfet$4_0.s.t23 VSS 1.54978f
C3776 programmable_telescopic_cascode_0.programmable_nfet$4_0.s.n1 VSS 2.22933f
C3777 programmable_telescopic_cascode_0.programmable_nfet$4_0.s.t17 VSS 1.54978f
C3778 programmable_telescopic_cascode_0.programmable_nfet$4_0.s.n2 VSS 2.20477f
C3779 programmable_telescopic_cascode_0.programmable_nfet$4_0.s.t25 VSS 1.54978f
C3780 programmable_telescopic_cascode_0.programmable_nfet$4_0.s.n3 VSS 2.20477f
C3781 programmable_telescopic_cascode_0.programmable_nfet$4_0.s.t19 VSS 1.54978f
C3782 programmable_telescopic_cascode_0.programmable_nfet$4_0.s.n4 VSS 2.01224f
C3783 programmable_telescopic_cascode_0.programmable_nfet$4_0.s.t5 VSS 3.05283f
C3784 programmable_telescopic_cascode_0.programmable_nfet$4_0.s.t2 VSS 3.6201f
C3785 programmable_telescopic_cascode_0.programmable_nfet$4_0.s.t7 VSS 1.54978f
C3786 programmable_telescopic_cascode_0.programmable_nfet$4_0.s.n5 VSS 2.21084f
C3787 programmable_telescopic_cascode_0.programmable_nfet$4_0.s.t4 VSS 1.54978f
C3788 programmable_telescopic_cascode_0.programmable_nfet$4_0.s.n6 VSS 2.18653f
C3789 programmable_telescopic_cascode_0.programmable_nfet$4_0.s.t6 VSS 1.54978f
C3790 programmable_telescopic_cascode_0.programmable_nfet$4_0.s.n7 VSS 2.18653f
C3791 programmable_telescopic_cascode_0.programmable_nfet$4_0.s.t3 VSS 1.54978f
C3792 programmable_telescopic_cascode_0.programmable_nfet$4_0.s.n8 VSS 1.9953f
C3793 programmable_telescopic_cascode_0.programmable_nfet$4_0.s.n9 VSS 0.78666f
C3794 programmable_telescopic_cascode_0.programmable_nfet$4_0.s.t10 VSS 3.05313f
C3795 programmable_telescopic_cascode_0.programmable_nfet$4_0.s.t13 VSS 3.6201f
C3796 programmable_telescopic_cascode_0.programmable_nfet$4_0.s.t8 VSS 1.54978f
C3797 programmable_telescopic_cascode_0.programmable_nfet$4_0.s.n10 VSS 2.21084f
C3798 programmable_telescopic_cascode_0.programmable_nfet$4_0.s.t11 VSS 1.54978f
C3799 programmable_telescopic_cascode_0.programmable_nfet$4_0.s.n11 VSS 2.18653f
C3800 programmable_telescopic_cascode_0.programmable_nfet$4_0.s.t9 VSS 1.54978f
C3801 programmable_telescopic_cascode_0.programmable_nfet$4_0.s.n12 VSS 2.18653f
C3802 programmable_telescopic_cascode_0.programmable_nfet$4_0.s.t12 VSS 1.54978f
C3803 programmable_telescopic_cascode_0.programmable_nfet$4_0.s.n13 VSS 1.99506f
C3804 programmable_telescopic_cascode_0.programmable_nfet$4_0.s.n14 VSS 0.78276f
C3805 programmable_telescopic_cascode_0.programmable_nfet$4_0.s.n15 VSS 0.0322f
C3806 programmable_telescopic_cascode_0.programmable_nfet$4_0.s.t14 VSS 3.05313f
C3807 programmable_telescopic_cascode_0.programmable_nfet$4_0.s.t20 VSS 3.61777f
C3808 programmable_telescopic_cascode_0.programmable_nfet$4_0.s.t22 VSS 1.54978f
C3809 programmable_telescopic_cascode_0.programmable_nfet$4_0.s.n16 VSS 2.30068f
C3810 programmable_telescopic_cascode_0.programmable_nfet$4_0.s.t16 VSS 1.54978f
C3811 programmable_telescopic_cascode_0.programmable_nfet$4_0.s.n17 VSS 2.27527f
C3812 programmable_telescopic_cascode_0.programmable_nfet$4_0.s.t24 VSS 1.54978f
C3813 programmable_telescopic_cascode_0.programmable_nfet$4_0.s.n18 VSS 2.27527f
C3814 programmable_telescopic_cascode_0.programmable_nfet$4_0.s.t18 VSS 1.54978f
C3815 programmable_telescopic_cascode_0.programmable_nfet$4_0.s.n19 VSS 2.07789f
C3816 programmable_telescopic_cascode_0.programmable_nfet$4_0.s.n20 VSS 0.78742f
C3817 programmable_telescopic_cascode_0.programmable_nfet$4_0.s.n21 VSS 0.09316f
C3818 programmable_telescopic_cascode_0.programmable_nfet$4_0.s.n22 VSS 0.67178f
C3819 programmable_telescopic_cascode_0.programmable_nfet$4_0.s.n23 VSS 0.74021f
C3820 programmable_telescopic_cascode_0.programmable_nfet$4_0.s.n24 VSS 0.67059f
C3821 programmable_telescopic_cascode_0.programmable_nfet$4_0.s.t0 VSS 2.28843f
C3822 programmable_telescopic_cascode_0.programmable_nfet$4_0.s.t1 VSS 2.2743f
C3823 programmable_telescopic_cascode_0.programmable_nfet$4_0.s.n25 VSS 0.3461f
C3824 programmable_telescopic_cascode_0.programmable_nfet$4_0.transmission_gate$24_0.out.t1 VSS 0.01019f
C3825 programmable_telescopic_cascode_0.programmable_nfet$4_0.transmission_gate$24_0.out.t0 VSS 0.02814f
C3826 programmable_telescopic_cascode_0.programmable_nfet$4_0.transmission_gate$24_0.out.t7 VSS 1.02183f
C3827 programmable_telescopic_cascode_0.programmable_nfet$4_0.transmission_gate$24_0.out.t5 VSS 1.03556f
C3828 programmable_telescopic_cascode_0.programmable_nfet$4_0.transmission_gate$24_0.out.t11 VSS 1.03556f
C3829 programmable_telescopic_cascode_0.programmable_nfet$4_0.transmission_gate$24_0.out.t3 VSS 1.03556f
C3830 programmable_telescopic_cascode_0.programmable_nfet$4_0.transmission_gate$24_0.out.t9 VSS 1.03556f
C3831 programmable_telescopic_cascode_0.programmable_nfet$4_0.transmission_gate$24_0.out.t13 VSS 0.78641f
C3832 programmable_telescopic_cascode_0.programmable_nfet$4_0.transmission_gate$24_0.out.n0 VSS 0.35962f
C3833 programmable_telescopic_cascode_0.programmable_nfet$4_0.transmission_gate$24_0.out.t8 VSS 1.02183f
C3834 programmable_telescopic_cascode_0.programmable_nfet$4_0.transmission_gate$24_0.out.t6 VSS 1.03556f
C3835 programmable_telescopic_cascode_0.programmable_nfet$4_0.transmission_gate$24_0.out.t12 VSS 1.03556f
C3836 programmable_telescopic_cascode_0.programmable_nfet$4_0.transmission_gate$24_0.out.t4 VSS 1.03556f
C3837 programmable_telescopic_cascode_0.programmable_nfet$4_0.transmission_gate$24_0.out.t10 VSS 1.03556f
C3838 programmable_telescopic_cascode_0.programmable_nfet$4_0.transmission_gate$24_0.out.t14 VSS 0.78642f
C3839 programmable_telescopic_cascode_0.programmable_nfet$4_0.transmission_gate$24_0.out.n1 VSS 0.29384f
C3840 programmable_telescopic_cascode_0.programmable_nfet$4_0.transmission_gate$24_0.out.t2 VSS 0.00953f
C3841 programmable_telescopic_cascode_0.programmable_nfet$4_0.transmission_gate$24_0.out.n2 VSS 0.055f
C3842 programmable_telescopic_cascode_0.programmable_pfet$3_1.d.t24 VSS 0.82726f
C3843 programmable_telescopic_cascode_0.programmable_pfet$3_1.d.t41 VSS 0.82726f
C3844 programmable_telescopic_cascode_0.programmable_pfet$3_1.d.n0 VSS 3.04246f
C3845 programmable_telescopic_cascode_0.programmable_pfet$3_1.d.t36 VSS 6.10095f
C3846 programmable_telescopic_cascode_0.programmable_pfet$3_1.d.t40 VSS 7.69046f
C3847 programmable_telescopic_cascode_0.programmable_pfet$3_1.d.t37 VSS 3.07184f
C3848 programmable_telescopic_cascode_0.programmable_pfet$3_1.d.n1 VSS 4.75945f
C3849 programmable_telescopic_cascode_0.programmable_pfet$3_1.d.t38 VSS 3.07184f
C3850 programmable_telescopic_cascode_0.programmable_pfet$3_1.d.n2 VSS 4.71307f
C3851 programmable_telescopic_cascode_0.programmable_pfet$3_1.d.t39 VSS 3.07184f
C3852 programmable_telescopic_cascode_0.programmable_pfet$3_1.d.n3 VSS 4.08858f
C3853 programmable_telescopic_cascode_0.programmable_pfet$3_1.d.t12 VSS 6.81068f
C3854 programmable_telescopic_cascode_0.programmable_pfet$3_1.d.t13 VSS 7.69046f
C3855 programmable_telescopic_cascode_0.programmable_pfet$3_1.d.t10 VSS 3.07184f
C3856 programmable_telescopic_cascode_0.programmable_pfet$3_1.d.n4 VSS 4.75945f
C3857 programmable_telescopic_cascode_0.programmable_pfet$3_1.d.t8 VSS 3.07184f
C3858 programmable_telescopic_cascode_0.programmable_pfet$3_1.d.n5 VSS 4.71307f
C3859 programmable_telescopic_cascode_0.programmable_pfet$3_1.d.t14 VSS 3.07184f
C3860 programmable_telescopic_cascode_0.programmable_pfet$3_1.d.n6 VSS 4.08888f
C3861 programmable_telescopic_cascode_0.programmable_pfet$3_1.d.n7 VSS 1.55946f
C3862 programmable_telescopic_cascode_0.programmable_pfet$3_1.d.t7 VSS 6.81085f
C3863 programmable_telescopic_cascode_0.programmable_pfet$3_1.d.t9 VSS 7.69046f
C3864 programmable_telescopic_cascode_0.programmable_pfet$3_1.d.t6 VSS 3.07184f
C3865 programmable_telescopic_cascode_0.programmable_pfet$3_1.d.n8 VSS 4.75945f
C3866 programmable_telescopic_cascode_0.programmable_pfet$3_1.d.t15 VSS 3.07184f
C3867 programmable_telescopic_cascode_0.programmable_pfet$3_1.d.n9 VSS 4.71307f
C3868 programmable_telescopic_cascode_0.programmable_pfet$3_1.d.t11 VSS 3.07184f
C3869 programmable_telescopic_cascode_0.programmable_pfet$3_1.d.n10 VSS 4.08873f
C3870 programmable_telescopic_cascode_0.programmable_pfet$3_1.d.n11 VSS 1.55033f
C3871 programmable_telescopic_cascode_0.programmable_pfet$3_1.d.n12 VSS 0.22242f
C3872 programmable_telescopic_cascode_0.programmable_pfet$3_1.d.t17 VSS 6.81051f
C3873 programmable_telescopic_cascode_0.programmable_pfet$3_1.d.t20 VSS 7.69046f
C3874 programmable_telescopic_cascode_0.programmable_pfet$3_1.d.t18 VSS 3.07184f
C3875 programmable_telescopic_cascode_0.programmable_pfet$3_1.d.n13 VSS 4.75945f
C3876 programmable_telescopic_cascode_0.programmable_pfet$3_1.d.t16 VSS 3.07184f
C3877 programmable_telescopic_cascode_0.programmable_pfet$3_1.d.n14 VSS 4.71307f
C3878 programmable_telescopic_cascode_0.programmable_pfet$3_1.d.t19 VSS 3.07184f
C3879 programmable_telescopic_cascode_0.programmable_pfet$3_1.d.n15 VSS 4.08903f
C3880 programmable_telescopic_cascode_0.programmable_pfet$3_1.d.n16 VSS 1.55036f
C3881 programmable_telescopic_cascode_0.programmable_pfet$3_1.d.n17 VSS 0.14615f
C3882 programmable_telescopic_cascode_0.programmable_pfet$3_1.d.n18 VSS 1.32596f
C3883 programmable_telescopic_cascode_0.programmable_pfet$3_1.d.n19 VSS 1.6252f
C3884 programmable_telescopic_cascode_0.programmable_pfet$3_1.d.n20 VSS 1.07911f
C3885 programmable_telescopic_cascode_0.programmable_pfet$3_1.d.t42 VSS 0.82726f
C3886 programmable_telescopic_cascode_0.programmable_pfet$3_1.d.t22 VSS 0.82726f
C3887 programmable_telescopic_cascode_0.programmable_pfet$3_1.d.n21 VSS 3.75044f
C3888 programmable_telescopic_cascode_0.programmable_pfet$3_1.d.t21 VSS 0.82726f
C3889 programmable_telescopic_cascode_0.programmable_pfet$3_1.d.t29 VSS 0.82726f
C3890 programmable_telescopic_cascode_0.programmable_pfet$3_1.d.n22 VSS 3.73f
C3891 programmable_telescopic_cascode_0.programmable_pfet$3_1.d.n23 VSS 3.20016f
C3892 programmable_telescopic_cascode_0.programmable_pfet$3_1.d.t27 VSS 0.82726f
C3893 programmable_telescopic_cascode_0.programmable_pfet$3_1.d.t23 VSS 0.82726f
C3894 programmable_telescopic_cascode_0.programmable_pfet$3_1.d.n24 VSS 3.73004f
C3895 programmable_telescopic_cascode_0.programmable_pfet$3_1.d.n25 VSS 4.0099f
C3896 programmable_telescopic_cascode_0.programmable_pfet$3_1.d.t25 VSS 0.82726f
C3897 programmable_telescopic_cascode_0.programmable_pfet$3_1.d.t43 VSS 0.82726f
C3898 programmable_telescopic_cascode_0.programmable_pfet$3_1.d.n26 VSS 3.72996f
C3899 programmable_telescopic_cascode_0.programmable_pfet$3_1.d.n27 VSS 2.82312f
C3900 programmable_telescopic_cascode_0.programmable_pfet$3_1.d.t26 VSS 0.82726f
C3901 programmable_telescopic_cascode_0.programmable_pfet$3_1.d.t28 VSS 0.82726f
C3902 programmable_telescopic_cascode_0.programmable_pfet$3_1.d.n28 VSS 3.73004f
C3903 programmable_telescopic_cascode_0.programmable_pfet$3_1.d.n29 VSS 1.78124f
C3904 programmable_telescopic_cascode_0.programmable_pfet$3_1.d.n30 VSS 0.55576f
C3905 programmable_telescopic_cascode_0.programmable_pfet$3_1.d.t0 VSS 5.53577f
C3906 programmable_telescopic_cascode_0.programmable_pfet$3_1.d.t4 VSS 6.53149f
C3907 programmable_telescopic_cascode_0.programmable_pfet$3_1.d.t3 VSS 2.61644f
C3908 programmable_telescopic_cascode_0.programmable_pfet$3_1.d.n31 VSS 4.07553f
C3909 programmable_telescopic_cascode_0.programmable_pfet$3_1.d.t5 VSS 2.61644f
C3910 programmable_telescopic_cascode_0.programmable_pfet$3_1.d.n32 VSS 4.02144f
C3911 programmable_telescopic_cascode_0.programmable_pfet$3_1.d.t1 VSS 2.61644f
C3912 programmable_telescopic_cascode_0.programmable_pfet$3_1.d.n33 VSS 4.02144f
C3913 programmable_telescopic_cascode_0.programmable_pfet$3_1.d.t2 VSS 2.61644f
C3914 programmable_telescopic_cascode_0.programmable_pfet$3_1.d.n34 VSS 3.67489f
C3915 programmable_telescopic_cascode_0.programmable_pfet$3_1.d.n35 VSS 1.41817f
C3916 programmable_telescopic_cascode_0.programmable_pfet$3_1.d.t35 VSS 5.53557f
C3917 programmable_telescopic_cascode_0.programmable_pfet$3_1.d.t31 VSS 6.53149f
C3918 programmable_telescopic_cascode_0.programmable_pfet$3_1.d.t32 VSS 2.61644f
C3919 programmable_telescopic_cascode_0.programmable_pfet$3_1.d.n36 VSS 4.07553f
C3920 programmable_telescopic_cascode_0.programmable_pfet$3_1.d.t30 VSS 2.61644f
C3921 programmable_telescopic_cascode_0.programmable_pfet$3_1.d.n37 VSS 4.02144f
C3922 programmable_telescopic_cascode_0.programmable_pfet$3_1.d.t34 VSS 2.61644f
C3923 programmable_telescopic_cascode_0.programmable_pfet$3_1.d.n38 VSS 4.02144f
C3924 programmable_telescopic_cascode_0.programmable_pfet$3_1.d.t33 VSS 2.61644f
C3925 programmable_telescopic_cascode_0.programmable_pfet$3_1.d.n39 VSS 3.67504f
C3926 programmable_telescopic_cascode_0.programmable_pfet$3_1.d.n40 VSS 1.39641f
C3927 programmable_telescopic_cascode_0.programmable_pfet$3_1.d.n41 VSS 0.29022f
C3928 programmable_telescopic_cascode_0.programmable_pfet$2_1.transmission_gate$22_0.out.t0 VSS 0.01294f
C3929 programmable_telescopic_cascode_0.programmable_pfet$2_1.transmission_gate$22_0.out.t1 VSS 0.01255f
C3930 programmable_telescopic_cascode_0.programmable_pfet$2_1.transmission_gate$22_0.out.t5 VSS 1.70308f
C3931 programmable_telescopic_cascode_0.programmable_pfet$2_1.transmission_gate$22_0.out.t8 VSS 1.73361f
C3932 programmable_telescopic_cascode_0.programmable_pfet$2_1.transmission_gate$22_0.out.t10 VSS 1.73361f
C3933 programmable_telescopic_cascode_0.programmable_pfet$2_1.transmission_gate$22_0.out.t4 VSS 1.73361f
C3934 programmable_telescopic_cascode_0.programmable_pfet$2_1.transmission_gate$22_0.out.t6 VSS 1.3206f
C3935 programmable_telescopic_cascode_0.programmable_pfet$2_1.transmission_gate$22_0.out.t9 VSS 1.70308f
C3936 programmable_telescopic_cascode_0.programmable_pfet$2_1.transmission_gate$22_0.out.t12 VSS 1.73361f
C3937 programmable_telescopic_cascode_0.programmable_pfet$2_1.transmission_gate$22_0.out.t3 VSS 1.73361f
C3938 programmable_telescopic_cascode_0.programmable_pfet$2_1.transmission_gate$22_0.out.t7 VSS 1.73361f
C3939 programmable_telescopic_cascode_0.programmable_pfet$2_1.transmission_gate$22_0.out.t11 VSS 1.30906f
C3940 programmable_telescopic_cascode_0.programmable_pfet$2_1.transmission_gate$22_0.out.n0 VSS 0.91097f
C3941 programmable_telescopic_cascode_0.programmable_pfet$2_1.transmission_gate$22_0.out.t2 VSS 0.08037f
C3942 programmable_telescopic_cascode_0.programmable_pfet$2_1.transmission_gate$22_0.out.n1 VSS 0.23201f
C3943 programmable_telescopic_cascode_0.programmable_pfet$2_1.transmission_gate$22_0.out.n2 VSS 0.07237f
C3944 programmable_folded_cascode_0.OUT.t17 VSS 0.09148f
C3945 programmable_folded_cascode_0.OUT.t18 VSS 0.09148f
C3946 programmable_folded_cascode_0.OUT.n0 VSS 0.42185f
C3947 programmable_folded_cascode_0.OUT.t0 VSS 0.63888f
C3948 programmable_folded_cascode_0.OUT.n1 VSS 0.20244f
C3949 programmable_folded_cascode_0.OUT.t16 VSS 0.30103f
C3950 programmable_folded_cascode_0.OUT.n2 VSS 2.23421f
C3951 programmable_folded_cascode_0.OUT.t1 VSS 2.02821f
C3952 programmable_folded_cascode_0.OUT.t3 VSS 0.8162f
C3953 programmable_folded_cascode_0.OUT.n3 VSS 1.29141f
C3954 programmable_folded_cascode_0.OUT.t5 VSS 0.8162f
C3955 programmable_folded_cascode_0.OUT.n4 VSS 1.26119f
C3956 programmable_folded_cascode_0.OUT.t4 VSS 0.8162f
C3957 programmable_folded_cascode_0.OUT.n5 VSS 1.26119f
C3958 programmable_folded_cascode_0.OUT.t2 VSS 0.8162f
C3959 programmable_folded_cascode_0.OUT.n6 VSS 0.90287f
C3960 programmable_folded_cascode_0.OUT.t11 VSS 0.25789f
C3961 programmable_folded_cascode_0.OUT.t15 VSS 0.25789f
C3962 programmable_folded_cascode_0.OUT.n7 VSS 1.29096f
C3963 programmable_folded_cascode_0.OUT.t7 VSS 0.25789f
C3964 programmable_folded_cascode_0.OUT.t9 VSS 0.25789f
C3965 programmable_folded_cascode_0.OUT.n8 VSS 0.51578f
C3966 programmable_folded_cascode_0.OUT.n9 VSS 0.81231f
C3967 programmable_folded_cascode_0.OUT.t10 VSS 0.25789f
C3968 programmable_folded_cascode_0.OUT.t14 VSS 0.25789f
C3969 programmable_folded_cascode_0.OUT.n10 VSS 0.51578f
C3970 programmable_folded_cascode_0.OUT.n11 VSS 0.80834f
C3971 programmable_folded_cascode_0.OUT.t6 VSS 0.25789f
C3972 programmable_folded_cascode_0.OUT.t12 VSS 0.25789f
C3973 programmable_folded_cascode_0.OUT.n12 VSS 0.51578f
C3974 programmable_folded_cascode_0.OUT.n13 VSS 0.80832f
C3975 programmable_folded_cascode_0.OUT.t13 VSS 0.25789f
C3976 programmable_folded_cascode_0.OUT.t8 VSS 0.25789f
C3977 programmable_folded_cascode_0.OUT.n14 VSS 0.51578f
C3978 programmable_folded_cascode_0.OUT.n15 VSS 0.74947f
C3979 programmable_folded_cascode_0.OUT.t19 VSS 2.03521f
C3980 programmable_folded_cascode_0.OUT.t22 VSS 0.8162f
C3981 programmable_folded_cascode_0.OUT.n16 VSS 1.30183f
C3982 programmable_folded_cascode_0.OUT.t20 VSS 0.8162f
C3983 programmable_folded_cascode_0.OUT.n17 VSS 1.27117f
C3984 programmable_folded_cascode_0.OUT.t21 VSS 0.8162f
C3985 programmable_folded_cascode_0.OUT.n18 VSS 1.26107f
C3986 programmable_folded_cascode_0.OUT.t23 VSS 0.8162f
C3987 programmable_folded_cascode_0.OUT.n19 VSS 1.21321f
C3988 programmable_folded_cascode_0.OUT.n20 VSS 0.27413f
C3989 programmable_folded_cascode_0.OUT.n21 VSS 0.44202f
C3990 programmable_folded_cascode_0.OUT.n22 VSS 42.1404f
C3991 programmable_common_source_0.programmable_pfet$5_0.transmission_gate$30_0.out.t2 VSS 0.01555f
C3992 programmable_common_source_0.programmable_pfet$5_0.transmission_gate$30_0.out.t17 VSS 0.84974f
C3993 programmable_common_source_0.programmable_pfet$5_0.transmission_gate$30_0.out.t3 VSS 0.93194f
C3994 programmable_common_source_0.programmable_pfet$5_0.transmission_gate$30_0.out.t22 VSS 0.93194f
C3995 programmable_common_source_0.programmable_pfet$5_0.transmission_gate$30_0.out.t10 VSS 0.93194f
C3996 programmable_common_source_0.programmable_pfet$5_0.transmission_gate$30_0.out.t4 VSS 0.93194f
C3997 programmable_common_source_0.programmable_pfet$5_0.transmission_gate$30_0.out.t18 VSS 0.93194f
C3998 programmable_common_source_0.programmable_pfet$5_0.transmission_gate$30_0.out.t5 VSS 0.93194f
C3999 programmable_common_source_0.programmable_pfet$5_0.transmission_gate$30_0.out.t19 VSS 0.93194f
C4000 programmable_common_source_0.programmable_pfet$5_0.transmission_gate$30_0.out.t11 VSS 0.93194f
C4001 programmable_common_source_0.programmable_pfet$5_0.transmission_gate$30_0.out.t6 VSS 0.73677f
C4002 programmable_common_source_0.programmable_pfet$5_0.transmission_gate$30_0.out.t0 VSS 0.06319f
C4003 programmable_common_source_0.programmable_pfet$5_0.transmission_gate$30_0.out.t7 VSS 0.84974f
C4004 programmable_common_source_0.programmable_pfet$5_0.transmission_gate$30_0.out.t13 VSS 0.93194f
C4005 programmable_common_source_0.programmable_pfet$5_0.transmission_gate$30_0.out.t12 VSS 0.93194f
C4006 programmable_common_source_0.programmable_pfet$5_0.transmission_gate$30_0.out.t20 VSS 0.93194f
C4007 programmable_common_source_0.programmable_pfet$5_0.transmission_gate$30_0.out.t14 VSS 0.93194f
C4008 programmable_common_source_0.programmable_pfet$5_0.transmission_gate$30_0.out.t8 VSS 0.93194f
C4009 programmable_common_source_0.programmable_pfet$5_0.transmission_gate$30_0.out.t15 VSS 0.93194f
C4010 programmable_common_source_0.programmable_pfet$5_0.transmission_gate$30_0.out.t9 VSS 0.93194f
C4011 programmable_common_source_0.programmable_pfet$5_0.transmission_gate$30_0.out.t21 VSS 0.93194f
C4012 programmable_common_source_0.programmable_pfet$5_0.transmission_gate$30_0.out.t16 VSS 0.75615f
C4013 programmable_common_source_0.programmable_pfet$5_0.transmission_gate$30_0.out.n0 VSS 0.39893f
C4014 programmable_common_source_0.programmable_pfet$5_0.transmission_gate$30_0.out.n1 VSS 0.35477f
C4015 programmable_common_source_0.programmable_pfet$5_0.transmission_gate$30_0.out.n2 VSS 0.09699f
C4016 programmable_common_source_0.programmable_pfet$5_0.transmission_gate$30_0.out.t1 VSS 0.01603f
C4017 programmable_telescopic_cascode_0.programmable_pfet$3_0.d.t35 VSS 6.86631f
C4018 programmable_telescopic_cascode_0.programmable_pfet$3_0.d.t31 VSS 7.75327f
C4019 programmable_telescopic_cascode_0.programmable_pfet$3_0.d.t37 VSS 3.09693f
C4020 programmable_telescopic_cascode_0.programmable_pfet$3_0.d.n0 VSS 4.79833f
C4021 programmable_telescopic_cascode_0.programmable_pfet$3_0.d.t32 VSS 3.09693f
C4022 programmable_telescopic_cascode_0.programmable_pfet$3_0.d.n1 VSS 4.75156f
C4023 programmable_telescopic_cascode_0.programmable_pfet$3_0.d.t30 VSS 3.09693f
C4024 programmable_telescopic_cascode_0.programmable_pfet$3_0.d.n2 VSS 4.12228f
C4025 programmable_telescopic_cascode_0.programmable_pfet$3_0.d.n3 VSS 1.5722f
C4026 programmable_telescopic_cascode_0.programmable_pfet$3_0.d.t33 VSS 6.86648f
C4027 programmable_telescopic_cascode_0.programmable_pfet$3_0.d.t38 VSS 7.75327f
C4028 programmable_telescopic_cascode_0.programmable_pfet$3_0.d.t34 VSS 3.09693f
C4029 programmable_telescopic_cascode_0.programmable_pfet$3_0.d.n4 VSS 4.79833f
C4030 programmable_telescopic_cascode_0.programmable_pfet$3_0.d.t29 VSS 3.09693f
C4031 programmable_telescopic_cascode_0.programmable_pfet$3_0.d.n5 VSS 4.75156f
C4032 programmable_telescopic_cascode_0.programmable_pfet$3_0.d.t36 VSS 3.09693f
C4033 programmable_telescopic_cascode_0.programmable_pfet$3_0.d.n6 VSS 4.12213f
C4034 programmable_telescopic_cascode_0.programmable_pfet$3_0.d.n7 VSS 1.56299f
C4035 programmable_telescopic_cascode_0.programmable_pfet$3_0.d.n8 VSS 0.22424f
C4036 programmable_telescopic_cascode_0.programmable_pfet$3_0.d.t11 VSS 6.86614f
C4037 programmable_telescopic_cascode_0.programmable_pfet$3_0.d.t1 VSS 7.75327f
C4038 programmable_telescopic_cascode_0.programmable_pfet$3_0.d.t12 VSS 3.09693f
C4039 programmable_telescopic_cascode_0.programmable_pfet$3_0.d.n9 VSS 4.79833f
C4040 programmable_telescopic_cascode_0.programmable_pfet$3_0.d.t10 VSS 3.09693f
C4041 programmable_telescopic_cascode_0.programmable_pfet$3_0.d.n10 VSS 4.75156f
C4042 programmable_telescopic_cascode_0.programmable_pfet$3_0.d.t0 VSS 3.09693f
C4043 programmable_telescopic_cascode_0.programmable_pfet$3_0.d.n11 VSS 4.12243f
C4044 programmable_telescopic_cascode_0.programmable_pfet$3_0.d.n12 VSS 1.56303f
C4045 programmable_telescopic_cascode_0.programmable_pfet$3_0.d.n13 VSS 0.14734f
C4046 programmable_telescopic_cascode_0.programmable_pfet$3_0.d.t16 VSS 6.3356f
C4047 programmable_telescopic_cascode_0.programmable_pfet$3_0.d.t4 VSS 0.83402f
C4048 programmable_telescopic_cascode_0.programmable_pfet$3_0.d.t6 VSS 0.83402f
C4049 programmable_telescopic_cascode_0.programmable_pfet$3_0.d.n14 VSS 3.15851f
C4050 programmable_telescopic_cascode_0.programmable_pfet$3_0.d.t2 VSS 0.83402f
C4051 programmable_telescopic_cascode_0.programmable_pfet$3_0.d.t5 VSS 0.83402f
C4052 programmable_telescopic_cascode_0.programmable_pfet$3_0.d.n15 VSS 3.78108f
C4053 programmable_telescopic_cascode_0.programmable_pfet$3_0.d.t24 VSS 0.83402f
C4054 programmable_telescopic_cascode_0.programmable_pfet$3_0.d.t9 VSS 0.83402f
C4055 programmable_telescopic_cascode_0.programmable_pfet$3_0.d.n16 VSS 3.76047f
C4056 programmable_telescopic_cascode_0.programmable_pfet$3_0.d.n17 VSS 3.2263f
C4057 programmable_telescopic_cascode_0.programmable_pfet$3_0.d.t3 VSS 0.83402f
C4058 programmable_telescopic_cascode_0.programmable_pfet$3_0.d.t41 VSS 0.83402f
C4059 programmable_telescopic_cascode_0.programmable_pfet$3_0.d.n18 VSS 3.76051f
C4060 programmable_telescopic_cascode_0.programmable_pfet$3_0.d.n19 VSS 4.04265f
C4061 programmable_telescopic_cascode_0.programmable_pfet$3_0.d.t39 VSS 0.83402f
C4062 programmable_telescopic_cascode_0.programmable_pfet$3_0.d.t7 VSS 0.83402f
C4063 programmable_telescopic_cascode_0.programmable_pfet$3_0.d.n20 VSS 3.76043f
C4064 programmable_telescopic_cascode_0.programmable_pfet$3_0.d.n21 VSS 2.84618f
C4065 programmable_telescopic_cascode_0.programmable_pfet$3_0.d.t40 VSS 0.83402f
C4066 programmable_telescopic_cascode_0.programmable_pfet$3_0.d.t8 VSS 0.83402f
C4067 programmable_telescopic_cascode_0.programmable_pfet$3_0.d.n22 VSS 3.76051f
C4068 programmable_telescopic_cascode_0.programmable_pfet$3_0.d.n23 VSS 1.79579f
C4069 programmable_telescopic_cascode_0.programmable_pfet$3_0.d.t25 VSS 5.58099f
C4070 programmable_telescopic_cascode_0.programmable_pfet$3_0.d.t42 VSS 6.58484f
C4071 programmable_telescopic_cascode_0.programmable_pfet$3_0.d.t28 VSS 2.63781f
C4072 programmable_telescopic_cascode_0.programmable_pfet$3_0.d.n24 VSS 4.10882f
C4073 programmable_telescopic_cascode_0.programmable_pfet$3_0.d.t43 VSS 2.63781f
C4074 programmable_telescopic_cascode_0.programmable_pfet$3_0.d.n25 VSS 4.05428f
C4075 programmable_telescopic_cascode_0.programmable_pfet$3_0.d.t26 VSS 2.63781f
C4076 programmable_telescopic_cascode_0.programmable_pfet$3_0.d.n26 VSS 4.05428f
C4077 programmable_telescopic_cascode_0.programmable_pfet$3_0.d.t27 VSS 2.63781f
C4078 programmable_telescopic_cascode_0.programmable_pfet$3_0.d.n27 VSS 3.7049f
C4079 programmable_telescopic_cascode_0.programmable_pfet$3_0.d.n28 VSS 1.42975f
C4080 programmable_telescopic_cascode_0.programmable_pfet$3_0.d.t21 VSS 5.58078f
C4081 programmable_telescopic_cascode_0.programmable_pfet$3_0.d.t23 VSS 6.58484f
C4082 programmable_telescopic_cascode_0.programmable_pfet$3_0.d.t18 VSS 2.63781f
C4083 programmable_telescopic_cascode_0.programmable_pfet$3_0.d.n29 VSS 4.10882f
C4084 programmable_telescopic_cascode_0.programmable_pfet$3_0.d.t22 VSS 2.63781f
C4085 programmable_telescopic_cascode_0.programmable_pfet$3_0.d.n30 VSS 4.05428f
C4086 programmable_telescopic_cascode_0.programmable_pfet$3_0.d.t20 VSS 2.63781f
C4087 programmable_telescopic_cascode_0.programmable_pfet$3_0.d.n31 VSS 4.05428f
C4088 programmable_telescopic_cascode_0.programmable_pfet$3_0.d.t19 VSS 2.63781f
C4089 programmable_telescopic_cascode_0.programmable_pfet$3_0.d.n32 VSS 3.70505f
C4090 programmable_telescopic_cascode_0.programmable_pfet$3_0.d.n33 VSS 1.40782f
C4091 programmable_telescopic_cascode_0.programmable_pfet$3_0.d.n34 VSS 0.29259f
C4092 programmable_telescopic_cascode_0.programmable_pfet$3_0.d.n35 VSS 0.47878f
C4093 programmable_telescopic_cascode_0.programmable_pfet$3_0.d.n36 VSS 1.07824f
C4094 programmable_telescopic_cascode_0.programmable_pfet$3_0.d.n37 VSS 1.53518f
C4095 programmable_telescopic_cascode_0.programmable_pfet$3_0.d.t17 VSS 7.75327f
C4096 programmable_telescopic_cascode_0.programmable_pfet$3_0.d.t15 VSS 3.09693f
C4097 programmable_telescopic_cascode_0.programmable_pfet$3_0.d.n38 VSS 4.79833f
C4098 programmable_telescopic_cascode_0.programmable_pfet$3_0.d.t14 VSS 3.09693f
C4099 programmable_telescopic_cascode_0.programmable_pfet$3_0.d.n39 VSS 4.75156f
C4100 programmable_telescopic_cascode_0.programmable_pfet$3_0.d.t13 VSS 3.09693f
C4101 programmable_telescopic_cascode_0.programmable_pfet$3_0.d.n40 VSS 4.12197f
C4102 programmable_telescopic_cascode_0.programmable_pfet$3_0.d.n41 VSS 1.25528f
C4103 programmable_telescopic_cascode_0.programmable_pfet$3_0.g.t2 VSS 0.0206f
C4104 programmable_telescopic_cascode_0.programmable_pfet$3_0.g.t0 VSS 0.01995f
C4105 programmable_telescopic_cascode_0.programmable_pfet$3_0.g.t11 VSS 0.0206f
C4106 programmable_telescopic_cascode_0.programmable_pfet$3_0.g.t24 VSS 0.01994f
C4107 programmable_telescopic_cascode_0.programmable_pfet$3_0.g.n0 VSS 0.06671f
C4108 programmable_telescopic_cascode_0.programmable_pfet$3_0.g.t5 VSS 5.09035f
C4109 programmable_telescopic_cascode_0.programmable_pfet$3_0.g.t16 VSS 2.1798f
C4110 programmable_telescopic_cascode_0.programmable_pfet$3_0.g.n1 VSS 3.21363f
C4111 programmable_telescopic_cascode_0.programmable_pfet$3_0.g.t7 VSS 2.1798f
C4112 programmable_telescopic_cascode_0.programmable_pfet$3_0.g.n2 VSS 3.17805f
C4113 programmable_telescopic_cascode_0.programmable_pfet$3_0.g.t15 VSS 2.1798f
C4114 programmable_telescopic_cascode_0.programmable_pfet$3_0.g.n3 VSS 3.17805f
C4115 programmable_telescopic_cascode_0.programmable_pfet$3_0.g.t6 VSS 2.1798f
C4116 programmable_telescopic_cascode_0.programmable_pfet$3_0.g.n4 VSS 2.92542f
C4117 programmable_telescopic_cascode_0.programmable_pfet$3_0.g.t51 VSS 0.67104f
C4118 programmable_telescopic_cascode_0.programmable_pfet$3_0.g.t9 VSS 0.67104f
C4119 programmable_telescopic_cascode_0.programmable_pfet$3_0.g.n5 VSS 2.52601f
C4120 programmable_telescopic_cascode_0.programmable_pfet$3_0.g.t45 VSS 0.67104f
C4121 programmable_telescopic_cascode_0.programmable_pfet$3_0.g.t46 VSS 0.67104f
C4122 programmable_telescopic_cascode_0.programmable_pfet$3_0.g.n6 VSS 3.33074f
C4123 programmable_telescopic_cascode_0.programmable_pfet$3_0.g.t43 VSS 0.67104f
C4124 programmable_telescopic_cascode_0.programmable_pfet$3_0.g.t44 VSS 0.67104f
C4125 programmable_telescopic_cascode_0.programmable_pfet$3_0.g.n7 VSS 1.34208f
C4126 programmable_telescopic_cascode_0.programmable_pfet$3_0.g.n8 VSS 2.04693f
C4127 programmable_telescopic_cascode_0.programmable_pfet$3_0.g.t49 VSS 0.67104f
C4128 programmable_telescopic_cascode_0.programmable_pfet$3_0.g.t50 VSS 0.67104f
C4129 programmable_telescopic_cascode_0.programmable_pfet$3_0.g.n9 VSS 1.34208f
C4130 programmable_telescopic_cascode_0.programmable_pfet$3_0.g.n10 VSS 2.04095f
C4131 programmable_telescopic_cascode_0.programmable_pfet$3_0.g.t31 VSS 0.67104f
C4132 programmable_telescopic_cascode_0.programmable_pfet$3_0.g.t32 VSS 0.67104f
C4133 programmable_telescopic_cascode_0.programmable_pfet$3_0.g.n11 VSS 1.34208f
C4134 programmable_telescopic_cascode_0.programmable_pfet$3_0.g.n12 VSS 2.0418f
C4135 programmable_telescopic_cascode_0.programmable_pfet$3_0.g.t47 VSS 0.67104f
C4136 programmable_telescopic_cascode_0.programmable_pfet$3_0.g.t48 VSS 0.67104f
C4137 programmable_telescopic_cascode_0.programmable_pfet$3_0.g.n13 VSS 1.34208f
C4138 programmable_telescopic_cascode_0.programmable_pfet$3_0.g.n14 VSS 1.9254f
C4139 programmable_telescopic_cascode_0.programmable_pfet$3_0.g.n15 VSS 0.94183f
C4140 programmable_telescopic_cascode_0.programmable_pfet$3_0.g.t27 VSS 4.26481f
C4141 programmable_telescopic_cascode_0.programmable_pfet$3_0.g.t30 VSS 5.09035f
C4142 programmable_telescopic_cascode_0.programmable_pfet$3_0.g.t25 VSS 2.1798f
C4143 programmable_telescopic_cascode_0.programmable_pfet$3_0.g.n16 VSS 3.21363f
C4144 programmable_telescopic_cascode_0.programmable_pfet$3_0.g.t28 VSS 2.1798f
C4145 programmable_telescopic_cascode_0.programmable_pfet$3_0.g.n17 VSS 3.17805f
C4146 programmable_telescopic_cascode_0.programmable_pfet$3_0.g.t26 VSS 2.1798f
C4147 programmable_telescopic_cascode_0.programmable_pfet$3_0.g.n18 VSS 3.17805f
C4148 programmable_telescopic_cascode_0.programmable_pfet$3_0.g.t29 VSS 2.1798f
C4149 programmable_telescopic_cascode_0.programmable_pfet$3_0.g.n19 VSS 2.9253f
C4150 programmable_telescopic_cascode_0.programmable_pfet$3_0.g.n20 VSS 1.11386f
C4151 programmable_telescopic_cascode_0.programmable_pfet$3_0.g.n21 VSS 0.14299f
C4152 programmable_telescopic_cascode_0.programmable_pfet$3_0.g.n22 VSS 1.02394f
C4153 programmable_telescopic_cascode_0.programmable_pfet$3_0.g.t8 VSS 2.1798f
C4154 programmable_telescopic_cascode_0.programmable_pfet$3_0.g.n23 VSS 2.09868f
C4155 programmable_telescopic_cascode_0.programmable_pfet$3_0.g.t35 VSS 0.70086f
C4156 programmable_telescopic_cascode_0.programmable_pfet$3_0.g.t42 VSS 0.70086f
C4157 programmable_telescopic_cascode_0.programmable_pfet$3_0.g.n24 VSS 3.16474f
C4158 programmable_telescopic_cascode_0.programmable_pfet$3_0.g.t41 VSS 0.70086f
C4159 programmable_telescopic_cascode_0.programmable_pfet$3_0.g.t38 VSS 0.70086f
C4160 programmable_telescopic_cascode_0.programmable_pfet$3_0.g.n25 VSS 3.14946f
C4161 programmable_telescopic_cascode_0.programmable_pfet$3_0.g.n26 VSS 1.7182f
C4162 programmable_telescopic_cascode_0.programmable_pfet$3_0.g.t36 VSS 0.70086f
C4163 programmable_telescopic_cascode_0.programmable_pfet$3_0.g.t33 VSS 0.70086f
C4164 programmable_telescopic_cascode_0.programmable_pfet$3_0.g.n27 VSS 3.14946f
C4165 programmable_telescopic_cascode_0.programmable_pfet$3_0.g.n28 VSS 2.40075f
C4166 programmable_telescopic_cascode_0.programmable_pfet$3_0.g.t34 VSS 0.70086f
C4167 programmable_telescopic_cascode_0.programmable_pfet$3_0.g.t40 VSS 0.70086f
C4168 programmable_telescopic_cascode_0.programmable_pfet$3_0.g.n29 VSS 3.14942f
C4169 programmable_telescopic_cascode_0.programmable_pfet$3_0.g.n30 VSS 2.74291f
C4170 programmable_telescopic_cascode_0.programmable_pfet$3_0.g.t21 VSS 4.88593f
C4171 programmable_telescopic_cascode_0.programmable_pfet$3_0.g.t22 VSS 5.54506f
C4172 programmable_telescopic_cascode_0.programmable_pfet$3_0.g.t20 VSS 2.21489f
C4173 programmable_telescopic_cascode_0.programmable_pfet$3_0.g.n31 VSS 3.43172f
C4174 programmable_telescopic_cascode_0.programmable_pfet$3_0.g.t19 VSS 2.21489f
C4175 programmable_telescopic_cascode_0.programmable_pfet$3_0.g.n32 VSS 3.39827f
C4176 programmable_telescopic_cascode_0.programmable_pfet$3_0.g.t18 VSS 2.21489f
C4177 programmable_telescopic_cascode_0.programmable_pfet$3_0.g.n33 VSS 2.97033f
C4178 programmable_telescopic_cascode_0.programmable_pfet$3_0.g.n34 VSS 1.12939f
C4179 programmable_telescopic_cascode_0.programmable_pfet$3_0.g.t13 VSS 4.88593f
C4180 programmable_telescopic_cascode_0.programmable_pfet$3_0.g.t4 VSS 5.54506f
C4181 programmable_telescopic_cascode_0.programmable_pfet$3_0.g.t14 VSS 2.21489f
C4182 programmable_telescopic_cascode_0.programmable_pfet$3_0.g.n35 VSS 3.43172f
C4183 programmable_telescopic_cascode_0.programmable_pfet$3_0.g.t12 VSS 2.21489f
C4184 programmable_telescopic_cascode_0.programmable_pfet$3_0.g.n36 VSS 3.39827f
C4185 programmable_telescopic_cascode_0.programmable_pfet$3_0.g.t3 VSS 2.21489f
C4186 programmable_telescopic_cascode_0.programmable_pfet$3_0.g.n37 VSS 2.97033f
C4187 programmable_telescopic_cascode_0.programmable_pfet$3_0.g.n38 VSS 1.12052f
C4188 programmable_telescopic_cascode_0.programmable_pfet$3_0.g.n39 VSS 0.22926f
C4189 programmable_telescopic_cascode_0.programmable_pfet$3_0.g.n40 VSS 1.33693f
C4190 programmable_telescopic_cascode_0.programmable_pfet$3_0.g.t39 VSS 0.70086f
C4191 programmable_telescopic_cascode_0.programmable_pfet$3_0.g.t37 VSS 0.70086f
C4192 programmable_telescopic_cascode_0.programmable_pfet$3_0.g.n41 VSS 1.40173f
C4193 programmable_telescopic_cascode_0.programmable_pfet$3_0.g.n42 VSS 1.14535f
C4194 programmable_telescopic_cascode_0.programmable_pfet$3_0.g.n43 VSS 2.26019f
C4195 programmable_telescopic_cascode_0.programmable_pfet$3_0.g.t10 VSS 0.0206f
C4196 programmable_telescopic_cascode_0.programmable_pfet$3_0.g.t23 VSS 0.01994f
C4197 programmable_telescopic_cascode_0.programmable_pfet$3_0.g.n44 VSS 0.06671f
C4198 programmable_telescopic_cascode_0.programmable_pfet$3_0.g.t17 VSS 0.0206f
C4199 programmable_telescopic_cascode_0.programmable_pfet$3_0.g.t1 VSS 0.01995f
C4200 programmable_telescopic_cascode_0.programmable_pfet$3_0.g.n45 VSS 0.06605f
C4201 programmable_telescopic_cascode_0.programmable_pfet$3_0.g.n46 VSS 0.07106f
C4202 programmable_telescopic_cascode_0.programmable_pfet$3_0.g.t52 VSS 2.30816f
C4203 programmable_telescopic_cascode_0.programmable_pfet$3_0.g.t61 VSS 2.35674f
C4204 programmable_telescopic_cascode_0.programmable_pfet$3_0.g.t54 VSS 2.35674f
C4205 programmable_telescopic_cascode_0.programmable_pfet$3_0.g.t59 VSS 2.35674f
C4206 programmable_telescopic_cascode_0.programmable_pfet$3_0.g.t60 VSS 2.35674f
C4207 programmable_telescopic_cascode_0.programmable_pfet$3_0.g.t58 VSS 1.78163f
C4208 programmable_telescopic_cascode_0.programmable_pfet$3_0.g.n47 VSS 0.91019f
C4209 programmable_telescopic_cascode_0.programmable_pfet$3_0.g.n48 VSS 1.40593f
C4210 programmable_telescopic_cascode_0.programmable_pfet$3_0.g.t62 VSS 2.30816f
C4211 programmable_telescopic_cascode_0.programmable_pfet$3_0.g.t57 VSS 2.35674f
C4212 programmable_telescopic_cascode_0.programmable_pfet$3_0.g.t63 VSS 2.35674f
C4213 programmable_telescopic_cascode_0.programmable_pfet$3_0.g.t55 VSS 2.35674f
C4214 programmable_telescopic_cascode_0.programmable_pfet$3_0.g.t56 VSS 2.35674f
C4215 programmable_telescopic_cascode_0.programmable_pfet$3_0.g.t53 VSS 1.78163f
C4216 programmable_telescopic_cascode_0.programmable_pfet$3_0.g.n49 VSS 1.03629f
C4217 programmable_telescopic_cascode_0.programmable_pfet$3_0.g.n50 VSS 0.07106f
C4218 programmable_telescopic_cascode_0.programmable_pfet$3_0.g.n51 VSS 0.06605f
C4219 programmable_telescopic_cascode_0.programmable_pfet$2_0.transmission_gate$22_1.out.t2 VSS 0.00923f
C4220 programmable_telescopic_cascode_0.programmable_pfet$2_0.transmission_gate$22_1.out.t1 VSS 0.00895f
C4221 programmable_telescopic_cascode_0.programmable_pfet$2_0.transmission_gate$22_1.out.t3 VSS 1.21401f
C4222 programmable_telescopic_cascode_0.programmable_pfet$2_0.transmission_gate$22_1.out.t5 VSS 1.23577f
C4223 programmable_telescopic_cascode_0.programmable_pfet$2_0.transmission_gate$22_1.out.t6 VSS 1.23577f
C4224 programmable_telescopic_cascode_0.programmable_pfet$2_0.transmission_gate$22_1.out.t7 VSS 1.23577f
C4225 programmable_telescopic_cascode_0.programmable_pfet$2_0.transmission_gate$22_1.out.t4 VSS 0.93323f
C4226 programmable_telescopic_cascode_0.programmable_pfet$2_0.transmission_gate$22_1.out.t0 VSS 0.05981f
C4227 programmable_telescopic_cascode_0.programmable_pfet$2_0.transmission_gate$22_1.out.n0 VSS 0.48581f
C4228 programmable_telescopic_cascode_0.programmable_pfet$2_0.transmission_gate$22_1.out.n1 VSS 0.05228f
C4229 a_61069_4063.t4 VSS 2.16537f
C4230 a_61069_4063.t8 VSS 0.88146f
C4231 a_61069_4063.n0 VSS 1.4646f
C4232 a_61069_4063.t6 VSS 0.88146f
C4233 a_61069_4063.n1 VSS 1.39221f
C4234 a_61069_4063.t1 VSS 0.88146f
C4235 a_61069_4063.n2 VSS 1.39221f
C4236 a_61069_4063.t5 VSS 0.88146f
C4237 a_61069_4063.n3 VSS 0.96402f
C4238 a_61069_4063.t18 VSS 2.53486f
C4239 a_61069_4063.t16 VSS 2.62103f
C4240 a_61069_4063.t14 VSS 2.62103f
C4241 a_61069_4063.t10 VSS 2.62103f
C4242 a_61069_4063.t12 VSS 2.05151f
C4243 a_61069_4063.t22 VSS 2.53489f
C4244 a_61069_4063.t20 VSS 2.62103f
C4245 a_61069_4063.t23 VSS 2.62103f
C4246 a_61069_4063.t21 VSS 2.62103f
C4247 a_61069_4063.t24 VSS 2.0591f
C4248 a_61069_4063.n4 VSS 1.49234f
C4249 a_61069_4063.t19 VSS 2.5514f
C4250 a_61069_4063.t17 VSS 1.035f
C4251 a_61069_4063.n5 VSS 1.67282f
C4252 a_61069_4063.t15 VSS 1.035f
C4253 a_61069_4063.n6 VSS 1.6108f
C4254 a_61069_4063.t11 VSS 1.035f
C4255 a_61069_4063.n7 VSS 1.6108f
C4256 a_61069_4063.t13 VSS 1.035f
C4257 a_61069_4063.n8 VSS 1.31019f
C4258 a_61069_4063.n9 VSS 0.91805f
C4259 a_61069_4063.n10 VSS 1.06295f
C4260 a_61069_4063.t3 VSS 0.88146f
C4261 a_61069_4063.n11 VSS 1.37962f
C4262 a_61069_4063.t7 VSS 0.88146f
C4263 a_61069_4063.n12 VSS 1.39221f
C4264 a_61069_4063.t2 VSS 0.88146f
C4265 a_61069_4063.n13 VSS 1.39221f
C4266 a_61069_4063.t0 VSS 2.16537f
C4267 a_61069_4063.n14 VSS 1.4646f
C4268 a_61069_4063.t9 VSS 0.88146f
C4269 a_91570_47942.t9 VSS 0.18672f
C4270 a_91570_47942.t11 VSS 0.18672f
C4271 a_91570_47942.t8 VSS 0.18672f
C4272 a_91570_47942.n0 VSS 0.78877f
C4273 a_91570_47942.t18 VSS 1.25991f
C4274 a_91570_47942.t31 VSS 0.6593f
C4275 a_91570_47942.t32 VSS 0.30658f
C4276 a_91570_47942.n1 VSS 0.44137f
C4277 a_91570_47942.t30 VSS 0.5072f
C4278 a_91570_47942.n2 VSS 0.2622f
C4279 a_91570_47942.t15 VSS 0.6593f
C4280 a_91570_47942.t14 VSS 0.30658f
C4281 a_91570_47942.n3 VSS 0.44143f
C4282 a_91570_47942.t13 VSS 0.50707f
C4283 a_91570_47942.n4 VSS 0.2576f
C4284 a_91570_47942.n5 VSS 0.06535f
C4285 a_91570_47942.t4 VSS 0.6593f
C4286 a_91570_47942.t5 VSS 0.30658f
C4287 a_91570_47942.n6 VSS 0.44143f
C4288 a_91570_47942.t7 VSS 0.50707f
C4289 a_91570_47942.n7 VSS 0.2576f
C4290 a_91570_47942.n8 VSS 0.03544f
C4291 a_91570_47942.t2 VSS 0.6593f
C4292 a_91570_47942.t3 VSS 0.30658f
C4293 a_91570_47942.n9 VSS 0.44143f
C4294 a_91570_47942.t6 VSS 0.50707f
C4295 a_91570_47942.n10 VSS 0.2576f
C4296 a_91570_47942.n11 VSS 0.21753f
C4297 a_91570_47942.t33 VSS 0.5072f
C4298 a_91570_47942.t35 VSS 0.6593f
C4299 a_91570_47942.t34 VSS 0.30658f
C4300 a_91570_47942.n12 VSS 0.44137f
C4301 a_91570_47942.n13 VSS 0.2622f
C4302 a_91570_47942.t21 VSS 0.50707f
C4303 a_91570_47942.t23 VSS 0.6593f
C4304 a_91570_47942.t22 VSS 0.30658f
C4305 a_91570_47942.n14 VSS 0.44143f
C4306 a_91570_47942.n15 VSS 0.2576f
C4307 a_91570_47942.n16 VSS 0.06535f
C4308 a_91570_47942.t27 VSS 0.50707f
C4309 a_91570_47942.t24 VSS 0.6593f
C4310 a_91570_47942.t29 VSS 0.30658f
C4311 a_91570_47942.n17 VSS 0.44143f
C4312 a_91570_47942.n18 VSS 0.2576f
C4313 a_91570_47942.n19 VSS 0.0354f
C4314 a_91570_47942.t25 VSS 0.50707f
C4315 a_91570_47942.t28 VSS 0.6593f
C4316 a_91570_47942.t26 VSS 0.30658f
C4317 a_91570_47942.n20 VSS 0.44143f
C4318 a_91570_47942.n21 VSS 0.2576f
C4319 a_91570_47942.n22 VSS 0.16097f
C4320 a_91570_47942.n23 VSS 1.61682f
C4321 a_91570_47942.t19 VSS 0.61003f
C4322 a_91570_47942.n24 VSS 1.35934f
C4323 a_91570_47942.t20 VSS 0.61003f
C4324 a_91570_47942.n25 VSS 0.66987f
C4325 a_91570_47942.n26 VSS 0.33928f
C4326 a_91570_47942.t17 VSS 1.25991f
C4327 a_91570_47942.t12 VSS 1.39368f
C4328 a_91570_47942.t16 VSS 0.61003f
C4329 a_91570_47942.n27 VSS 0.70391f
C4330 a_91570_47942.n28 VSS 0.33311f
C4331 a_91570_47942.n29 VSS 0.14356f
C4332 a_91570_47942.n30 VSS 0.31395f
C4333 a_91570_47942.t1 VSS 0.18672f
C4334 a_91570_47942.t10 VSS 0.18672f
C4335 a_91570_47942.n31 VSS 0.37345f
C4336 a_91570_47942.n32 VSS 0.41656f
C4337 a_91570_47942.n33 VSS 0.91217f
C4338 a_91570_47942.t0 VSS 0.18672f
C4339 programmable_folded_cascode_0.programmable_nfet$1_0.g.t18 VSS 0.0221f
C4340 programmable_folded_cascode_0.programmable_nfet$1_0.g.t20 VSS 0.02159f
C4341 programmable_folded_cascode_0.programmable_nfet$1_0.g.n0 VSS 0.0741f
C4342 programmable_folded_cascode_0.programmable_nfet$1_0.g.t19 VSS 0.02159f
C4343 programmable_folded_cascode_0.programmable_nfet$1_0.g.t17 VSS 0.0221f
C4344 programmable_folded_cascode_0.programmable_nfet$1_0.g.n1 VSS 0.07405f
C4345 programmable_folded_cascode_0.programmable_nfet$1_0.g.t15 VSS 0.02159f
C4346 programmable_folded_cascode_0.programmable_nfet$1_0.g.t21 VSS 0.02206f
C4347 programmable_folded_cascode_0.programmable_nfet$1_0.g.n2 VSS 0.07441f
C4348 programmable_folded_cascode_0.programmable_nfet$1_0.g.t33 VSS 0.5187f
C4349 programmable_folded_cascode_0.programmable_nfet$1_0.g.n3 VSS 0.40643f
C4350 programmable_folded_cascode_0.programmable_nfet$1_0.g.n4 VSS 0.49438f
C4351 programmable_folded_cascode_0.programmable_nfet$1_0.g.n5 VSS 0.49533f
C4352 programmable_folded_cascode_0.programmable_nfet$1_0.g.t30 VSS 0.02206f
C4353 programmable_folded_cascode_0.programmable_nfet$1_0.g.t16 VSS 0.02159f
C4354 programmable_folded_cascode_0.programmable_nfet$1_0.g.n6 VSS 0.07441f
C4355 programmable_folded_cascode_0.programmable_nfet$1_0.g.t14 VSS 0.47552f
C4356 programmable_folded_cascode_0.programmable_nfet$1_0.g.t24 VSS 0.47552f
C4357 programmable_folded_cascode_0.programmable_nfet$1_0.g.n7 VSS 2.3804f
C4358 programmable_folded_cascode_0.programmable_nfet$1_0.g.t12 VSS 0.47552f
C4359 programmable_folded_cascode_0.programmable_nfet$1_0.g.t26 VSS 0.47552f
C4360 programmable_folded_cascode_0.programmable_nfet$1_0.g.n8 VSS 0.95105f
C4361 programmable_folded_cascode_0.programmable_nfet$1_0.g.n9 VSS 1.49782f
C4362 programmable_folded_cascode_0.programmable_nfet$1_0.g.t28 VSS 0.47552f
C4363 programmable_folded_cascode_0.programmable_nfet$1_0.g.t23 VSS 0.47552f
C4364 programmable_folded_cascode_0.programmable_nfet$1_0.g.n10 VSS 0.95105f
C4365 programmable_folded_cascode_0.programmable_nfet$1_0.g.n11 VSS 1.4905f
C4366 programmable_folded_cascode_0.programmable_nfet$1_0.g.t22 VSS 0.47552f
C4367 programmable_folded_cascode_0.programmable_nfet$1_0.g.t27 VSS 0.47552f
C4368 programmable_folded_cascode_0.programmable_nfet$1_0.g.n12 VSS 0.95105f
C4369 programmable_folded_cascode_0.programmable_nfet$1_0.g.n13 VSS 1.49047f
C4370 programmable_folded_cascode_0.programmable_nfet$1_0.g.t13 VSS 0.47552f
C4371 programmable_folded_cascode_0.programmable_nfet$1_0.g.t25 VSS 0.47552f
C4372 programmable_folded_cascode_0.programmable_nfet$1_0.g.n14 VSS 0.95105f
C4373 programmable_folded_cascode_0.programmable_nfet$1_0.g.n15 VSS 0.81102f
C4374 programmable_folded_cascode_0.programmable_nfet$1_0.g.t32 VSS 0.16868f
C4375 programmable_folded_cascode_0.programmable_nfet$1_0.g.t31 VSS 0.16868f
C4376 programmable_folded_cascode_0.programmable_nfet$1_0.g.n16 VSS 0.77786f
C4377 programmable_folded_cascode_0.programmable_nfet$1_0.g.t6 VSS 1.17803f
C4378 programmable_folded_cascode_0.programmable_nfet$1_0.g.n17 VSS 0.37271f
C4379 programmable_folded_cascode_0.programmable_nfet$1_0.g.t29 VSS 0.56723f
C4380 programmable_folded_cascode_0.programmable_nfet$1_0.g.n18 VSS 1.50653f
C4381 programmable_folded_cascode_0.programmable_nfet$1_0.g.t4 VSS 3.75274f
C4382 programmable_folded_cascode_0.programmable_nfet$1_0.g.t2 VSS 1.50501f
C4383 programmable_folded_cascode_0.programmable_nfet$1_0.g.n19 VSS 2.40046f
C4384 programmable_folded_cascode_0.programmable_nfet$1_0.g.t0 VSS 1.50501f
C4385 programmable_folded_cascode_0.programmable_nfet$1_0.g.n20 VSS 2.34393f
C4386 programmable_folded_cascode_0.programmable_nfet$1_0.g.t3 VSS 1.50501f
C4387 programmable_folded_cascode_0.programmable_nfet$1_0.g.n21 VSS 2.32531f
C4388 programmable_folded_cascode_0.programmable_nfet$1_0.g.t1 VSS 1.50501f
C4389 programmable_folded_cascode_0.programmable_nfet$1_0.g.n22 VSS 1.66493f
C4390 programmable_folded_cascode_0.programmable_nfet$1_0.g.n23 VSS 1.2286f
C4391 programmable_folded_cascode_0.programmable_nfet$1_0.g.t7 VSS 3.73983f
C4392 programmable_folded_cascode_0.programmable_nfet$1_0.g.t9 VSS 1.50501f
C4393 programmable_folded_cascode_0.programmable_nfet$1_0.g.n24 VSS 2.38125f
C4394 programmable_folded_cascode_0.programmable_nfet$1_0.g.t11 VSS 1.50501f
C4395 programmable_folded_cascode_0.programmable_nfet$1_0.g.n25 VSS 2.32552f
C4396 programmable_folded_cascode_0.programmable_nfet$1_0.g.t8 VSS 1.50501f
C4397 programmable_folded_cascode_0.programmable_nfet$1_0.g.n26 VSS 2.32552f
C4398 programmable_folded_cascode_0.programmable_nfet$1_0.g.t10 VSS 1.50501f
C4399 programmable_folded_cascode_0.programmable_nfet$1_0.g.n27 VSS 2.20898f
C4400 programmable_folded_cascode_0.programmable_nfet$1_0.g.n28 VSS 0.44416f
C4401 programmable_folded_cascode_0.programmable_nfet$1_0.g.n29 VSS 1.14547f
C4402 programmable_folded_cascode_0.programmable_nfet$1_0.g.t5 VSS 0.4993f
C4403 programmable_folded_cascode_0.programmable_nfet$1_0.g.n30 VSS 1.22099f
C4404 programmable_folded_cascode_0.programmable_nfet$1_0.g.n31 VSS 0.07662f
C4405 OUT_5T.t10 VSS 0.11482f
C4406 OUT_5T.t8 VSS 0.11482f
C4407 OUT_5T.n0 VSS 0.30494f
C4408 OUT_5T.t7 VSS 0.11482f
C4409 OUT_5T.t11 VSS 0.11482f
C4410 OUT_5T.n1 VSS 0.7442f
C4411 OUT_5T.t12 VSS 0.11482f
C4412 OUT_5T.t9 VSS 0.11482f
C4413 OUT_5T.n2 VSS 0.22964f
C4414 OUT_5T.n3 VSS 0.70773f
C4415 OUT_5T.n4 VSS 0.45873f
C4416 OUT_5T.t4 VSS 0.65391f
C4417 OUT_5T.t6 VSS 0.81082f
C4418 OUT_5T.t5 VSS 0.37704f
C4419 OUT_5T.n5 VSS 0.52787f
C4420 OUT_5T.n6 VSS 0.30152f
C4421 OUT_5T.n7 VSS 0.12961f
C4422 OUT_5T.t17 VSS 0.65391f
C4423 OUT_5T.t19 VSS 0.81082f
C4424 OUT_5T.t18 VSS 0.37704f
C4425 OUT_5T.n8 VSS 0.52787f
C4426 OUT_5T.n9 VSS 0.30152f
C4427 OUT_5T.n10 VSS 0.21896f
C4428 OUT_5T.t1 VSS 0.50359f
C4429 OUT_5T.t2 VSS 0.50359f
C4430 OUT_5T.n11 VSS 2.78286f
C4431 OUT_5T.t3 VSS 0.50359f
C4432 OUT_5T.t0 VSS 0.50359f
C4433 OUT_5T.n12 VSS 1.00718f
C4434 OUT_5T.n13 VSS 1.56487f
C4435 OUT_5T.n14 VSS 0.40677f
C4436 OUT_5T.t13 VSS 3.98683f
C4437 OUT_5T.t14 VSS 1.58873f
C4438 OUT_5T.n15 VSS 2.2217f
C4439 OUT_5T.n16 VSS 0.30627f
C4440 OUT_5T.t16 VSS 3.98683f
C4441 OUT_5T.t15 VSS 1.58873f
C4442 OUT_5T.n17 VSS 2.2217f
C4443 OUT_5T.n18 VSS 0.7849f
C4444 OUT_5T.n19 VSS 3.80285f
C4445 programmable_telescopic_cascode_0.programmable_nfet$4_1.transmission_gate$24_1.out.t2 VSS 0.01036f
C4446 programmable_telescopic_cascode_0.programmable_nfet$4_1.transmission_gate$24_1.out.t0 VSS 0.02984f
C4447 programmable_telescopic_cascode_0.programmable_nfet$4_1.transmission_gate$24_1.out.t6 VSS 1.0393f
C4448 programmable_telescopic_cascode_0.programmable_nfet$4_1.transmission_gate$24_1.out.t5 VSS 1.05326f
C4449 programmable_telescopic_cascode_0.programmable_nfet$4_1.transmission_gate$24_1.out.t8 VSS 1.05326f
C4450 programmable_telescopic_cascode_0.programmable_nfet$4_1.transmission_gate$24_1.out.t4 VSS 1.05326f
C4451 programmable_telescopic_cascode_0.programmable_nfet$4_1.transmission_gate$24_1.out.t7 VSS 1.05326f
C4452 programmable_telescopic_cascode_0.programmable_nfet$4_1.transmission_gate$24_1.out.t3 VSS 0.79986f
C4453 programmable_telescopic_cascode_0.programmable_nfet$4_1.transmission_gate$24_1.out.n0 VSS 0.39533f
C4454 programmable_telescopic_cascode_0.programmable_nfet$4_1.transmission_gate$24_1.out.t1 VSS 0.00969f
C4455 programmable_telescopic_cascode_0.programmable_nfet$4_1.transmission_gate$24_1.out.n1 VSS 0.05914f
C4456 programmable_telescopic_cascode_0.programmable_nfet$4_1.transmission_gate$24_0.out.t1 VSS 0.01027f
C4457 programmable_telescopic_cascode_0.programmable_nfet$4_1.transmission_gate$24_0.out.t0 VSS 0.02836f
C4458 programmable_telescopic_cascode_0.programmable_nfet$4_1.transmission_gate$24_0.out.t6 VSS 1.02988f
C4459 programmable_telescopic_cascode_0.programmable_nfet$4_1.transmission_gate$24_0.out.t3 VSS 1.04371f
C4460 programmable_telescopic_cascode_0.programmable_nfet$4_1.transmission_gate$24_0.out.t10 VSS 1.04371f
C4461 programmable_telescopic_cascode_0.programmable_nfet$4_1.transmission_gate$24_0.out.t13 VSS 1.04371f
C4462 programmable_telescopic_cascode_0.programmable_nfet$4_1.transmission_gate$24_0.out.t8 VSS 1.04371f
C4463 programmable_telescopic_cascode_0.programmable_nfet$4_1.transmission_gate$24_0.out.t11 VSS 0.79261f
C4464 programmable_telescopic_cascode_0.programmable_nfet$4_1.transmission_gate$24_0.out.n0 VSS 0.36245f
C4465 programmable_telescopic_cascode_0.programmable_nfet$4_1.transmission_gate$24_0.out.t12 VSS 1.02988f
C4466 programmable_telescopic_cascode_0.programmable_nfet$4_1.transmission_gate$24_0.out.t9 VSS 1.04371f
C4467 programmable_telescopic_cascode_0.programmable_nfet$4_1.transmission_gate$24_0.out.t4 VSS 1.04371f
C4468 programmable_telescopic_cascode_0.programmable_nfet$4_1.transmission_gate$24_0.out.t7 VSS 1.04371f
C4469 programmable_telescopic_cascode_0.programmable_nfet$4_1.transmission_gate$24_0.out.t14 VSS 1.04371f
C4470 programmable_telescopic_cascode_0.programmable_nfet$4_1.transmission_gate$24_0.out.t5 VSS 0.79261f
C4471 programmable_telescopic_cascode_0.programmable_nfet$4_1.transmission_gate$24_0.out.n1 VSS 0.29615f
C4472 programmable_telescopic_cascode_0.programmable_nfet$4_1.transmission_gate$24_0.out.t2 VSS 0.00961f
C4473 programmable_telescopic_cascode_0.programmable_nfet$4_1.transmission_gate$24_0.out.n2 VSS 0.05543f
C4474 programmable_telescopic_cascode_0.EN1.t10 VSS 0.04207f
C4475 programmable_telescopic_cascode_0.EN1.t8 VSS 0.04011f
C4476 programmable_telescopic_cascode_0.EN1.n0 VSS 0.40648f
C4477 programmable_telescopic_cascode_0.EN1.t0 VSS 0.10501f
C4478 programmable_telescopic_cascode_0.EN1.t2 VSS 0.10061f
C4479 programmable_telescopic_cascode_0.EN1.n1 VSS 0.19172f
C4480 programmable_telescopic_cascode_0.EN1.t1 VSS 0.10191f
C4481 programmable_telescopic_cascode_0.EN1.n2 VSS 0.21518f
C4482 programmable_telescopic_cascode_0.EN1.t5 VSS 0.10665f
C4483 programmable_telescopic_cascode_0.EN1.n3 VSS 0.69092f
C4484 programmable_telescopic_cascode_0.EN1.t11 VSS 0.04179f
C4485 programmable_telescopic_cascode_0.EN1.n4 VSS 0.06563f
C4486 programmable_telescopic_cascode_0.EN1.t7 VSS 0.10665f
C4487 programmable_telescopic_cascode_0.EN1.n5 VSS 0.69062f
C4488 programmable_telescopic_cascode_0.EN1.t14 VSS 0.04179f
C4489 programmable_telescopic_cascode_0.EN1.n6 VSS 0.06472f
C4490 programmable_telescopic_cascode_0.EN1.n7 VSS 1.32678f
C4491 programmable_telescopic_cascode_0.EN1.t13 VSS 0.10665f
C4492 programmable_telescopic_cascode_0.EN1.n8 VSS 0.69062f
C4493 programmable_telescopic_cascode_0.EN1.t4 VSS 0.04179f
C4494 programmable_telescopic_cascode_0.EN1.n9 VSS 0.06563f
C4495 programmable_telescopic_cascode_0.EN1.n10 VSS 1.02151f
C4496 programmable_telescopic_cascode_0.EN1.t15 VSS 0.10659f
C4497 programmable_telescopic_cascode_0.EN1.n11 VSS 0.69734f
C4498 programmable_telescopic_cascode_0.EN1.t6 VSS 0.04179f
C4499 programmable_telescopic_cascode_0.EN1.n12 VSS 0.06563f
C4500 programmable_telescopic_cascode_0.EN1.n13 VSS 1.02329f
C4501 programmable_telescopic_cascode_0.EN1.t17 VSS 0.10659f
C4502 programmable_telescopic_cascode_0.EN1.n14 VSS 0.69734f
C4503 programmable_telescopic_cascode_0.EN1.t3 VSS 0.04179f
C4504 programmable_telescopic_cascode_0.EN1.n15 VSS 0.06563f
C4505 programmable_telescopic_cascode_0.EN1.n16 VSS 0.59383f
C4506 programmable_telescopic_cascode_0.EN1.t9 VSS 0.0418f
C4507 programmable_telescopic_cascode_0.EN1.n17 VSS 0.44033f
C4508 programmable_telescopic_cascode_0.EN1.t12 VSS 0.04179f
C4509 programmable_telescopic_cascode_0.EN1.n18 VSS 0.04262f
C4510 programmable_telescopic_cascode_0.EN1.t18 VSS 0.04179f
C4511 programmable_telescopic_cascode_0.EN1.n19 VSS 0.04262f
C4512 programmable_telescopic_cascode_0.EN1.n20 VSS 2.31446f
C4513 programmable_telescopic_cascode_0.EN1.t16 VSS 0.04179f
C4514 programmable_telescopic_cascode_0.EN1.n21 VSS 0.06502f
C4515 programmable_telescopic_cascode_0.EN1.n22 VSS 1.68979f
C4516 programmable_telescopic_cascode_0.EN1.n23 VSS 1.69173f
C4517 programmable_telescopic_cascode_0.EN1.n24 VSS 0.68671f
C4518 INN_5T.t4 VSS 0.27309f
C4519 INN_5T.t5 VSS 0.28839f
C4520 INN_5T.t6 VSS 0.22529f
C4521 INN_5T.t3 VSS 0.00852f
C4522 INN_5T.t2 VSS 0.00834f
C4523 INN_5T.n0 VSS 0.02875f
C4524 INN_5T.t0 VSS 0.00854f
C4525 INN_5T.t1 VSS 0.00834f
C4526 INN_5T.n1 VSS 0.02893f
C4527 INN_5T.n2 VSS 0.02326f
C4528 INN_5T.n3 VSS 0.39033f
C4529 INN_5T.n4 VSS 0
C4530 INN_5T.n5 VSS 0.02318f
C4531 INN_5T.n6 VSS 0.0455f
C4532 INN_5T.n7 VSS 5.25137f
C4533 INN_5T.n8 VSS 0.02239f
C4534 INN_5T.n9 VSS 0.02239f
C4535 INN_5T.n10 VSS 0.0212f
C4536 INN_5T.n11 VSS 0.0455f
C4537 INN_5T.n12 VSS 0.05111f
C4538 INN_5T.n13 VSS 4.7731f
C4539 INN_5T.n14 VSS 1.56621f
C4540 programmable_folded_cascode_0.programmable_pfet$1_0.transmission_gate$17_1.out.t1 VSS 0.01174f
C4541 programmable_folded_cascode_0.programmable_pfet$1_0.transmission_gate$17_1.out.t7 VSS 1.0059f
C4542 programmable_folded_cascode_0.programmable_pfet$1_0.transmission_gate$17_1.out.t11 VSS 1.03447f
C4543 programmable_folded_cascode_0.programmable_pfet$1_0.transmission_gate$17_1.out.t8 VSS 1.03455f
C4544 programmable_folded_cascode_0.programmable_pfet$1_0.transmission_gate$17_1.out.t12 VSS 1.03454f
C4545 programmable_folded_cascode_0.programmable_pfet$1_0.transmission_gate$17_1.out.t5 VSS 0.78524f
C4546 programmable_folded_cascode_0.programmable_pfet$1_0.transmission_gate$17_1.out.t2 VSS 0.01669f
C4547 programmable_folded_cascode_0.programmable_pfet$1_0.transmission_gate$17_1.out.n0 VSS 0.49216f
C4548 programmable_folded_cascode_0.programmable_pfet$1_0.transmission_gate$17_1.out.t3 VSS 1.0059f
C4549 programmable_folded_cascode_0.programmable_pfet$1_0.transmission_gate$17_1.out.t9 VSS 1.03447f
C4550 programmable_folded_cascode_0.programmable_pfet$1_0.transmission_gate$17_1.out.t4 VSS 1.03454f
C4551 programmable_folded_cascode_0.programmable_pfet$1_0.transmission_gate$17_1.out.t6 VSS 1.03454f
C4552 programmable_folded_cascode_0.programmable_pfet$1_0.transmission_gate$17_1.out.t10 VSS 0.78478f
C4553 programmable_folded_cascode_0.programmable_pfet$1_0.transmission_gate$17_1.out.n1 VSS 0.46712f
C4554 programmable_folded_cascode_0.programmable_pfet$1_0.transmission_gate$17_1.out.n2 VSS 0.07274f
C4555 programmable_folded_cascode_0.programmable_pfet$1_0.transmission_gate$17_1.out.t0 VSS 0.0121f
C4556 programmable_folded_cascode_0.programmable_pfet$1_0.g.t24 VSS 0.01072f
C4557 programmable_folded_cascode_0.programmable_pfet$1_0.g.t25 VSS 0.01032f
C4558 programmable_folded_cascode_0.programmable_pfet$1_0.g.n0 VSS 0.03315f
C4559 programmable_folded_cascode_0.programmable_pfet$1_0.g.t26 VSS 0.01032f
C4560 programmable_folded_cascode_0.programmable_pfet$1_0.g.t23 VSS 0.01072f
C4561 programmable_folded_cascode_0.programmable_pfet$1_0.g.n1 VSS 0.03314f
C4562 programmable_folded_cascode_0.programmable_pfet$1_0.g.t22 VSS 0.01033f
C4563 programmable_folded_cascode_0.programmable_pfet$1_0.g.t28 VSS 0.01072f
C4564 programmable_folded_cascode_0.programmable_pfet$1_0.g.n2 VSS 0.03336f
C4565 programmable_folded_cascode_0.programmable_pfet$1_0.g.t38 VSS 0.89102f
C4566 programmable_folded_cascode_0.programmable_pfet$1_0.g.t35 VSS 0.91632f
C4567 programmable_folded_cascode_0.programmable_pfet$1_0.g.t30 VSS 0.91639f
C4568 programmable_folded_cascode_0.programmable_pfet$1_0.g.t33 VSS 0.91638f
C4569 programmable_folded_cascode_0.programmable_pfet$1_0.g.t36 VSS 0.70248f
C4570 programmable_folded_cascode_0.programmable_pfet$1_0.g.n3 VSS 0.35855f
C4571 programmable_folded_cascode_0.programmable_pfet$1_0.g.n4 VSS 0.24416f
C4572 programmable_folded_cascode_0.programmable_pfet$1_0.g.n5 VSS 0.24433f
C4573 programmable_folded_cascode_0.programmable_pfet$1_0.g.t27 VSS 0.01072f
C4574 programmable_folded_cascode_0.programmable_pfet$1_0.g.t21 VSS 0.01033f
C4575 programmable_folded_cascode_0.programmable_pfet$1_0.g.n6 VSS 0.03336f
C4576 programmable_folded_cascode_0.programmable_pfet$1_0.g.t37 VSS 0.89102f
C4577 programmable_folded_cascode_0.programmable_pfet$1_0.g.t32 VSS 0.91632f
C4578 programmable_folded_cascode_0.programmable_pfet$1_0.g.t29 VSS 0.91639f
C4579 programmable_folded_cascode_0.programmable_pfet$1_0.g.t34 VSS 0.91638f
C4580 programmable_folded_cascode_0.programmable_pfet$1_0.g.t31 VSS 0.69464f
C4581 programmable_folded_cascode_0.programmable_pfet$1_0.g.t6 VSS 0.59105f
C4582 programmable_folded_cascode_0.programmable_pfet$1_0.g.t4 VSS 0.6149f
C4583 programmable_folded_cascode_0.programmable_pfet$1_0.g.t10 VSS 0.6149f
C4584 programmable_folded_cascode_0.programmable_pfet$1_0.g.t0 VSS 0.6149f
C4585 programmable_folded_cascode_0.programmable_pfet$1_0.g.t12 VSS 0.6149f
C4586 programmable_folded_cascode_0.programmable_pfet$1_0.g.t16 VSS 0.6149f
C4587 programmable_folded_cascode_0.programmable_pfet$1_0.g.t8 VSS 0.6149f
C4588 programmable_folded_cascode_0.programmable_pfet$1_0.g.t18 VSS 0.6149f
C4589 programmable_folded_cascode_0.programmable_pfet$1_0.g.t2 VSS 0.6149f
C4590 programmable_folded_cascode_0.programmable_pfet$1_0.g.t14 VSS 0.48281f
C4591 programmable_folded_cascode_0.programmable_pfet$1_0.g.t15 VSS 0.48171f
C4592 programmable_folded_cascode_0.programmable_pfet$1_0.g.n7 VSS 0.9258f
C4593 programmable_folded_cascode_0.programmable_pfet$1_0.g.t3 VSS 0.48171f
C4594 programmable_folded_cascode_0.programmable_pfet$1_0.g.n8 VSS 0.75508f
C4595 programmable_folded_cascode_0.programmable_pfet$1_0.g.t19 VSS 0.48171f
C4596 programmable_folded_cascode_0.programmable_pfet$1_0.g.n9 VSS 0.55864f
C4597 programmable_folded_cascode_0.programmable_pfet$1_0.g.t7 VSS 1.17835f
C4598 programmable_folded_cascode_0.programmable_pfet$1_0.g.t5 VSS 0.48171f
C4599 programmable_folded_cascode_0.programmable_pfet$1_0.g.n10 VSS 0.7939f
C4600 programmable_folded_cascode_0.programmable_pfet$1_0.g.t11 VSS 0.48171f
C4601 programmable_folded_cascode_0.programmable_pfet$1_0.g.n11 VSS 0.52091f
C4602 programmable_folded_cascode_0.programmable_pfet$1_0.g.t20 VSS 1.65343f
C4603 programmable_folded_cascode_0.programmable_pfet$1_0.g.n12 VSS 0.4419f
C4604 programmable_folded_cascode_0.programmable_pfet$1_0.g.t1 VSS 0.48171f
C4605 programmable_folded_cascode_0.programmable_pfet$1_0.g.n13 VSS 0.75123f
C4606 programmable_folded_cascode_0.programmable_pfet$1_0.g.t13 VSS 0.48171f
C4607 programmable_folded_cascode_0.programmable_pfet$1_0.g.n14 VSS 0.75508f
C4608 programmable_folded_cascode_0.programmable_pfet$1_0.g.t17 VSS 0.48171f
C4609 programmable_folded_cascode_0.programmable_pfet$1_0.g.n15 VSS 0.75508f
C4610 programmable_folded_cascode_0.programmable_pfet$1_0.g.t9 VSS 0.48171f
C4611 programmable_folded_cascode_0.programmable_pfet$1_0.g.n16 VSS 0.7135f
C4612 programmable_folded_cascode_0.programmable_pfet$1_0.g.n17 VSS 1.06802f
C4613 programmable_folded_cascode_0.programmable_pfet$1_0.g.n18 VSS 1.16513f
C4614 programmable_folded_cascode_0.programmable_pfet$1_0.g.n19 VSS 0.03132f
C4615 transmission_gate$2$1_6.out.t3 VSS 0.02646f
C4616 transmission_gate$2$1_6.out.t4 VSS 0.02602f
C4617 transmission_gate$2$1_6.out.n0 VSS 0.13224f
C4618 transmission_gate$2$1_6.out.t22 VSS 0.01913f
C4619 transmission_gate$2$1_6.out.t20 VSS 0.03263f
C4620 transmission_gate$2$1_6.out.n1 VSS 0.05266f
C4621 transmission_gate$2$1_6.out.t8 VSS 0.04401f
C4622 transmission_gate$2$1_6.out.t24 VSS 0.01901f
C4623 transmission_gate$2$1_6.out.n2 VSS 0.03731f
C4624 transmission_gate$2$1_6.out.n3 VSS 0.13655f
C4625 transmission_gate$2$1_6.out.t9 VSS 0.01901f
C4626 transmission_gate$2$1_6.out.n4 VSS 0.01934f
C4627 transmission_gate$2$1_6.out.n5 VSS 1.04987f
C4628 transmission_gate$2$1_6.out.t25 VSS 0.01901f
C4629 transmission_gate$2$1_6.out.n6 VSS 0.01935f
C4630 transmission_gate$2$1_6.out.t7 VSS 0.01901f
C4631 transmission_gate$2$1_6.out.n7 VSS 0.01934f
C4632 transmission_gate$2$1_6.out.n8 VSS 1.36474f
C4633 transmission_gate$2$1_6.out.n9 VSS 0.76357f
C4634 transmission_gate$2$1_6.out.t11 VSS 0.01901f
C4635 transmission_gate$2$1_6.out.n10 VSS 0.01934f
C4636 transmission_gate$2$1_6.out.t23 VSS 0.01901f
C4637 transmission_gate$2$1_6.out.n11 VSS 0.01934f
C4638 transmission_gate$2$1_6.out.n12 VSS 1.36492f
C4639 transmission_gate$2$1_6.out.n13 VSS 0.75596f
C4640 transmission_gate$2$1_6.out.t19 VSS 0.01901f
C4641 transmission_gate$2$1_6.out.n14 VSS 0.01935f
C4642 transmission_gate$2$1_6.out.t6 VSS 0.01901f
C4643 transmission_gate$2$1_6.out.n15 VSS 0.01934f
C4644 transmission_gate$2$1_6.out.n16 VSS 1.36493f
C4645 transmission_gate$2$1_6.out.n17 VSS 0.78868f
C4646 transmission_gate$2$1_6.out.t21 VSS 0.04401f
C4647 transmission_gate$2$1_6.out.t5 VSS 0.01901f
C4648 transmission_gate$2$1_6.out.n18 VSS 0.03719f
C4649 transmission_gate$2$1_6.out.n19 VSS 0.17472f
C4650 transmission_gate$2$1_6.out.t17 VSS 0.04401f
C4651 transmission_gate$2$1_6.out.t10 VSS 0.01901f
C4652 transmission_gate$2$1_6.out.n20 VSS 0.03707f
C4653 transmission_gate$2$1_6.out.n21 VSS 0.3476f
C4654 transmission_gate$2$1_6.out.n22 VSS 1.043f
C4655 transmission_gate$2$1_6.out.n23 VSS 0.89776f
C4656 transmission_gate$2$1_6.out.t18 VSS 0.04401f
C4657 transmission_gate$2$1_6.out.t16 VSS 0.01901f
C4658 transmission_gate$2$1_6.out.n24 VSS 0.03658f
C4659 transmission_gate$2$1_6.out.n25 VSS 5.36522f
C4660 transmission_gate$2$1_6.out.n26 VSS 13.0441f
C4661 transmission_gate$2$1_6.out.n27 VSS 18.1843f
C4662 transmission_gate$2$1_6.out.n28 VSS 9.86016f
C4663 transmission_gate$2$1_6.out.t13 VSS 0.01994f
C4664 transmission_gate$2$1_6.out.t15 VSS 0.01901f
C4665 transmission_gate$2$1_6.out.n29 VSS 0.06844f
C4666 transmission_gate$2$1_6.out.n30 VSS 0.10097f
C4667 transmission_gate$2$1_6.out.t12 VSS 0.01994f
C4668 transmission_gate$2$1_6.out.t14 VSS 0.01901f
C4669 transmission_gate$2$1_6.out.n31 VSS 0.04913f
C4670 transmission_gate$2$1_6.out.n32 VSS 0.01639f
C4671 transmission_gate$2$1_6.out.n33 VSS 0.21029f
C4672 transmission_gate$2$1_6.out.t1 VSS 0.05039f
C4673 transmission_gate$2$1_6.out.t0 VSS 0.04769f
C4674 transmission_gate$2$1_6.out.n34 VSS 0.1835f
C4675 transmission_gate$2$1_6.out.t2 VSS 0.0475f
C4676 transmission_gate$2$1_6.out.n35 VSS 0.14604f
C4677 CLK.t14 VSS 0.03448f
C4678 CLK.t43 VSS 0.03306f
C4679 CLK.t0 VSS 0.10255f
C4680 CLK.t6 VSS 0.10094f
C4681 CLK.n0 VSS 0.18105f
C4682 CLK.t5 VSS 0.05637f
C4683 CLK.t29 VSS 0.0331f
C4684 CLK.n1 VSS 0.09117f
C4685 CLK.n2 VSS 1.89637f
C4686 CLK.t2 VSS 0.03448f
C4687 CLK.t30 VSS 0.03306f
C4688 CLK.t40 VSS 0.10255f
C4689 CLK.t47 VSS 0.10094f
C4690 CLK.n3 VSS 0.18096f
C4691 CLK.t45 VSS 0.05637f
C4692 CLK.t19 VSS 0.0331f
C4693 CLK.n4 VSS 0.09117f
C4694 CLK.n5 VSS 0.53041f
C4695 CLK.n6 VSS 4.90976f
C4696 CLK.t42 VSS 0.03448f
C4697 CLK.t20 VSS 0.03306f
C4698 CLK.t28 VSS 0.10255f
C4699 CLK.t33 VSS 0.10094f
C4700 CLK.n7 VSS 0.18161f
C4701 CLK.t51 VSS 0.05637f
C4702 CLK.t24 VSS 0.0331f
C4703 CLK.n8 VSS 0.09117f
C4704 CLK.n9 VSS 0.53062f
C4705 CLK.n10 VSS 4.17367f
C4706 CLK.t48 VSS 0.03448f
C4707 CLK.t25 VSS 0.03306f
C4708 CLK.t31 VSS 0.10255f
C4709 CLK.t39 VSS 0.10094f
C4710 CLK.n11 VSS 0.18135f
C4711 CLK.t38 VSS 0.05637f
C4712 CLK.t13 VSS 0.0331f
C4713 CLK.n12 VSS 0.09117f
C4714 CLK.n13 VSS 0.53054f
C4715 CLK.n14 VSS 3.52521f
C4716 CLK.n15 VSS 0.24424f
C4717 CLK.n16 VSS 0.12718f
C4718 CLK.n17 VSS 0.12248f
C4719 CLK.n18 VSS 0.10029f
C4720 CLK.n19 VSS 1.15548f
C4721 CLK.n20 VSS 0.12248f
C4722 CLK.n21 VSS 0.12032f
C4723 CLK.n22 VSS 0.12248f
C4724 CLK.n23 VSS 0.01409f
C4725 CLK.n24 VSS 0.40392f
C4726 CLK.n25 VSS 0.26763f
C4727 CLK.n26 VSS 0.12705f
C4728 CLK.n27 VSS 2.08694f
C4729 CLK.t35 VSS 0.03448f
C4730 CLK.t15 VSS 0.03306f
C4731 CLK.t21 VSS 0.10255f
C4732 CLK.t27 VSS 0.10094f
C4733 CLK.n28 VSS 0.18131f
C4734 CLK.t26 VSS 0.05637f
C4735 CLK.t1 VSS 0.0331f
C4736 CLK.n29 VSS 0.09117f
C4737 CLK.n30 VSS 0.53052f
C4738 CLK.n31 VSS 2.73529f
C4739 CLK.t22 VSS 0.03448f
C4740 CLK.t3 VSS 0.03306f
C4741 CLK.t12 VSS 0.10255f
C4742 CLK.t17 VSS 0.10094f
C4743 CLK.n32 VSS 0.18113f
C4744 CLK.t16 VSS 0.05637f
C4745 CLK.t41 VSS 0.0331f
C4746 CLK.n33 VSS 0.09117f
C4747 CLK.n34 VSS 0.53047f
C4748 CLK.n35 VSS 4.17367f
C4749 CLK.t7 VSS 0.03448f
C4750 CLK.t36 VSS 0.03306f
C4751 CLK.t44 VSS 0.10255f
C4752 CLK.t52 VSS 0.10094f
C4753 CLK.n36 VSS 0.18118f
C4754 CLK.t50 VSS 0.05637f
C4755 CLK.t23 VSS 0.0331f
C4756 CLK.n37 VSS 0.09117f
C4757 CLK.n38 VSS 0.53048f
C4758 CLK.n39 VSS 4.17367f
C4759 CLK.t8 VSS 0.03448f
C4760 CLK.t37 VSS 0.03306f
C4761 CLK.t46 VSS 0.10255f
C4762 CLK.t53 VSS 0.10094f
C4763 CLK.n40 VSS 0.18126f
C4764 CLK.t9 VSS 0.05637f
C4765 CLK.t32 VSS 0.0331f
C4766 CLK.n41 VSS 0.09117f
C4767 CLK.n42 VSS 0.53051f
C4768 CLK.n43 VSS 4.15823f
C4769 CLK.t18 VSS 0.03448f
C4770 CLK.t49 VSS 0.03306f
C4771 CLK.t4 VSS 0.10255f
C4772 CLK.t11 VSS 0.10094f
C4773 CLK.n44 VSS 0.18126f
C4774 CLK.t10 VSS 0.05637f
C4775 CLK.t34 VSS 0.0331f
C4776 CLK.n45 VSS 0.09117f
C4777 CLK.n46 VSS 0.53092f
C4778 programmable_telescopic_cascode_0.programmable_nfet$5_1.d.t1 VSS 0.32047f
C4779 programmable_telescopic_cascode_0.programmable_nfet$5_1.d.t0 VSS 0.32047f
C4780 programmable_telescopic_cascode_0.programmable_nfet$5_1.d.n0 VSS 1.46269f
C4781 programmable_telescopic_cascode_0.programmable_nfet$5_1.d.t2 VSS 2.04038f
C4782 programmable_telescopic_cascode_0.programmable_nfet$5_1.d.t4 VSS 2.72878f
C4783 programmable_telescopic_cascode_0.programmable_nfet$5_1.d.t23 VSS 3.6473f
C4784 programmable_telescopic_cascode_0.programmable_nfet$5_1.d.t14 VSS 1.56153f
C4785 programmable_telescopic_cascode_0.programmable_nfet$5_1.d.n1 VSS 2.24624f
C4786 programmable_telescopic_cascode_0.programmable_nfet$5_1.d.t3 VSS 1.56153f
C4787 programmable_telescopic_cascode_0.programmable_nfet$5_1.d.n2 VSS 2.22149f
C4788 programmable_telescopic_cascode_0.programmable_nfet$5_1.d.t6 VSS 1.56153f
C4789 programmable_telescopic_cascode_0.programmable_nfet$5_1.d.n3 VSS 2.22149f
C4790 programmable_telescopic_cascode_0.programmable_nfet$5_1.d.t25 VSS 1.56153f
C4791 programmable_telescopic_cascode_0.programmable_nfet$5_1.d.n4 VSS 2.0275f
C4792 programmable_telescopic_cascode_0.programmable_nfet$5_1.d.t11 VSS 3.07598f
C4793 programmable_telescopic_cascode_0.programmable_nfet$5_1.d.t10 VSS 3.64755f
C4794 programmable_telescopic_cascode_0.programmable_nfet$5_1.d.t9 VSS 1.56153f
C4795 programmable_telescopic_cascode_0.programmable_nfet$5_1.d.n5 VSS 2.2276f
C4796 programmable_telescopic_cascode_0.programmable_nfet$5_1.d.t13 VSS 1.56153f
C4797 programmable_telescopic_cascode_0.programmable_nfet$5_1.d.n6 VSS 2.20311f
C4798 programmable_telescopic_cascode_0.programmable_nfet$5_1.d.t8 VSS 1.56153f
C4799 programmable_telescopic_cascode_0.programmable_nfet$5_1.d.n7 VSS 2.20311f
C4800 programmable_telescopic_cascode_0.programmable_nfet$5_1.d.t12 VSS 1.56153f
C4801 programmable_telescopic_cascode_0.programmable_nfet$5_1.d.n8 VSS 2.01043f
C4802 programmable_telescopic_cascode_0.programmable_nfet$5_1.d.n9 VSS 0.79263f
C4803 programmable_telescopic_cascode_0.programmable_nfet$5_1.d.t19 VSS 3.07628f
C4804 programmable_telescopic_cascode_0.programmable_nfet$5_1.d.t16 VSS 3.64755f
C4805 programmable_telescopic_cascode_0.programmable_nfet$5_1.d.t17 VSS 1.56153f
C4806 programmable_telescopic_cascode_0.programmable_nfet$5_1.d.n10 VSS 2.2276f
C4807 programmable_telescopic_cascode_0.programmable_nfet$5_1.d.t20 VSS 1.56153f
C4808 programmable_telescopic_cascode_0.programmable_nfet$5_1.d.n11 VSS 2.20311f
C4809 programmable_telescopic_cascode_0.programmable_nfet$5_1.d.t18 VSS 1.56153f
C4810 programmable_telescopic_cascode_0.programmable_nfet$5_1.d.n12 VSS 2.20311f
C4811 programmable_telescopic_cascode_0.programmable_nfet$5_1.d.t21 VSS 1.56153f
C4812 programmable_telescopic_cascode_0.programmable_nfet$5_1.d.n13 VSS 2.01018f
C4813 programmable_telescopic_cascode_0.programmable_nfet$5_1.d.n14 VSS 0.78869f
C4814 programmable_telescopic_cascode_0.programmable_nfet$5_1.d.n15 VSS 0.03245f
C4815 programmable_telescopic_cascode_0.programmable_nfet$5_1.d.t22 VSS 3.07628f
C4816 programmable_telescopic_cascode_0.programmable_nfet$5_1.d.t5 VSS 3.6452f
C4817 programmable_telescopic_cascode_0.programmable_nfet$5_1.d.t26 VSS 1.56153f
C4818 programmable_telescopic_cascode_0.programmable_nfet$5_1.d.n16 VSS 2.31812f
C4819 programmable_telescopic_cascode_0.programmable_nfet$5_1.d.t15 VSS 1.56153f
C4820 programmable_telescopic_cascode_0.programmable_nfet$5_1.d.n17 VSS 2.29253f
C4821 programmable_telescopic_cascode_0.programmable_nfet$5_1.d.t24 VSS 1.56153f
C4822 programmable_telescopic_cascode_0.programmable_nfet$5_1.d.n18 VSS 2.29253f
C4823 programmable_telescopic_cascode_0.programmable_nfet$5_1.d.t7 VSS 1.56153f
C4824 programmable_telescopic_cascode_0.programmable_nfet$5_1.d.n19 VSS 2.09365f
C4825 programmable_telescopic_cascode_0.programmable_nfet$5_1.d.n20 VSS 0.79339f
C4826 programmable_telescopic_cascode_0.programmable_nfet$5_1.d.n21 VSS 0.09386f
C4827 programmable_telescopic_cascode_0.programmable_nfet$5_1.d.n22 VSS 0.6928f
C4828 programmable_telescopic_cascode_0.programmable_nfet$5_1.d.n23 VSS 0.69349f
C4829 programmable_telescopic_cascode_0.programmable_nfet$5_1.d.n24 VSS 0.61993f
C4830 programmable_telescopic_cascode_0.programmable_nfet$5_1.d.t27 VSS 2.29154f
C4831 programmable_telescopic_cascode_0.programmable_nfet$5_1.d.n25 VSS 0.23932f
C4832 OUT_TELESCOPIC.n0 VSS 0.00371f
C4833 OUT_TELESCOPIC.n1 VSS 0.10584f
C4834 OUT_TELESCOPIC.n2 VSS 0
C4835 OUT_TELESCOPIC.n3 VSS 0.04559f
C4836 OUT_TELESCOPIC.n4 VSS 0.1035f
C4837 OUT_TELESCOPIC.n5 VSS 0.11457f
C4838 OUT_TELESCOPIC.n6 VSS 0.04403f
C4839 OUT_TELESCOPIC.n7 VSS 0.04403f
C4840 OUT_TELESCOPIC.n8 VSS 0.0473f
C4841 OUT_TELESCOPIC.n9 VSS 0.1035f
C4842 OUT_TELESCOPIC.n10 VSS 0.10053f
C4843 OUT_TELESCOPIC.n11 VSS 12.2084f
C4844 OUT_TELESCOPIC.n12 VSS 0.08558f
C4845 OUT_TELESCOPIC.n13 VSS 0.05854f
C4846 OUT_TELESCOPIC.n14 VSS 0.11821f
C4847 OUT_TELESCOPIC.n15 VSS 0.08902f
C4848 OUT_TELESCOPIC.n16 VSS 0.09124f
C4849 OUT_TELESCOPIC.n17 VSS 0.00371f
C4850 OUT_TELESCOPIC.n18 VSS 0.08664f
C4851 OUT_TELESCOPIC.n19 VSS 0.03091f
C4852 OUT_TELESCOPIC.n20 VSS 0.07774f
C4853 OUT_TELESCOPIC.n21 VSS 0.13649f
C4854 OUT_TELESCOPIC.n22 VSS 0.08753f
C4855 OUT_TELESCOPIC.n23 VSS 12.2093f
C4856 OUT_TELESCOPIC.n24 VSS 0.03091f
C4857 OUT_TELESCOPIC.n25 VSS 10.2008f
C4858 OUT_TELESCOPIC.t19 VSS 3.73997f
C4859 OUT_TELESCOPIC.t23 VSS 4.5392f
C4860 OUT_TELESCOPIC.t20 VSS 1.81312f
C4861 OUT_TELESCOPIC.n26 VSS 2.80921f
C4862 OUT_TELESCOPIC.t21 VSS 1.81312f
C4863 OUT_TELESCOPIC.n27 VSS 2.78183f
C4864 OUT_TELESCOPIC.t22 VSS 1.81312f
C4865 OUT_TELESCOPIC.n28 VSS 2.43153f
C4866 OUT_TELESCOPIC.t41 VSS 0.57373f
C4867 OUT_TELESCOPIC.t38 VSS 0.57373f
C4868 OUT_TELESCOPIC.n29 VSS 1.98353f
C4869 OUT_TELESCOPIC.t1 VSS 0.54932f
C4870 OUT_TELESCOPIC.t32 VSS 0.54932f
C4871 OUT_TELESCOPIC.n30 VSS 1.90646f
C4872 OUT_TELESCOPIC.t33 VSS 0.54932f
C4873 OUT_TELESCOPIC.t2 VSS 0.54932f
C4874 OUT_TELESCOPIC.n31 VSS 2.72655f
C4875 OUT_TELESCOPIC.t17 VSS 0.54932f
C4876 OUT_TELESCOPIC.t36 VSS 0.54932f
C4877 OUT_TELESCOPIC.n32 VSS 1.09863f
C4878 OUT_TELESCOPIC.n33 VSS 1.67562f
C4879 OUT_TELESCOPIC.t0 VSS 0.54932f
C4880 OUT_TELESCOPIC.t18 VSS 0.54932f
C4881 OUT_TELESCOPIC.n34 VSS 1.09863f
C4882 OUT_TELESCOPIC.n35 VSS 1.67072f
C4883 OUT_TELESCOPIC.t3 VSS 0.54932f
C4884 OUT_TELESCOPIC.t34 VSS 0.54932f
C4885 OUT_TELESCOPIC.n36 VSS 1.09863f
C4886 OUT_TELESCOPIC.n37 VSS 1.67142f
C4887 OUT_TELESCOPIC.t35 VSS 0.54932f
C4888 OUT_TELESCOPIC.t4 VSS 0.54932f
C4889 OUT_TELESCOPIC.n38 VSS 1.09863f
C4890 OUT_TELESCOPIC.n39 VSS 1.57614f
C4891 OUT_TELESCOPIC.t14 VSS 3.49106f
C4892 OUT_TELESCOPIC.t8 VSS 4.16697f
C4893 OUT_TELESCOPIC.t7 VSS 1.78439f
C4894 OUT_TELESCOPIC.n40 VSS 2.63069f
C4895 OUT_TELESCOPIC.t16 VSS 1.78439f
C4896 OUT_TELESCOPIC.n41 VSS 2.60156f
C4897 OUT_TELESCOPIC.t6 VSS 1.78439f
C4898 OUT_TELESCOPIC.n42 VSS 2.60156f
C4899 OUT_TELESCOPIC.t15 VSS 1.78439f
C4900 OUT_TELESCOPIC.n43 VSS 2.39476f
C4901 OUT_TELESCOPIC.n44 VSS 0.91862f
C4902 OUT_TELESCOPIC.t30 VSS 3.49119f
C4903 OUT_TELESCOPIC.t27 VSS 4.16697f
C4904 OUT_TELESCOPIC.t28 VSS 1.78439f
C4905 OUT_TELESCOPIC.n45 VSS 2.63069f
C4906 OUT_TELESCOPIC.t31 VSS 1.78439f
C4907 OUT_TELESCOPIC.n46 VSS 2.60156f
C4908 OUT_TELESCOPIC.t29 VSS 1.78439f
C4909 OUT_TELESCOPIC.n47 VSS 2.60156f
C4910 OUT_TELESCOPIC.t26 VSS 1.78439f
C4911 OUT_TELESCOPIC.n48 VSS 2.39466f
C4912 OUT_TELESCOPIC.n49 VSS 0.91181f
C4913 OUT_TELESCOPIC.n50 VSS 0.11705f
C4914 OUT_TELESCOPIC.n51 VSS 0.67781f
C4915 OUT_TELESCOPIC.n52 VSS 1.05453f
C4916 OUT_TELESCOPIC.n53 VSS 1.20737f
C4917 OUT_TELESCOPIC.t40 VSS 0.57373f
C4918 OUT_TELESCOPIC.t25 VSS 0.57373f
C4919 OUT_TELESCOPIC.n54 VSS 2.59066f
C4920 OUT_TELESCOPIC.t24 VSS 0.57373f
C4921 OUT_TELESCOPIC.t5 VSS 0.57373f
C4922 OUT_TELESCOPIC.n55 VSS 2.57815f
C4923 OUT_TELESCOPIC.n56 VSS 1.40652f
C4924 OUT_TELESCOPIC.t37 VSS 0.57373f
C4925 OUT_TELESCOPIC.t43 VSS 0.57373f
C4926 OUT_TELESCOPIC.n57 VSS 2.57815f
C4927 OUT_TELESCOPIC.n58 VSS 1.96526f
C4928 OUT_TELESCOPIC.t39 VSS 0.57373f
C4929 OUT_TELESCOPIC.t42 VSS 0.57373f
C4930 OUT_TELESCOPIC.n59 VSS 2.57813f
C4931 OUT_TELESCOPIC.n60 VSS 2.24535f
C4932 OUT_TELESCOPIC.n61 VSS 1.03626f
C4933 OUT_TELESCOPIC.t10 VSS 3.99964f
C4934 OUT_TELESCOPIC.t13 VSS 4.5392f
C4935 OUT_TELESCOPIC.t11 VSS 1.81312f
C4936 OUT_TELESCOPIC.n62 VSS 2.80921f
C4937 OUT_TELESCOPIC.t9 VSS 1.81312f
C4938 OUT_TELESCOPIC.n63 VSS 2.78183f
C4939 OUT_TELESCOPIC.t12 VSS 1.81312f
C4940 OUT_TELESCOPIC.n64 VSS 2.43153f
C4941 OUT_TELESCOPIC.n65 VSS 0.91726f
C4942 OUT_TELESCOPIC.n66 VSS 0.18767f
C4943 OUT_TELESCOPIC.n67 VSS 0.72162f
C4944 OUT_TELESCOPIC.n68 VSS 3.64376f
C4945 OUT_TELESCOPIC.n69 VSS 8.85113f
C4946 programmable_telescopic_cascode_0.programmable_nfet$4_0.g.t6 VSS 0.01261f
C4947 programmable_telescopic_cascode_0.programmable_nfet$4_0.g.t0 VSS 0.01222f
C4948 programmable_telescopic_cascode_0.programmable_nfet$4_0.g.t3 VSS 0.01261f
C4949 programmable_telescopic_cascode_0.programmable_nfet$4_0.g.t7 VSS 0.01221f
C4950 programmable_telescopic_cascode_0.programmable_nfet$4_0.g.n0 VSS 0.04078f
C4951 programmable_telescopic_cascode_0.programmable_nfet$4_0.g.t4 VSS 0.01261f
C4952 programmable_telescopic_cascode_0.programmable_nfet$4_0.g.t8 VSS 0.01221f
C4953 programmable_telescopic_cascode_0.programmable_nfet$4_0.g.n1 VSS 0.04078f
C4954 programmable_telescopic_cascode_0.programmable_nfet$4_0.g.t5 VSS 0.01261f
C4955 programmable_telescopic_cascode_0.programmable_nfet$4_0.g.t1 VSS 0.01222f
C4956 programmable_telescopic_cascode_0.programmable_nfet$4_0.g.n2 VSS 0.0411f
C4957 programmable_telescopic_cascode_0.programmable_nfet$4_0.g.n3 VSS 0.0616f
C4958 programmable_telescopic_cascode_0.programmable_nfet$4_0.g.t12 VSS 1.26387f
C4959 programmable_telescopic_cascode_0.programmable_nfet$4_0.g.t22 VSS 1.28085f
C4960 programmable_telescopic_cascode_0.programmable_nfet$4_0.g.t16 VSS 1.28085f
C4961 programmable_telescopic_cascode_0.programmable_nfet$4_0.g.t21 VSS 1.28085f
C4962 programmable_telescopic_cascode_0.programmable_nfet$4_0.g.t14 VSS 1.28085f
C4963 programmable_telescopic_cascode_0.programmable_nfet$4_0.g.t18 VSS 0.96924f
C4964 programmable_telescopic_cascode_0.programmable_nfet$4_0.g.n4 VSS 0.42892f
C4965 programmable_telescopic_cascode_0.programmable_nfet$4_0.g.t2 VSS 2.01662f
C4966 programmable_telescopic_cascode_0.programmable_nfet$4_0.g.t9 VSS 1.85061f
C4967 programmable_telescopic_cascode_0.programmable_nfet$4_0.g.n5 VSS 0.78289f
C4968 programmable_telescopic_cascode_0.programmable_nfet$4_0.g.t10 VSS 4.74767f
C4969 programmable_telescopic_cascode_0.programmable_nfet$4_0.g.n6 VSS 0.38983f
C4970 programmable_telescopic_cascode_0.programmable_nfet$4_0.g.t20 VSS 1.85596f
C4971 programmable_telescopic_cascode_0.programmable_nfet$4_0.g.n7 VSS 3.1638f
C4972 programmable_telescopic_cascode_0.programmable_nfet$4_0.g.n8 VSS 2.62464f
C4973 programmable_telescopic_cascode_0.programmable_nfet$4_0.g.t23 VSS 1.26387f
C4974 programmable_telescopic_cascode_0.programmable_nfet$4_0.g.t19 VSS 1.28085f
C4975 programmable_telescopic_cascode_0.programmable_nfet$4_0.g.t13 VSS 1.28085f
C4976 programmable_telescopic_cascode_0.programmable_nfet$4_0.g.t17 VSS 1.28085f
C4977 programmable_telescopic_cascode_0.programmable_nfet$4_0.g.t11 VSS 1.28085f
C4978 programmable_telescopic_cascode_0.programmable_nfet$4_0.g.t15 VSS 0.96924f
C4979 programmable_telescopic_cascode_0.programmable_nfet$4_0.g.n9 VSS 0.43294f
C4980 programmable_telescopic_cascode_0.programmable_nfet$4_0.g.n10 VSS 0.0616f
C4981 programmable_telescopic_cascode_0.programmable_nfet$4_0.g.n11 VSS 0.0411f
C4982 programmable_telescopic_cascode_0.programmable_nfet$6_0.d.t14 VSS 1.53682f
C4983 programmable_telescopic_cascode_0.programmable_nfet$6_0.d.t8 VSS 1.41709f
C4984 programmable_telescopic_cascode_0.programmable_nfet$6_0.d.t13 VSS 0.22053f
C4985 programmable_telescopic_cascode_0.programmable_nfet$6_0.d.t10 VSS 0.22053f
C4986 programmable_telescopic_cascode_0.programmable_nfet$6_0.d.n0 VSS 1.08417f
C4987 programmable_telescopic_cascode_0.programmable_nfet$6_0.d.t11 VSS 0.22053f
C4988 programmable_telescopic_cascode_0.programmable_nfet$6_0.d.t12 VSS 0.22053f
C4989 programmable_telescopic_cascode_0.programmable_nfet$6_0.d.n1 VSS 0.44107f
C4990 programmable_telescopic_cascode_0.programmable_nfet$6_0.d.n2 VSS 0.61078f
C4991 programmable_telescopic_cascode_0.programmable_nfet$6_0.d.t6 VSS 1.65974f
C4992 programmable_telescopic_cascode_0.programmable_nfet$6_0.d.t5 VSS 0.71701f
C4993 programmable_telescopic_cascode_0.programmable_nfet$6_0.d.n3 VSS 0.93287f
C4994 programmable_telescopic_cascode_0.programmable_nfet$6_0.d.n4 VSS 0.22518f
C4995 programmable_telescopic_cascode_0.programmable_nfet$6_0.d.t7 VSS 0.71701f
C4996 programmable_telescopic_cascode_0.programmable_nfet$6_0.d.n5 VSS 0.79251f
C4997 programmable_telescopic_cascode_0.programmable_nfet$6_0.d.n6 VSS 0.44189f
C4998 programmable_telescopic_cascode_0.programmable_nfet$6_0.d.n7 VSS 0.34673f
C4999 programmable_telescopic_cascode_0.programmable_nfet$6_0.d.t15 VSS 1.74344f
C5000 programmable_telescopic_cascode_0.programmable_nfet$6_0.d.n8 VSS 0.19942f
C5001 programmable_telescopic_cascode_0.programmable_nfet$6_0.d.t3 VSS 1.74342f
C5002 programmable_telescopic_cascode_0.programmable_nfet$6_0.d.n9 VSS 0.13f
C5003 programmable_telescopic_cascode_0.programmable_nfet$6_0.d.t4 VSS 1.75111f
C5004 programmable_telescopic_cascode_0.programmable_nfet$6_0.d.t9 VSS 1.74342f
C5005 programmable_telescopic_cascode_0.programmable_nfet$6_0.d.n10 VSS 0.13f
C5006 programmable_telescopic_cascode_0.programmable_nfet$6_0.d.t1 VSS 1.74344f
C5007 programmable_telescopic_cascode_0.programmable_nfet$6_0.d.n11 VSS 0.15253f
C5008 programmable_telescopic_cascode_0.programmable_nfet$6_0.d.t2 VSS 1.74343f
C5009 programmable_telescopic_cascode_0.programmable_nfet$6_0.d.n12 VSS 0.19631f
C5010 programmable_telescopic_cascode_0.programmable_nfet$6_0.d.t0 VSS 1.74344f
C5011 programmable_telescopic_cascode_0.programmable_nfet$6_0.d.n13 VSS 0.1942f
C5012 programmable_telescopic_cascode_0.programmable_nfet$6_0.transmission_gate$26_0.out.t2 VSS 0.00403f
C5013 programmable_telescopic_cascode_0.programmable_nfet$6_0.transmission_gate$26_0.out.t0 VSS 0.01035f
C5014 programmable_telescopic_cascode_0.programmable_nfet$6_0.transmission_gate$26_0.out.t5 VSS 0.61068f
C5015 programmable_telescopic_cascode_0.programmable_nfet$6_0.transmission_gate$26_0.out.t3 VSS 0.48846f
C5016 programmable_telescopic_cascode_0.programmable_nfet$6_0.transmission_gate$26_0.out.n0 VSS 0.17681f
C5017 programmable_telescopic_cascode_0.programmable_nfet$6_0.transmission_gate$26_0.out.t4 VSS 0.61068f
C5018 programmable_telescopic_cascode_0.programmable_nfet$6_0.transmission_gate$26_0.out.t6 VSS 0.48846f
C5019 programmable_telescopic_cascode_0.programmable_nfet$6_0.transmission_gate$26_0.out.n1 VSS 0.16566f
C5020 programmable_telescopic_cascode_0.programmable_nfet$6_0.transmission_gate$26_0.out.t1 VSS 0.00377f
C5021 programmable_telescopic_cascode_0.programmable_nfet$6_0.transmission_gate$26_0.out.n2 VSS 0.0242f
C5022 programmable_folded_cascode_0.programmable_pfet_0.g.t15 VSS 0.01452f
C5023 programmable_folded_cascode_0.programmable_pfet_0.g.t18 VSS 0.01398f
C5024 programmable_folded_cascode_0.programmable_pfet_0.g.n0 VSS 0.04539f
C5025 programmable_folded_cascode_0.programmable_pfet_0.g.t17 VSS 0.01452f
C5026 programmable_folded_cascode_0.programmable_pfet_0.g.t12 VSS 0.01399f
C5027 programmable_folded_cascode_0.programmable_pfet_0.g.n1 VSS 0.04519f
C5028 programmable_folded_cascode_0.programmable_pfet_0.g.n2 VSS 1.1119f
C5029 programmable_folded_cascode_0.programmable_pfet_0.g.t20 VSS 1.46307f
C5030 programmable_folded_cascode_0.programmable_pfet_0.g.n3 VSS 1.11193f
C5031 programmable_folded_cascode_0.programmable_pfet_0.g.t35 VSS 1.46307f
C5032 programmable_folded_cascode_0.programmable_pfet_0.g.t4 VSS 1.87627f
C5033 programmable_folded_cascode_0.programmable_pfet_0.g.t2 VSS 1.94005f
C5034 programmable_folded_cascode_0.programmable_pfet_0.g.t10 VSS 1.94005f
C5035 programmable_folded_cascode_0.programmable_pfet_0.g.t6 VSS 1.94005f
C5036 programmable_folded_cascode_0.programmable_pfet_0.g.t8 VSS 1.49637f
C5037 programmable_folded_cascode_0.programmable_pfet_0.g.t5 VSS 1.88852f
C5038 programmable_folded_cascode_0.programmable_pfet_0.g.t3 VSS 0.7661f
C5039 programmable_folded_cascode_0.programmable_pfet_0.g.n4 VSS 1.2382f
C5040 programmable_folded_cascode_0.programmable_pfet_0.g.t11 VSS 0.7661f
C5041 programmable_folded_cascode_0.programmable_pfet_0.g.n5 VSS 1.14044f
C5042 programmable_folded_cascode_0.programmable_pfet_0.g.t0 VSS 2.31279f
C5043 programmable_folded_cascode_0.programmable_pfet_0.g.n6 VSS 0.72974f
C5044 programmable_folded_cascode_0.programmable_pfet_0.g.t7 VSS 0.7661f
C5045 programmable_folded_cascode_0.programmable_pfet_0.g.n7 VSS 0.86952f
C5046 programmable_folded_cascode_0.programmable_pfet_0.g.t9 VSS 0.7661f
C5047 programmable_folded_cascode_0.programmable_pfet_0.g.n8 VSS 1.16038f
C5048 programmable_folded_cascode_0.programmable_pfet_0.g.n9 VSS 2.04456f
C5049 programmable_folded_cascode_0.programmable_pfet_0.g.t34 VSS 2.84017f
C5050 programmable_folded_cascode_0.programmable_pfet_0.g.t33 VSS 2.91467f
C5051 programmable_folded_cascode_0.programmable_pfet_0.g.t38 VSS 2.91467f
C5052 programmable_folded_cascode_0.programmable_pfet_0.g.t19 VSS 2.18075f
C5053 programmable_folded_cascode_0.programmable_pfet_0.g.n10 VSS 1.46307f
C5054 programmable_folded_cascode_0.programmable_pfet_0.g.n11 VSS 2.17731f
C5055 programmable_folded_cascode_0.programmable_pfet_0.g.n12 VSS 1.11193f
C5056 programmable_folded_cascode_0.programmable_pfet_0.g.n13 VSS 1.46307f
C5057 programmable_folded_cascode_0.programmable_pfet_0.g.t23 VSS 1.46307f
C5058 programmable_folded_cascode_0.programmable_pfet_0.g.n14 VSS 1.46307f
C5059 programmable_folded_cascode_0.programmable_pfet_0.g.t25 VSS 1.46307f
C5060 programmable_folded_cascode_0.programmable_pfet_0.g.n15 VSS 1.46307f
C5061 programmable_folded_cascode_0.programmable_pfet_0.g.n16 VSS 1.11193f
C5062 programmable_folded_cascode_0.programmable_pfet_0.g.n17 VSS 1.11193f
C5063 programmable_folded_cascode_0.programmable_pfet_0.g.n18 VSS 1.46307f
C5064 programmable_folded_cascode_0.programmable_pfet_0.g.t36 VSS 1.46307f
C5065 programmable_folded_cascode_0.programmable_pfet_0.g.n19 VSS 1.46307f
C5066 programmable_folded_cascode_0.programmable_pfet_0.g.t21 VSS 1.50572f
C5067 programmable_folded_cascode_0.programmable_pfet_0.g.n20 VSS 1.2628f
C5068 programmable_folded_cascode_0.programmable_pfet_0.g.t14 VSS 0.01452f
C5069 programmable_folded_cascode_0.programmable_pfet_0.g.t16 VSS 0.01398f
C5070 programmable_folded_cascode_0.programmable_pfet_0.g.n21 VSS 0.04539f
C5071 programmable_folded_cascode_0.programmable_pfet_0.g.t1 VSS 0.01452f
C5072 programmable_folded_cascode_0.programmable_pfet_0.g.t13 VSS 0.01399f
C5073 programmable_folded_cascode_0.programmable_pfet_0.g.n22 VSS 0.04519f
C5074 programmable_folded_cascode_0.programmable_pfet_0.g.n23 VSS 0.03268f
C5075 programmable_folded_cascode_0.programmable_pfet_0.g.t31 VSS 2.84017f
C5076 programmable_folded_cascode_0.programmable_pfet_0.g.t37 VSS 2.91467f
C5077 programmable_folded_cascode_0.programmable_pfet_0.g.t26 VSS 2.91467f
C5078 programmable_folded_cascode_0.programmable_pfet_0.g.t27 VSS 2.91447f
C5079 programmable_folded_cascode_0.programmable_pfet_0.g.t22 VSS 2.91447f
C5080 programmable_folded_cascode_0.programmable_pfet_0.g.t30 VSS 2.91447f
C5081 programmable_folded_cascode_0.programmable_pfet_0.g.t32 VSS 2.91447f
C5082 programmable_folded_cascode_0.programmable_pfet_0.g.t28 VSS 2.91447f
C5083 programmable_folded_cascode_0.programmable_pfet_0.g.t24 VSS 2.91447f
C5084 programmable_folded_cascode_0.programmable_pfet_0.g.t29 VSS 2.22421f
C5085 programmable_folded_cascode_0.programmable_pfet_0.g.n24 VSS 1.05221f
C5086 programmable_folded_cascode_0.programmable_pfet_0.g.n25 VSS 0.34037f
C5087 programmable_folded_cascode_0.programmable_pfet_0.g.n26 VSS 0.03268f
C5088 programmable_folded_cascode_0.programmable_pfet_0.transmission_gate$16_0.out.t0 VSS 0.00932f
C5089 programmable_folded_cascode_0.programmable_pfet_0.transmission_gate$16_0.out.t1 VSS 0.00902f
C5090 programmable_folded_cascode_0.programmable_pfet_0.transmission_gate$16_0.out.t2 VSS 0.05652f
C5091 programmable_folded_cascode_0.programmable_pfet_0.transmission_gate$16_0.out.t5 VSS 1.82294f
C5092 programmable_folded_cascode_0.programmable_pfet_0.transmission_gate$16_0.out.t11 VSS 1.87062f
C5093 programmable_folded_cascode_0.programmable_pfet_0.transmission_gate$16_0.out.t12 VSS 1.87075f
C5094 programmable_folded_cascode_0.programmable_pfet_0.transmission_gate$16_0.out.t6 VSS 1.87075f
C5095 programmable_folded_cascode_0.programmable_pfet_0.transmission_gate$16_0.out.t3 VSS 1.87062f
C5096 programmable_folded_cascode_0.programmable_pfet_0.transmission_gate$16_0.out.t9 VSS 1.87062f
C5097 programmable_folded_cascode_0.programmable_pfet_0.transmission_gate$16_0.out.t10 VSS 1.87062f
C5098 programmable_folded_cascode_0.programmable_pfet_0.transmission_gate$16_0.out.t7 VSS 1.87062f
C5099 programmable_folded_cascode_0.programmable_pfet_0.transmission_gate$16_0.out.t4 VSS 1.87062f
C5100 programmable_folded_cascode_0.programmable_pfet_0.transmission_gate$16_0.out.t8 VSS 1.42706f
C5101 programmable_folded_cascode_0.programmable_pfet_0.transmission_gate$16_0.out.n0 VSS 0.62133f
C5102 programmable_folded_cascode_0.programmable_pfet_0.transmission_gate$16_0.out.n1 VSS 0.05857f
C5103 transmission_gate$2$1_7.out.t1 VSS 0.02394f
C5104 transmission_gate$2$1_7.out.t2 VSS 0.02354f
C5105 transmission_gate$2$1_7.out.n0 VSS 0.11965f
C5106 transmission_gate$2$1_7.out.t20 VSS 0.01731f
C5107 transmission_gate$2$1_7.out.t18 VSS 0.02952f
C5108 transmission_gate$2$1_7.out.n1 VSS 0.04936f
C5109 transmission_gate$2$1_7.out.t24 VSS 0.0172f
C5110 transmission_gate$2$1_7.out.n2 VSS 0.03173f
C5111 transmission_gate$2$1_7.out.t8 VSS 0.0401f
C5112 transmission_gate$2$1_7.out.n3 VSS 0.23613f
C5113 transmission_gate$2$1_7.out.t12 VSS 0.0172f
C5114 transmission_gate$2$1_7.out.n4 VSS 0.01776f
C5115 transmission_gate$2$1_7.out.n5 VSS 1.07259f
C5116 transmission_gate$2$1_7.out.t25 VSS 0.0172f
C5117 transmission_gate$2$1_7.out.n6 VSS 0.01776f
C5118 transmission_gate$2$1_7.out.t11 VSS 0.0172f
C5119 transmission_gate$2$1_7.out.n7 VSS 0.01776f
C5120 transmission_gate$2$1_7.out.n8 VSS 1.24842f
C5121 transmission_gate$2$1_7.out.n9 VSS 0.69983f
C5122 transmission_gate$2$1_7.out.t17 VSS 0.0172f
C5123 transmission_gate$2$1_7.out.n10 VSS 0.01776f
C5124 transmission_gate$2$1_7.out.t6 VSS 0.0172f
C5125 transmission_gate$2$1_7.out.n11 VSS 0.01776f
C5126 transmission_gate$2$1_7.out.n12 VSS 1.24842f
C5127 transmission_gate$2$1_7.out.n13 VSS 0.68399f
C5128 transmission_gate$2$1_7.out.t22 VSS 0.0172f
C5129 transmission_gate$2$1_7.out.n14 VSS 0.01776f
C5130 transmission_gate$2$1_7.out.t10 VSS 0.0172f
C5131 transmission_gate$2$1_7.out.n15 VSS 0.01776f
C5132 transmission_gate$2$1_7.out.n16 VSS 1.24841f
C5133 transmission_gate$2$1_7.out.n17 VSS 0.75333f
C5134 transmission_gate$2$1_7.out.t23 VSS 0.0172f
C5135 transmission_gate$2$1_7.out.n18 VSS 0.03173f
C5136 transmission_gate$2$1_7.out.t21 VSS 0.04006f
C5137 transmission_gate$2$1_7.out.n19 VSS 0.34651f
C5138 transmission_gate$2$1_7.out.t7 VSS 0.0172f
C5139 transmission_gate$2$1_7.out.n20 VSS 0.03173f
C5140 transmission_gate$2$1_7.out.t16 VSS 0.04003f
C5141 transmission_gate$2$1_7.out.n21 VSS 0.34689f
C5142 transmission_gate$2$1_7.out.n22 VSS 0.96101f
C5143 transmission_gate$2$1_7.out.n23 VSS 0.85333f
C5144 transmission_gate$2$1_7.out.t5 VSS 0.0172f
C5145 transmission_gate$2$1_7.out.n24 VSS 0.03173f
C5146 transmission_gate$2$1_7.out.t9 VSS 0.03985f
C5147 transmission_gate$2$1_7.out.n25 VSS 5.07857f
C5148 transmission_gate$2$1_7.out.n26 VSS 11.3122f
C5149 transmission_gate$2$1_7.out.n27 VSS 18.203f
C5150 transmission_gate$2$1_7.out.t13 VSS 0.01804f
C5151 transmission_gate$2$1_7.out.t15 VSS 0.0172f
C5152 transmission_gate$2$1_7.out.n28 VSS 0.06193f
C5153 transmission_gate$2$1_7.out.n29 VSS 10.4272f
C5154 transmission_gate$2$1_7.out.t14 VSS 0.01804f
C5155 transmission_gate$2$1_7.out.t19 VSS 0.0172f
C5156 transmission_gate$2$1_7.out.n30 VSS 0.04322f
C5157 transmission_gate$2$1_7.out.n31 VSS 0.01904f
C5158 transmission_gate$2$1_7.out.n32 VSS 0.19026f
C5159 transmission_gate$2$1_7.out.t4 VSS 0.04559f
C5160 transmission_gate$2$1_7.out.t3 VSS 0.04315f
C5161 transmission_gate$2$1_7.out.n33 VSS 0.16603f
C5162 transmission_gate$2$1_7.out.t0 VSS 0.04298f
C5163 transmission_gate$2$1_7.out.n34 VSS 0.13214f
C5164 a_49197_2844.t2 VSS 0.53442f
C5165 a_49197_2844.t3 VSS 0.53442f
C5166 a_49197_2844.t1 VSS 0.53442f
C5167 a_49197_2844.n0 VSS 2.66941f
C5168 a_49197_2844.t49 VSS 3.92307f
C5169 a_49197_2844.t51 VSS 4.88645f
C5170 a_49197_2844.t57 VSS 1.96127f
C5171 a_49197_2844.n1 VSS 3.0732f
C5172 a_49197_2844.t58 VSS 1.96127f
C5173 a_49197_2844.n2 VSS 3.02023f
C5174 a_49197_2844.t52 VSS 1.96127f
C5175 a_49197_2844.n3 VSS 3.02023f
C5176 a_49197_2844.t14 VSS 1.96127f
C5177 a_49197_2844.n4 VSS 3.02011f
C5178 a_49197_2844.t55 VSS 1.96127f
C5179 a_49197_2844.n5 VSS 3.02011f
C5180 a_49197_2844.t56 VSS 1.96127f
C5181 a_49197_2844.n6 VSS 3.02011f
C5182 a_49197_2844.t53 VSS 1.96127f
C5183 a_49197_2844.n7 VSS 3.02011f
C5184 a_49197_2844.t67 VSS 1.96127f
C5185 a_49197_2844.n8 VSS 3.02011f
C5186 a_49197_2844.t54 VSS 1.96127f
C5187 a_49197_2844.n9 VSS 2.80062f
C5188 a_49197_2844.t21 VSS 4.95419f
C5189 a_49197_2844.t61 VSS 1.96127f
C5190 a_49197_2844.n10 VSS 3.14761f
C5191 a_49197_2844.t16 VSS 1.96127f
C5192 a_49197_2844.n11 VSS 3.09124f
C5193 a_49197_2844.t17 VSS 1.96127f
C5194 a_49197_2844.n12 VSS 3.09112f
C5195 a_49197_2844.t59 VSS 1.96127f
C5196 a_49197_2844.n13 VSS 3.09112f
C5197 a_49197_2844.t20 VSS 1.96127f
C5198 a_49197_2844.n14 VSS 3.09112f
C5199 a_49197_2844.t60 VSS 1.96127f
C5200 a_49197_2844.n15 VSS 3.09112f
C5201 a_49197_2844.t18 VSS 1.96127f
C5202 a_49197_2844.n16 VSS 3.09112f
C5203 a_49197_2844.t15 VSS 1.96127f
C5204 a_49197_2844.n17 VSS 3.09112f
C5205 a_49197_2844.t19 VSS 1.96127f
C5206 a_49197_2844.n18 VSS 2.81895f
C5207 a_49197_2844.n19 VSS 0.97756f
C5208 a_49197_2844.t41 VSS 0.61993f
C5209 a_49197_2844.t30 VSS 0.61993f
C5210 a_49197_2844.n20 VSS 1.23986f
C5211 a_49197_2844.n21 VSS 1.66026f
C5212 a_49197_2844.t26 VSS 0.61993f
C5213 a_49197_2844.t36 VSS 0.61993f
C5214 a_49197_2844.n22 VSS 1.23986f
C5215 a_49197_2844.n23 VSS 1.88173f
C5216 a_49197_2844.t23 VSS 0.61993f
C5217 a_49197_2844.t32 VSS 0.61993f
C5218 a_49197_2844.n24 VSS 1.23986f
C5219 a_49197_2844.n25 VSS 1.88173f
C5220 a_49197_2844.t38 VSS 0.61993f
C5221 a_49197_2844.t27 VSS 0.61993f
C5222 a_49197_2844.n26 VSS 1.23986f
C5223 a_49197_2844.n27 VSS 1.51684f
C5224 a_49197_2844.t31 VSS 0.61993f
C5225 a_49197_2844.t22 VSS 0.61993f
C5226 a_49197_2844.n28 VSS 3.06486f
C5227 a_49197_2844.t34 VSS 0.61993f
C5228 a_49197_2844.t39 VSS 0.61993f
C5229 a_49197_2844.n29 VSS 1.23986f
C5230 a_49197_2844.n30 VSS 1.89701f
C5231 a_49197_2844.t25 VSS 0.61993f
C5232 a_49197_2844.t35 VSS 0.61993f
C5233 a_49197_2844.n31 VSS 1.23986f
C5234 a_49197_2844.n32 VSS 1.88185f
C5235 a_49197_2844.t24 VSS 0.61993f
C5236 a_49197_2844.t33 VSS 0.61993f
C5237 a_49197_2844.n33 VSS 1.23986f
C5238 a_49197_2844.n34 VSS 1.88173f
C5239 a_49197_2844.t28 VSS 0.61993f
C5240 a_49197_2844.t37 VSS 0.61993f
C5241 a_49197_2844.n35 VSS 1.23986f
C5242 a_49197_2844.n36 VSS 1.88173f
C5243 a_49197_2844.t40 VSS 0.61993f
C5244 a_49197_2844.t29 VSS 0.61993f
C5245 a_49197_2844.n37 VSS 1.23986f
C5246 a_49197_2844.n38 VSS 1.30719f
C5247 a_49197_2844.n39 VSS 0.99289f
C5248 a_49197_2844.t62 VSS 4.14699f
C5249 a_49197_2844.t65 VSS 1.66886f
C5250 a_49197_2844.n40 VSS 2.6405f
C5251 a_49197_2844.t63 VSS 1.66886f
C5252 a_49197_2844.n41 VSS 2.57871f
C5253 a_49197_2844.t64 VSS 1.66886f
C5254 a_49197_2844.n42 VSS 2.46982f
C5255 a_49197_2844.t8 VSS 4.20122f
C5256 a_49197_2844.t12 VSS 1.66886f
C5257 a_49197_2844.n43 VSS 2.64874f
C5258 a_49197_2844.t9 VSS 1.66886f
C5259 a_49197_2844.n44 VSS 2.62039f
C5260 a_49197_2844.t13 VSS 1.66886f
C5261 a_49197_2844.n45 VSS 2.62039f
C5262 a_49197_2844.t6 VSS 1.66886f
C5263 a_49197_2844.n46 VSS 2.42356f
C5264 a_49197_2844.t42 VSS 4.14699f
C5265 a_49197_2844.t10 VSS 1.66886f
C5266 a_49197_2844.n47 VSS 2.6405f
C5267 a_49197_2844.t43 VSS 1.66886f
C5268 a_49197_2844.n48 VSS 2.57847f
C5269 a_49197_2844.t7 VSS 1.66886f
C5270 a_49197_2844.n49 VSS 2.59912f
C5271 a_49197_2844.t11 VSS 1.66886f
C5272 a_49197_2844.n50 VSS 2.40287f
C5273 a_49197_2844.n51 VSS 0.52853f
C5274 a_49197_2844.t47 VSS 4.14699f
C5275 a_49197_2844.t45 VSS 1.66886f
C5276 a_49197_2844.n52 VSS 2.6405f
C5277 a_49197_2844.t50 VSS 1.66886f
C5278 a_49197_2844.n53 VSS 2.57847f
C5279 a_49197_2844.t44 VSS 1.66886f
C5280 a_49197_2844.n54 VSS 2.59912f
C5281 a_49197_2844.t46 VSS 1.66886f
C5282 a_49197_2844.n55 VSS 2.40287f
C5283 a_49197_2844.n56 VSS 0.59256f
C5284 a_49197_2844.t66 VSS 1.66886f
C5285 a_49197_2844.n57 VSS 1.72178f
C5286 a_49197_2844.n58 VSS 0.80521f
C5287 a_49197_2844.n59 VSS 1.18621f
C5288 a_49197_2844.n60 VSS 1.17576f
C5289 a_49197_2844.t48 VSS 1.7449f
C5290 a_49197_2844.n61 VSS 1.57617f
C5291 a_49197_2844.t4 VSS 4.09702f
C5292 a_49197_2844.t5 VSS 1.7449f
C5293 a_49197_2844.n62 VSS 2.35927f
C5294 a_49197_2844.n63 VSS 0.87297f
C5295 a_49197_2844.n64 VSS 1.46227f
C5296 a_49197_2844.n65 VSS 1.06884f
C5297 a_49197_2844.t0 VSS 0.53442f
C5298 programmable_folded_cascode_0.programmable_pfet_0.transmission_gate$16_1.out.t0 VSS 0.01024f
C5299 programmable_folded_cascode_0.programmable_pfet_0.transmission_gate$16_1.out.t1 VSS 0.00993f
C5300 programmable_folded_cascode_0.programmable_pfet_0.transmission_gate$16_1.out.t2 VSS 0.04036f
C5301 programmable_folded_cascode_0.programmable_pfet_0.transmission_gate$16_1.out.t13 VSS 2.00286f
C5302 programmable_folded_cascode_0.programmable_pfet_0.transmission_gate$16_1.out.t10 VSS 2.05539f
C5303 programmable_folded_cascode_0.programmable_pfet_0.transmission_gate$16_1.out.t19 VSS 2.0554f
C5304 programmable_folded_cascode_0.programmable_pfet_0.transmission_gate$16_1.out.t20 VSS 2.05525f
C5305 programmable_folded_cascode_0.programmable_pfet_0.transmission_gate$16_1.out.t16 VSS 2.05525f
C5306 programmable_folded_cascode_0.programmable_pfet_0.transmission_gate$16_1.out.t4 VSS 2.05525f
C5307 programmable_folded_cascode_0.programmable_pfet_0.transmission_gate$16_1.out.t6 VSS 2.05525f
C5308 programmable_folded_cascode_0.programmable_pfet_0.transmission_gate$16_1.out.t21 VSS 2.05525f
C5309 programmable_folded_cascode_0.programmable_pfet_0.transmission_gate$16_1.out.t18 VSS 2.05525f
C5310 programmable_folded_cascode_0.programmable_pfet_0.transmission_gate$16_1.out.t3 VSS 1.58362f
C5311 programmable_folded_cascode_0.programmable_pfet_0.transmission_gate$16_1.out.n0 VSS 0.61404f
C5312 programmable_folded_cascode_0.programmable_pfet_0.transmission_gate$16_1.out.t22 VSS 2.00286f
C5313 programmable_folded_cascode_0.programmable_pfet_0.transmission_gate$16_1.out.t5 VSS 2.05539f
C5314 programmable_folded_cascode_0.programmable_pfet_0.transmission_gate$16_1.out.t9 VSS 2.0554f
C5315 programmable_folded_cascode_0.programmable_pfet_0.transmission_gate$16_1.out.t11 VSS 2.05525f
C5316 programmable_folded_cascode_0.programmable_pfet_0.transmission_gate$16_1.out.t7 VSS 2.05525f
C5317 programmable_folded_cascode_0.programmable_pfet_0.transmission_gate$16_1.out.t15 VSS 2.05525f
C5318 programmable_folded_cascode_0.programmable_pfet_0.transmission_gate$16_1.out.t17 VSS 2.05525f
C5319 programmable_folded_cascode_0.programmable_pfet_0.transmission_gate$16_1.out.t12 VSS 2.05525f
C5320 programmable_folded_cascode_0.programmable_pfet_0.transmission_gate$16_1.out.t8 VSS 2.05525f
C5321 programmable_folded_cascode_0.programmable_pfet_0.transmission_gate$16_1.out.t14 VSS 1.56791f
C5322 programmable_folded_cascode_0.programmable_pfet_0.transmission_gate$16_1.out.n1 VSS 0.58906f
C5323 programmable_folded_cascode_0.programmable_pfet_0.transmission_gate$16_1.out.n2 VSS 0.06193f
C5324 programmable_5tOTA_0.ena_bar<1>.t6 VSS 0.0179f
C5325 programmable_5tOTA_0.ena_bar<1>.t5 VSS 0.01707f
C5326 programmable_5tOTA_0.ena_bar<1>.n0 VSS 0.173f
C5327 programmable_5tOTA_0.ena_bar<1>.t0 VSS 0.04469f
C5328 programmable_5tOTA_0.ena_bar<1>.t2 VSS 0.04282f
C5329 programmable_5tOTA_0.ena_bar<1>.n1 VSS 0.08159f
C5330 programmable_5tOTA_0.ena_bar<1>.t1 VSS 0.04337f
C5331 programmable_5tOTA_0.ena_bar<1>.n2 VSS 0.09177f
C5332 programmable_5tOTA_0.ena_bar<1>.t3 VSS 0.01863f
C5333 programmable_5tOTA_0.ena_bar<1>.t7 VSS 0.01779f
C5334 programmable_5tOTA_0.ena_bar<1>.n3 VSS 0.03275f
C5335 programmable_5tOTA_0.ena_bar<1>.n4 VSS 0.19346f
C5336 programmable_5tOTA_0.ena_bar<1>.n5 VSS 0.60009f
C5337 programmable_5tOTA_0.ena_bar<1>.t12 VSS 0.01779f
C5338 programmable_5tOTA_0.ena_bar<1>.n6 VSS 0.01853f
C5339 programmable_5tOTA_0.ena_bar<1>.t10 VSS 0.01779f
C5340 programmable_5tOTA_0.ena_bar<1>.n7 VSS 0.01853f
C5341 programmable_5tOTA_0.ena_bar<1>.n8 VSS 0.20732f
C5342 programmable_5tOTA_0.ena_bar<1>.n9 VSS 0.70784f
C5343 programmable_5tOTA_0.ena_bar<1>.t4 VSS 0.01863f
C5344 programmable_5tOTA_0.ena_bar<1>.t8 VSS 0.01779f
C5345 programmable_5tOTA_0.ena_bar<1>.n10 VSS 0.03275f
C5346 programmable_5tOTA_0.ena_bar<1>.n11 VSS 0.16174f
C5347 programmable_5tOTA_0.ena_bar<1>.t9 VSS 0.01863f
C5348 programmable_5tOTA_0.ena_bar<1>.t11 VSS 0.01779f
C5349 programmable_5tOTA_0.ena_bar<1>.n12 VSS 0.03275f
C5350 programmable_5tOTA_0.ena_bar<1>.n13 VSS 0.31978f
C5351 programmable_5tOTA_0.ena_bar<1>.n14 VSS 0.20786f
C5352 programmable_5tOTA_0.ena_bar<1>.n15 VSS 10.8018f
C5353 programmable_5tOTA_0.ena_bar<1>.n16 VSS 8.92657f
C5354 transmission_gate$2$1_2.out.t2 VSS 0.07439f
C5355 transmission_gate$2$1_2.out.t1 VSS 0.07041f
C5356 transmission_gate$2$1_2.out.n0 VSS 0.2709f
C5357 transmission_gate$2$1_2.out.t4 VSS 0.07013f
C5358 transmission_gate$2$1_2.out.n1 VSS 0.2156f
C5359 transmission_gate$2$1_2.out.t7 VSS 0.02824f
C5360 transmission_gate$2$1_2.out.t17 VSS 0.04817f
C5361 transmission_gate$2$1_2.out.n2 VSS 0.07421f
C5362 transmission_gate$2$1_2.out.t15 VSS 0.02807f
C5363 transmission_gate$2$1_2.out.n3 VSS 0.54105f
C5364 transmission_gate$2$1_2.out.n4 VSS 1.7814f
C5365 transmission_gate$2$1_2.out.t16 VSS 0.02807f
C5366 transmission_gate$2$1_2.out.n5 VSS 0.05614f
C5367 transmission_gate$2$1_2.out.t6 VSS 0.06047f
C5368 transmission_gate$2$1_2.out.n6 VSS 0.50682f
C5369 transmission_gate$2$1_2.out.t8 VSS 0.02807f
C5370 transmission_gate$2$1_2.out.n7 VSS 0.05614f
C5371 transmission_gate$2$1_2.out.t14 VSS 0.06047f
C5372 transmission_gate$2$1_2.out.n8 VSS 0.57277f
C5373 transmission_gate$2$1_2.out.n9 VSS 1.13452f
C5374 transmission_gate$2$1_2.out.n10 VSS 0.98655f
C5375 transmission_gate$2$1_2.out.t11 VSS 0.02807f
C5376 transmission_gate$2$1_2.out.n11 VSS 0.18757f
C5377 transmission_gate$2$1_2.out.t9 VSS 0.02807f
C5378 transmission_gate$2$1_2.out.n12 VSS 0.21996f
C5379 transmission_gate$2$1_2.out.n13 VSS 1.36147f
C5380 transmission_gate$2$1_2.out.n14 VSS 17.3195f
C5381 transmission_gate$2$1_2.out.n15 VSS 14.7368f
C5382 transmission_gate$2$1_2.out.t10 VSS 0.02943f
C5383 transmission_gate$2$1_2.out.t12 VSS 0.02807f
C5384 transmission_gate$2$1_2.out.n16 VSS 0.10104f
C5385 transmission_gate$2$1_2.out.n17 VSS 0.145f
C5386 transmission_gate$2$1_2.out.t13 VSS 0.02943f
C5387 transmission_gate$2$1_2.out.t5 VSS 0.02807f
C5388 transmission_gate$2$1_2.out.n18 VSS 0.075f
C5389 transmission_gate$2$1_2.out.n19 VSS 0.17173f
C5390 transmission_gate$2$1_2.out.n20 VSS 0.31044f
C5391 transmission_gate$2$1_2.out.t0 VSS 0.03841f
C5392 transmission_gate$2$1_2.out.n21 VSS 0.19522f
C5393 transmission_gate$2$1_2.out.t3 VSS 0.03906f
C5394 OUT_CS.n0 VSS 0.2031f
C5395 OUT_CS.t36 VSS 0.10538f
C5396 OUT_CS.t27 VSS 0.10538f
C5397 OUT_CS.n1 VSS 0.50704f
C5398 OUT_CS.t42 VSS 0.10538f
C5399 OUT_CS.t43 VSS 0.10538f
C5400 OUT_CS.n2 VSS 0.21077f
C5401 OUT_CS.n3 VSS 0.38661f
C5402 OUT_CS.t41 VSS 0.10538f
C5403 OUT_CS.t32 VSS 0.10538f
C5404 OUT_CS.n4 VSS 0.21077f
C5405 OUT_CS.n5 VSS 0.35425f
C5406 OUT_CS.t30 VSS 0.10538f
C5407 OUT_CS.t39 VSS 0.10538f
C5408 OUT_CS.n6 VSS 0.21077f
C5409 OUT_CS.n7 VSS 0.35425f
C5410 OUT_CS.t24 VSS 0.10538f
C5411 OUT_CS.t33 VSS 0.10538f
C5412 OUT_CS.n8 VSS 0.21077f
C5413 OUT_CS.n9 VSS 0.35425f
C5414 OUT_CS.t37 VSS 0.10538f
C5415 OUT_CS.t28 VSS 0.10538f
C5416 OUT_CS.n10 VSS 0.21077f
C5417 OUT_CS.n11 VSS 0.35425f
C5418 OUT_CS.t25 VSS 0.10538f
C5419 OUT_CS.t34 VSS 0.10538f
C5420 OUT_CS.n12 VSS 0.21077f
C5421 OUT_CS.n13 VSS 0.35425f
C5422 OUT_CS.t38 VSS 0.10538f
C5423 OUT_CS.t29 VSS 0.10538f
C5424 OUT_CS.n14 VSS 0.21077f
C5425 OUT_CS.n15 VSS 0.35425f
C5426 OUT_CS.t31 VSS 0.10538f
C5427 OUT_CS.t40 VSS 0.10538f
C5428 OUT_CS.n16 VSS 0.21077f
C5429 OUT_CS.n17 VSS 0.17846f
C5430 OUT_CS.t0 VSS 1.00927f
C5431 OUT_CS.n18 VSS 1.24106f
C5432 OUT_CS.n19 VSS 0
C5433 OUT_CS.n20 VSS 0.04278f
C5434 OUT_CS.n21 VSS 0.08398f
C5435 OUT_CS.n22 VSS 2.21412f
C5436 OUT_CS.n23 VSS 0.04132f
C5437 OUT_CS.n24 VSS 0.04132f
C5438 OUT_CS.n25 VSS 0.03837f
C5439 OUT_CS.n26 VSS 0.08398f
C5440 OUT_CS.n27 VSS 0.09287f
C5441 OUT_CS.n28 VSS 3.39647f
C5442 OUT_CS.n29 VSS 1.75813f
C5443 OUT_CS.n30 VSS 0.20548f
C5444 OUT_CS.t3 VSS 1.00927f
C5445 OUT_CS.n31 VSS 1.22887f
C5446 OUT_CS.n32 VSS 0.16592f
C5447 OUT_CS.t1 VSS 0.31042f
C5448 OUT_CS.t2 VSS 0.31042f
C5449 OUT_CS.n33 VSS 0.62084f
C5450 OUT_CS.n34 VSS 0.78164f
C5451 OUT_CS.n35 VSS 0.12999f
C5452 OUT_CS.t22 VSS 0.75586f
C5453 OUT_CS.t18 VSS 0.33478f
C5454 OUT_CS.n36 VSS 0.64607f
C5455 OUT_CS.t19 VSS 0.33478f
C5456 OUT_CS.n37 VSS 0.54638f
C5457 OUT_CS.t14 VSS 0.33478f
C5458 OUT_CS.n38 VSS 0.54638f
C5459 OUT_CS.t17 VSS 0.33478f
C5460 OUT_CS.n39 VSS 0.54638f
C5461 OUT_CS.t21 VSS 0.33478f
C5462 OUT_CS.n40 VSS 0.54638f
C5463 OUT_CS.t16 VSS 0.33478f
C5464 OUT_CS.n41 VSS 0.54638f
C5465 OUT_CS.t20 VSS 0.33478f
C5466 OUT_CS.n42 VSS 0.54638f
C5467 OUT_CS.t23 VSS 0.33478f
C5468 OUT_CS.n43 VSS 0.3706f
C5469 OUT_CS.n44 VSS 0.19143f
C5470 OUT_CS.t9 VSS 0.75586f
C5471 OUT_CS.t11 VSS 0.33478f
C5472 OUT_CS.n45 VSS 0.64607f
C5473 OUT_CS.t13 VSS 0.33478f
C5474 OUT_CS.n46 VSS 0.54638f
C5475 OUT_CS.t7 VSS 0.33478f
C5476 OUT_CS.n47 VSS 0.54638f
C5477 OUT_CS.t4 VSS 0.33478f
C5478 OUT_CS.n48 VSS 0.54638f
C5479 OUT_CS.t10 VSS 0.33478f
C5480 OUT_CS.n49 VSS 0.54638f
C5481 OUT_CS.t5 VSS 0.33478f
C5482 OUT_CS.n50 VSS 0.54638f
C5483 OUT_CS.t12 VSS 0.33478f
C5484 OUT_CS.n51 VSS 0.54638f
C5485 OUT_CS.t8 VSS 0.33478f
C5486 OUT_CS.n52 VSS 0.37068f
C5487 OUT_CS.t15 VSS 0.33478f
C5488 OUT_CS.n53 VSS 0.53212f
C5489 OUT_CS.n54 VSS 0.16923f
C5490 OUT_CS.t6 VSS 0.33478f
C5491 OUT_CS.n55 VSS 0.51743f
C5492 OUT_CS.n56 VSS 0.17712f
C5493 OUT_CS.n57 VSS 0.18759f
C5494 OUT_CS.n58 VSS 0.16686f
C5495 OUT_CS.n59 VSS 0.17712f
C5496 OUT_CS.t26 VSS 0.10538f
C5497 OUT_CS.t35 VSS 0.10538f
C5498 OUT_CS.n60 VSS 0.21077f
C5499 OUT_CS.n61 VSS 0.32538f
C5500 OUT_CS.n62 VSS 0.06978f
C5501 programmable_common_source_0.programmable_pfet$5_0.transmission_gate$30_1.out.t1 VSS 0.01437f
C5502 programmable_common_source_0.programmable_pfet$5_0.transmission_gate$30_1.out.t2 VSS 0.09002f
C5503 programmable_common_source_0.programmable_pfet$5_0.transmission_gate$30_1.out.t4 VSS 0.78701f
C5504 programmable_common_source_0.programmable_pfet$5_0.transmission_gate$30_1.out.t8 VSS 0.86315f
C5505 programmable_common_source_0.programmable_pfet$5_0.transmission_gate$30_1.out.t7 VSS 0.86315f
C5506 programmable_common_source_0.programmable_pfet$5_0.transmission_gate$30_1.out.t12 VSS 0.86315f
C5507 programmable_common_source_0.programmable_pfet$5_0.transmission_gate$30_1.out.t9 VSS 0.86315f
C5508 programmable_common_source_0.programmable_pfet$5_0.transmission_gate$30_1.out.t5 VSS 0.86315f
C5509 programmable_common_source_0.programmable_pfet$5_0.transmission_gate$30_1.out.t10 VSS 0.86315f
C5510 programmable_common_source_0.programmable_pfet$5_0.transmission_gate$30_1.out.t6 VSS 0.86315f
C5511 programmable_common_source_0.programmable_pfet$5_0.transmission_gate$30_1.out.t3 VSS 0.86315f
C5512 programmable_common_source_0.programmable_pfet$5_0.transmission_gate$30_1.out.t11 VSS 0.68238f
C5513 programmable_common_source_0.programmable_pfet$5_0.transmission_gate$30_1.out.n0 VSS 0.465f
C5514 programmable_common_source_0.programmable_pfet$5_0.transmission_gate$30_1.out.n1 VSS 0.09334f
C5515 programmable_common_source_0.programmable_pfet$5_0.transmission_gate$30_1.out.t0 VSS 0.01485f
C5516 programmable_5tOTA_0.programmable_pfet$4_1.transmission_gate$27_1.out.t2 VSS 0.00761f
C5517 programmable_5tOTA_0.programmable_pfet$4_1.transmission_gate$27_1.out.t0 VSS 0.00737f
C5518 programmable_5tOTA_0.programmable_pfet$4_1.transmission_gate$27_1.out.t1 VSS 0.0279f
C5519 programmable_5tOTA_0.programmable_pfet$4_1.transmission_gate$27_1.out.t3 VSS 1.06477f
C5520 programmable_5tOTA_0.programmable_pfet$4_1.transmission_gate$27_1.out.t4 VSS 0.82878f
C5521 programmable_5tOTA_0.programmable_pfet$4_1.transmission_gate$27_1.out.n0 VSS 0.46782f
C5522 programmable_5tOTA_0.programmable_pfet$4_1.transmission_gate$27_1.out.n1 VSS 0.07126f
C5523 programmable_5tOTA_0.programmable_pfet$4_0.g.t20 VSS 0.01909f
C5524 programmable_5tOTA_0.programmable_pfet$4_0.g.t6 VSS 0.01982f
C5525 programmable_5tOTA_0.programmable_pfet$4_0.g.n0 VSS 0.0617f
C5526 programmable_5tOTA_0.programmable_pfet$4_0.g.t18 VSS 2.77358f
C5527 programmable_5tOTA_0.programmable_pfet$4_0.g.t16 VSS 2.13129f
C5528 programmable_5tOTA_0.programmable_pfet$4_0.g.t31 VSS 2.77358f
C5529 programmable_5tOTA_0.programmable_pfet$4_0.g.t30 VSS 2.13129f
C5530 programmable_5tOTA_0.programmable_pfet$4_0.g.t27 VSS 0.01982f
C5531 programmable_5tOTA_0.programmable_pfet$4_0.g.t21 VSS 0.01909f
C5532 programmable_5tOTA_0.programmable_pfet$4_0.g.n1 VSS 0.0617f
C5533 programmable_5tOTA_0.programmable_pfet$4_0.g.t28 VSS 0.01982f
C5534 programmable_5tOTA_0.programmable_pfet$4_0.g.t26 VSS 0.01909f
C5535 programmable_5tOTA_0.programmable_pfet$4_0.g.n2 VSS 0.06195f
C5536 programmable_5tOTA_0.programmable_pfet$4_0.g.n3 VSS 0.03908f
C5537 programmable_5tOTA_0.programmable_pfet$4_0.g.n4 VSS 1.01057f
C5538 programmable_5tOTA_0.programmable_pfet$4_0.g.t11 VSS 5.68129f
C5539 programmable_5tOTA_0.programmable_pfet$4_0.g.t10 VSS 2.26397f
C5540 programmable_5tOTA_0.programmable_pfet$4_0.g.n5 VSS 3.21744f
C5541 programmable_5tOTA_0.programmable_pfet$4_0.g.t19 VSS 5.68129f
C5542 programmable_5tOTA_0.programmable_pfet$4_0.g.t17 VSS 2.26397f
C5543 programmable_5tOTA_0.programmable_pfet$4_0.g.n6 VSS 3.16595f
C5544 programmable_5tOTA_0.programmable_pfet$4_0.g.n7 VSS 0.76961f
C5545 programmable_5tOTA_0.programmable_pfet$4_0.g.t12 VSS 0.71762f
C5546 programmable_5tOTA_0.programmable_pfet$4_0.g.t14 VSS 0.71762f
C5547 programmable_5tOTA_0.programmable_pfet$4_0.g.n8 VSS 3.96561f
C5548 programmable_5tOTA_0.programmable_pfet$4_0.g.t13 VSS 0.71762f
C5549 programmable_5tOTA_0.programmable_pfet$4_0.g.t15 VSS 0.71762f
C5550 programmable_5tOTA_0.programmable_pfet$4_0.g.n9 VSS 1.43524f
C5551 programmable_5tOTA_0.programmable_pfet$4_0.g.n10 VSS 2.22997f
C5552 programmable_5tOTA_0.programmable_pfet$4_0.g.n11 VSS 0.51367f
C5553 programmable_5tOTA_0.programmable_pfet$4_0.g.t1 VSS 0.16362f
C5554 programmable_5tOTA_0.programmable_pfet$4_0.g.t0 VSS 0.16362f
C5555 programmable_5tOTA_0.programmable_pfet$4_0.g.n12 VSS 0.43454f
C5556 programmable_5tOTA_0.programmable_pfet$4_0.g.t4 VSS 0.16362f
C5557 programmable_5tOTA_0.programmable_pfet$4_0.g.t2 VSS 0.16362f
C5558 programmable_5tOTA_0.programmable_pfet$4_0.g.n13 VSS 1.06049f
C5559 programmable_5tOTA_0.programmable_pfet$4_0.g.t5 VSS 0.16362f
C5560 programmable_5tOTA_0.programmable_pfet$4_0.g.t3 VSS 0.16362f
C5561 programmable_5tOTA_0.programmable_pfet$4_0.g.n14 VSS 0.32724f
C5562 programmable_5tOTA_0.programmable_pfet$4_0.g.n15 VSS 1.00852f
C5563 programmable_5tOTA_0.programmable_pfet$4_0.g.n16 VSS 0.6537f
C5564 programmable_5tOTA_0.programmable_pfet$4_0.g.t9 VSS 1.15543f
C5565 programmable_5tOTA_0.programmable_pfet$4_0.g.t8 VSS 0.53729f
C5566 programmable_5tOTA_0.programmable_pfet$4_0.g.n17 VSS 0.75222f
C5567 programmable_5tOTA_0.programmable_pfet$4_0.g.t7 VSS 0.93183f
C5568 programmable_5tOTA_0.programmable_pfet$4_0.g.n18 VSS 0.42966f
C5569 programmable_5tOTA_0.programmable_pfet$4_0.g.n19 VSS 0.18502f
C5570 programmable_5tOTA_0.programmable_pfet$4_0.g.t23 VSS 1.15543f
C5571 programmable_5tOTA_0.programmable_pfet$4_0.g.t24 VSS 0.53729f
C5572 programmable_5tOTA_0.programmable_pfet$4_0.g.n20 VSS 0.75222f
C5573 programmable_5tOTA_0.programmable_pfet$4_0.g.t22 VSS 0.93183f
C5574 programmable_5tOTA_0.programmable_pfet$4_0.g.n21 VSS 0.42966f
C5575 programmable_5tOTA_0.programmable_pfet$4_0.g.n22 VSS 0.19454f
C5576 programmable_5tOTA_0.programmable_pfet$4_0.g.n23 VSS 1.28922f
C5577 programmable_5tOTA_0.programmable_pfet$4_0.g.n24 VSS 1.25794f
C5578 programmable_5tOTA_0.programmable_pfet$4_0.g.n25 VSS 1.0584f
C5579 programmable_5tOTA_0.programmable_pfet$4_0.g.n26 VSS 0.03908f
C5580 programmable_5tOTA_0.programmable_pfet$4_0.g.t25 VSS 0.01909f
C5581 programmable_5tOTA_0.programmable_pfet$4_0.g.t29 VSS 0.01982f
C5582 programmable_5tOTA_0.programmable_pfet$4_0.g.n27 VSS 0.06195f
C5583 programmable_common_source_0.EN0.t2 VSS 0.05083f
C5584 programmable_common_source_0.EN0.t1 VSS 0.04998f
C5585 programmable_common_source_0.EN0.n0 VSS 0.25403f
C5586 programmable_common_source_0.EN0.t10 VSS 0.03675f
C5587 programmable_common_source_0.EN0.t8 VSS 0.06268f
C5588 programmable_common_source_0.EN0.n1 VSS 0.10479f
C5589 programmable_common_source_0.EN0.t6 VSS 0.03652f
C5590 programmable_common_source_0.EN0.n2 VSS 0.0377f
C5591 programmable_common_source_0.EN0.t11 VSS 0.03652f
C5592 programmable_common_source_0.EN0.n3 VSS 0.03743f
C5593 programmable_common_source_0.EN0.t13 VSS 0.08658f
C5594 programmable_common_source_0.EN0.n4 VSS 0.26346f
C5595 programmable_common_source_0.EN0.n5 VSS 10.901f
C5596 programmable_common_source_0.EN0.t12 VSS 0.0383f
C5597 programmable_common_source_0.EN0.t5 VSS 0.03652f
C5598 programmable_common_source_0.EN0.n6 VSS 0.13148f
C5599 programmable_common_source_0.EN0.n7 VSS 9.38995f
C5600 programmable_common_source_0.EN0.t7 VSS 0.0383f
C5601 programmable_common_source_0.EN0.t9 VSS 0.03652f
C5602 programmable_common_source_0.EN0.n8 VSS 0.09759f
C5603 programmable_common_source_0.EN0.n9 VSS 0.21919f
C5604 programmable_common_source_0.EN0.n10 VSS 0.40396f
C5605 programmable_common_source_0.EN0.t3 VSS 0.0968f
C5606 programmable_common_source_0.EN0.t4 VSS 0.09162f
C5607 programmable_common_source_0.EN0.n11 VSS 0.35251f
C5608 programmable_common_source_0.EN0.t0 VSS 0.09126f
C5609 programmable_common_source_0.EN0.n12 VSS 0.28055f
C5610 INN_FOLDED.t2 VSS 0.00987f
C5611 INN_FOLDED.t1 VSS 0.0101f
C5612 INN_FOLDED.n0 VSS 0.03424f
C5613 INN_FOLDED.t3 VSS 0.00987f
C5614 INN_FOLDED.t0 VSS 0.01009f
C5615 INN_FOLDED.n1 VSS 0.03402f
C5616 INN_FOLDED.n2 VSS 0.03497f
C5617 INN_FOLDED.n3 VSS 0.62669f
C5618 INN_FOLDED.t5 VSS 0.63389f
C5619 INN_FOLDED.t4 VSS 0.44464f
C5620 INN_FOLDED.n4 VSS 0.43755f
C5621 INN_FOLDED.n5 VSS 0.67368f
C5622 INN_FOLDED.n6 VSS 0
C5623 INN_FOLDED.n7 VSS 0.02744f
C5624 INN_FOLDED.n8 VSS 0.05651f
C5625 INN_FOLDED.n9 VSS 0.11279f
C5626 INN_FOLDED.n10 VSS 0.0265f
C5627 INN_FOLDED.n11 VSS 0.0265f
C5628 INN_FOLDED.n12 VSS 0.02633f
C5629 INN_FOLDED.n13 VSS 0.05651f
C5630 INN_FOLDED.n14 VSS 0.0605f
C5631 INN_FOLDED.n15 VSS 20.3567f
C5632 INN_FOLDED.n16 VSS 11.7209f
C5633 programmable_folded_cascode_0.EN1.t4 VSS 0.02027f
C5634 programmable_folded_cascode_0.EN1.t19 VSS 0.01933f
C5635 programmable_folded_cascode_0.EN1.n0 VSS 0.19588f
C5636 programmable_folded_cascode_0.EN1.t0 VSS 0.0506f
C5637 programmable_folded_cascode_0.EN1.t1 VSS 0.04848f
C5638 programmable_folded_cascode_0.EN1.n1 VSS 0.09238f
C5639 programmable_folded_cascode_0.EN1.t2 VSS 0.04911f
C5640 programmable_folded_cascode_0.EN1.n2 VSS 0.09821f
C5641 programmable_folded_cascode_0.EN1.t7 VSS 0.02014f
C5642 programmable_folded_cascode_0.EN1.n3 VSS 0.13121f
C5643 programmable_folded_cascode_0.EN1.t15 VSS 0.0474f
C5644 programmable_folded_cascode_0.EN1.t20 VSS 0.02014f
C5645 programmable_folded_cascode_0.EN1.n4 VSS 0.03708f
C5646 programmable_folded_cascode_0.EN1.n5 VSS 0.61826f
C5647 programmable_folded_cascode_0.EN1.t9 VSS 0.0474f
C5648 programmable_folded_cascode_0.EN1.t8 VSS 0.02014f
C5649 programmable_folded_cascode_0.EN1.n6 VSS 0.03723f
C5650 programmable_folded_cascode_0.EN1.t6 VSS 0.02014f
C5651 programmable_folded_cascode_0.EN1.t13 VSS 0.0474f
C5652 programmable_folded_cascode_0.EN1.n7 VSS 0.03723f
C5653 programmable_folded_cascode_0.EN1.n8 VSS 0.45676f
C5654 programmable_folded_cascode_0.EN1.n9 VSS 0.78057f
C5655 programmable_folded_cascode_0.EN1.t5 VSS 0.0474f
C5656 programmable_folded_cascode_0.EN1.t16 VSS 0.02014f
C5657 programmable_folded_cascode_0.EN1.n10 VSS 0.03723f
C5658 programmable_folded_cascode_0.EN1.t14 VSS 0.02014f
C5659 programmable_folded_cascode_0.EN1.t17 VSS 0.0474f
C5660 programmable_folded_cascode_0.EN1.n11 VSS 0.03723f
C5661 programmable_folded_cascode_0.EN1.n12 VSS 0.45677f
C5662 programmable_folded_cascode_0.EN1.n13 VSS 0.76875f
C5663 programmable_folded_cascode_0.EN1.t10 VSS 0.0474f
C5664 programmable_folded_cascode_0.EN1.t3 VSS 0.02014f
C5665 programmable_folded_cascode_0.EN1.n14 VSS 0.03723f
C5666 programmable_folded_cascode_0.EN1.t21 VSS 0.02014f
C5667 programmable_folded_cascode_0.EN1.t22 VSS 0.0474f
C5668 programmable_folded_cascode_0.EN1.n15 VSS 0.03723f
C5669 programmable_folded_cascode_0.EN1.n16 VSS 0.45677f
C5670 programmable_folded_cascode_0.EN1.n17 VSS 0.82391f
C5671 programmable_folded_cascode_0.EN1.t18 VSS 0.02014f
C5672 programmable_folded_cascode_0.EN1.n18 VSS 0.02097f
C5673 programmable_folded_cascode_0.EN1.t11 VSS 0.02014f
C5674 programmable_folded_cascode_0.EN1.n19 VSS 0.02097f
C5675 programmable_folded_cascode_0.EN1.n20 VSS 0.45171f
C5676 programmable_folded_cascode_0.EN1.n21 VSS 0.91932f
C5677 programmable_folded_cascode_0.EN1.t12 VSS 0.02014f
C5678 programmable_folded_cascode_0.EN1.n22 VSS 5.06304f
C5679 programmable_folded_cascode_0.EN1.n23 VSS 12.8633f
C5680 programmable_folded_cascode_0.EN1.n24 VSS 19.0726f
C5681 programmable_folded_cascode_0.EN1.n25 VSS 10.3824f
C5682 INN_TELESCOPIC.t2 VSS 0.00726f
C5683 INN_TELESCOPIC.t3 VSS 0.00705f
C5684 INN_TELESCOPIC.n0 VSS 0.02388f
C5685 INN_TELESCOPIC.t0 VSS 0.00726f
C5686 INN_TELESCOPIC.t1 VSS 0.00705f
C5687 INN_TELESCOPIC.n1 VSS 0.02387f
C5688 INN_TELESCOPIC.n2 VSS 0.02889f
C5689 INN_TELESCOPIC.t4 VSS 0.45922f
C5690 INN_TELESCOPIC.n3 VSS 0.42295f
C5691 INN_TELESCOPIC.n4 VSS 0.0016f
C5692 INN_TELESCOPIC.n5 VSS 0.04558f
C5693 INN_TELESCOPIC.n6 VSS 0
C5694 INN_TELESCOPIC.n7 VSS 0.01964f
C5695 INN_TELESCOPIC.n8 VSS 0.04457f
C5696 INN_TELESCOPIC.n9 VSS 0.04968f
C5697 INN_TELESCOPIC.n10 VSS 0.01896f
C5698 INN_TELESCOPIC.n11 VSS 0.01896f
C5699 INN_TELESCOPIC.n12 VSS 0.02077f
C5700 INN_TELESCOPIC.n13 VSS 0.04457f
C5701 INN_TELESCOPIC.n14 VSS 0.0433f
C5702 INN_TELESCOPIC.n15 VSS 7.48344f
C5703 INN_TELESCOPIC.n16 VSS 0.03686f
C5704 INN_TELESCOPIC.n17 VSS 0.02521f
C5705 INN_TELESCOPIC.n18 VSS 0.05051f
C5706 INN_TELESCOPIC.n19 VSS 0.03834f
C5707 INN_TELESCOPIC.n20 VSS 0.0393f
C5708 INN_TELESCOPIC.n21 VSS 0.0016f
C5709 INN_TELESCOPIC.n22 VSS 0.03731f
C5710 INN_TELESCOPIC.n23 VSS 0.01331f
C5711 INN_TELESCOPIC.n24 VSS 0.03348f
C5712 INN_TELESCOPIC.n25 VSS 0.05942f
C5713 INN_TELESCOPIC.n26 VSS 0.0377f
C5714 INN_TELESCOPIC.n27 VSS 7.48384f
C5715 INN_TELESCOPIC.n28 VSS 0.01331f
C5716 INN_TELESCOPIC.n29 VSS 9.58453f
C5717 INN_TELESCOPIC.n30 VSS 2.02178f
C5718 transmission_gate$2$1_4.out.t1 VSS 0.05938f
C5719 transmission_gate$2$1_4.out.t2 VSS 0.0562f
C5720 transmission_gate$2$1_4.out.n0 VSS 0.21625f
C5721 transmission_gate$2$1_4.out.t4 VSS 0.05598f
C5722 transmission_gate$2$1_4.out.n1 VSS 0.1721f
C5723 transmission_gate$2$1_4.out.t9 VSS 0.02254f
C5724 transmission_gate$2$1_4.out.t7 VSS 0.03845f
C5725 transmission_gate$2$1_4.out.n2 VSS 0.06428f
C5726 transmission_gate$2$1_4.out.t22 VSS 0.02349f
C5727 transmission_gate$2$1_4.out.t6 VSS 0.02241f
C5728 transmission_gate$2$1_4.out.n3 VSS 0.08066f
C5729 transmission_gate$2$1_4.out.n4 VSS 0.11487f
C5730 transmission_gate$2$1_4.out.t10 VSS 0.02241f
C5731 transmission_gate$2$1_4.out.n5 VSS 0.17125f
C5732 transmission_gate$2$1_4.out.t15 VSS 0.02241f
C5733 transmission_gate$2$1_4.out.n6 VSS 0.02397f
C5734 transmission_gate$2$1_4.out.n7 VSS 0.00101f
C5735 transmission_gate$2$1_4.out.n8 VSS 0.95971f
C5736 transmission_gate$2$1_4.out.t5 VSS 0.02241f
C5737 transmission_gate$2$1_4.out.n9 VSS 0.02279f
C5738 transmission_gate$2$1_4.out.n10 VSS 0.0022f
C5739 transmission_gate$2$1_4.out.n11 VSS 0.72859f
C5740 transmission_gate$2$1_4.out.t8 VSS 0.02241f
C5741 transmission_gate$2$1_4.out.n12 VSS 0.02431f
C5742 transmission_gate$2$1_4.out.n13 VSS 0.72875f
C5743 transmission_gate$2$1_4.out.t23 VSS 0.02241f
C5744 transmission_gate$2$1_4.out.n14 VSS 0.02296f
C5745 transmission_gate$2$1_4.out.n15 VSS 0.00169f
C5746 transmission_gate$2$1_4.out.n16 VSS 0.39049f
C5747 transmission_gate$2$1_4.out.t14 VSS 0.05346f
C5748 transmission_gate$2$1_4.out.n17 VSS 0.4622f
C5749 transmission_gate$2$1_4.out.t12 VSS 0.02241f
C5750 transmission_gate$2$1_4.out.n18 VSS 0.03738f
C5751 transmission_gate$2$1_4.out.n19 VSS 0.22984f
C5752 transmission_gate$2$1_4.out.t13 VSS 0.05531f
C5753 transmission_gate$2$1_4.out.t11 VSS 0.02241f
C5754 transmission_gate$2$1_4.out.n20 VSS 0.03675f
C5755 transmission_gate$2$1_4.out.n21 VSS 0.38409f
C5756 transmission_gate$2$1_4.out.t19 VSS 0.05531f
C5757 transmission_gate$2$1_4.out.t20 VSS 0.02241f
C5758 transmission_gate$2$1_4.out.n22 VSS 0.03731f
C5759 transmission_gate$2$1_4.out.n23 VSS 0.24571f
C5760 transmission_gate$2$1_4.out.n24 VSS 1.45967f
C5761 transmission_gate$2$1_4.out.t16 VSS 0.05603f
C5762 transmission_gate$2$1_4.out.t17 VSS 0.02241f
C5763 transmission_gate$2$1_4.out.n25 VSS 0.03771f
C5764 transmission_gate$2$1_4.out.n26 VSS 0.22357f
C5765 transmission_gate$2$1_4.out.n27 VSS 0.97343f
C5766 transmission_gate$2$1_4.out.n28 VSS 1.21457f
C5767 transmission_gate$2$1_4.out.n29 VSS 0.6261f
C5768 transmission_gate$2$1_4.out.t18 VSS 0.02349f
C5769 transmission_gate$2$1_4.out.t21 VSS 0.02241f
C5770 transmission_gate$2$1_4.out.n30 VSS 0.05808f
C5771 transmission_gate$2$1_4.out.n31 VSS 0.00985f
C5772 transmission_gate$2$1_4.out.n32 VSS 0.24781f
C5773 transmission_gate$2$1_4.out.t0 VSS 0.03066f
C5774 transmission_gate$2$1_4.out.n33 VSS 0.15583f
C5775 transmission_gate$2$1_4.out.t3 VSS 0.03118f
C5776 transmission_gate$2$1_3.out.t2 VSS 0.08692f
C5777 transmission_gate$2$1_3.out.t1 VSS 0.08226f
C5778 transmission_gate$2$1_3.out.n0 VSS 0.31653f
C5779 transmission_gate$2$1_3.out.t4 VSS 0.08194f
C5780 transmission_gate$2$1_3.out.n1 VSS 0.25191f
C5781 transmission_gate$2$1_3.out.t8 VSS 0.033f
C5782 transmission_gate$2$1_3.out.t5 VSS 0.05628f
C5783 transmission_gate$2$1_3.out.n2 VSS 0.0941f
C5784 transmission_gate$2$1_3.out.t13 VSS 0.03439f
C5785 transmission_gate$2$1_3.out.t16 VSS 0.0328f
C5786 transmission_gate$2$1_3.out.n3 VSS 0.11806f
C5787 transmission_gate$2$1_3.out.n4 VSS 0.15829f
C5788 transmission_gate$2$1_3.out.t14 VSS 0.0328f
C5789 transmission_gate$2$1_3.out.n5 VSS 0.03262f
C5790 transmission_gate$2$1_3.out.n6 VSS 0.40882f
C5791 transmission_gate$2$1_3.out.n7 VSS 1.43277f
C5792 transmission_gate$2$1_3.out.t10 VSS 0.07581f
C5793 transmission_gate$2$1_3.out.t17 VSS 0.0328f
C5794 transmission_gate$2$1_3.out.n8 VSS 0.06049f
C5795 transmission_gate$2$1_3.out.n9 VSS 0.54297f
C5796 transmission_gate$2$1_3.out.t9 VSS 0.07586f
C5797 transmission_gate$2$1_3.out.t6 VSS 0.0328f
C5798 transmission_gate$2$1_3.out.n10 VSS 0.06049f
C5799 transmission_gate$2$1_3.out.n11 VSS 0.55691f
C5800 transmission_gate$2$1_3.out.n12 VSS 1.29388f
C5801 transmission_gate$2$1_3.out.n13 VSS 1.43048f
C5802 transmission_gate$2$1_3.out.t11 VSS 0.0328f
C5803 transmission_gate$2$1_3.out.n14 VSS 0.03262f
C5804 transmission_gate$2$1_3.out.n15 VSS 0.19094f
C5805 transmission_gate$2$1_3.out.t7 VSS 0.0328f
C5806 transmission_gate$2$1_3.out.n16 VSS 0.03361f
C5807 transmission_gate$2$1_3.out.n17 VSS 0.19917f
C5808 transmission_gate$2$1_3.out.n18 VSS 1.58383f
C5809 transmission_gate$2$1_3.out.n19 VSS 22.6295f
C5810 transmission_gate$2$1_3.out.n20 VSS 19.4151f
C5811 transmission_gate$2$1_3.out.t12 VSS 0.03439f
C5812 transmission_gate$2$1_3.out.t15 VSS 0.0328f
C5813 transmission_gate$2$1_3.out.n21 VSS 0.08763f
C5814 transmission_gate$2$1_3.out.n22 VSS 0.20393f
C5815 transmission_gate$2$1_3.out.n23 VSS 0.36272f
C5816 transmission_gate$2$1_3.out.t0 VSS 0.04488f
C5817 transmission_gate$2$1_3.out.n24 VSS 0.2281f
C5818 transmission_gate$2$1_3.out.t3 VSS 0.04564f
C5819 a_45880_2844.t11 VSS 4.446f
C5820 a_45880_2844.t9 VSS 1.76609f
C5821 a_45880_2844.n0 VSS 2.80306f
C5822 a_45880_2844.t19 VSS 1.76609f
C5823 a_45880_2844.n1 VSS 2.77307f
C5824 a_45880_2844.t13 VSS 1.76609f
C5825 a_45880_2844.n2 VSS 2.77307f
C5826 a_45880_2844.t10 VSS 1.76609f
C5827 a_45880_2844.n3 VSS 2.56477f
C5828 a_45880_2844.t15 VSS 4.38861f
C5829 a_45880_2844.t17 VSS 1.76609f
C5830 a_45880_2844.n4 VSS 2.79435f
C5831 a_45880_2844.t14 VSS 1.76609f
C5832 a_45880_2844.n5 VSS 2.7287f
C5833 a_45880_2844.t18 VSS 1.76609f
C5834 a_45880_2844.n6 VSS 2.75056f
C5835 a_45880_2844.t16 VSS 1.76609f
C5836 a_45880_2844.n7 VSS 2.54287f
C5837 a_45880_2844.n8 VSS 0.55933f
C5838 a_45880_2844.t42 VSS 4.38861f
C5839 a_45880_2844.t40 VSS 1.76609f
C5840 a_45880_2844.n9 VSS 2.79435f
C5841 a_45880_2844.t43 VSS 1.76609f
C5842 a_45880_2844.n10 VSS 2.7287f
C5843 a_45880_2844.t41 VSS 1.76609f
C5844 a_45880_2844.n11 VSS 2.75056f
C5845 a_45880_2844.t44 VSS 1.76609f
C5846 a_45880_2844.n12 VSS 2.54287f
C5847 a_45880_2844.n13 VSS 0.62709f
C5848 a_45880_2844.t1 VSS 1.76609f
C5849 a_45880_2844.n14 VSS 1.76341f
C5850 a_45880_2844.t65 VSS 0.56556f
C5851 a_45880_2844.t67 VSS 0.56556f
C5852 a_45880_2844.n15 VSS 2.82494f
C5853 a_45880_2844.t64 VSS 0.56556f
C5854 a_45880_2844.t66 VSS 0.56556f
C5855 a_45880_2844.n16 VSS 1.13112f
C5856 a_45880_2844.n17 VSS 1.54747f
C5857 a_45880_2844.t6 VSS 4.33573f
C5858 a_45880_2844.t5 VSS 1.84656f
C5859 a_45880_2844.n18 VSS 2.49673f
C5860 a_45880_2844.n19 VSS 0.92384f
C5861 a_45880_2844.t8 VSS 1.84656f
C5862 a_45880_2844.n20 VSS 1.60795f
C5863 a_45880_2844.t7 VSS 4.2134f
C5864 a_45880_2844.n21 VSS 1.22768f
C5865 a_45880_2844.t36 VSS 0.65605f
C5866 a_45880_2844.t22 VSS 0.65605f
C5867 a_45880_2844.n22 VSS 3.24343f
C5868 a_45880_2844.t38 VSS 0.65605f
C5869 a_45880_2844.t28 VSS 0.65605f
C5870 a_45880_2844.n23 VSS 1.3121f
C5871 a_45880_2844.n24 VSS 2.00753f
C5872 a_45880_2844.t31 VSS 0.65605f
C5873 a_45880_2844.t21 VSS 0.65605f
C5874 a_45880_2844.n25 VSS 1.3121f
C5875 a_45880_2844.n26 VSS 1.9915f
C5876 a_45880_2844.t30 VSS 0.65605f
C5877 a_45880_2844.t20 VSS 0.65605f
C5878 a_45880_2844.n27 VSS 1.3121f
C5879 a_45880_2844.n28 VSS 1.99136f
C5880 a_45880_2844.t33 VSS 0.65605f
C5881 a_45880_2844.t24 VSS 0.65605f
C5882 a_45880_2844.n29 VSS 1.3121f
C5883 a_45880_2844.n30 VSS 1.99136f
C5884 a_45880_2844.t26 VSS 0.65605f
C5885 a_45880_2844.t35 VSS 0.65605f
C5886 a_45880_2844.n31 VSS 1.3121f
C5887 a_45880_2844.n32 VSS 1.99136f
C5888 a_45880_2844.t25 VSS 0.65605f
C5889 a_45880_2844.t34 VSS 0.65605f
C5890 a_45880_2844.n33 VSS 1.3121f
C5891 a_45880_2844.n34 VSS 1.99136f
C5892 a_45880_2844.t29 VSS 0.65605f
C5893 a_45880_2844.t39 VSS 0.65605f
C5894 a_45880_2844.n35 VSS 1.3121f
C5895 a_45880_2844.n36 VSS 1.99136f
C5896 a_45880_2844.t32 VSS 0.65605f
C5897 a_45880_2844.t23 VSS 0.65605f
C5898 a_45880_2844.n37 VSS 1.3121f
C5899 a_45880_2844.n38 VSS 1.99136f
C5900 a_45880_2844.t27 VSS 0.65605f
C5901 a_45880_2844.t37 VSS 0.65605f
C5902 a_45880_2844.n39 VSS 1.3121f
C5903 a_45880_2844.n40 VSS 1.757f
C5904 a_45880_2844.t50 VSS 5.24284f
C5905 a_45880_2844.t49 VSS 2.07554f
C5906 a_45880_2844.n41 VSS 3.331f
C5907 a_45880_2844.t53 VSS 2.07554f
C5908 a_45880_2844.n42 VSS 3.27135f
C5909 a_45880_2844.t45 VSS 2.07554f
C5910 a_45880_2844.n43 VSS 3.27122f
C5911 a_45880_2844.t51 VSS 2.07554f
C5912 a_45880_2844.n44 VSS 3.27122f
C5913 a_45880_2844.t48 VSS 2.07554f
C5914 a_45880_2844.n45 VSS 3.27122f
C5915 a_45880_2844.t12 VSS 2.07554f
C5916 a_45880_2844.n46 VSS 3.27122f
C5917 a_45880_2844.t46 VSS 2.07554f
C5918 a_45880_2844.n47 VSS 3.27122f
C5919 a_45880_2844.t52 VSS 2.07554f
C5920 a_45880_2844.n48 VSS 3.27122f
C5921 a_45880_2844.t47 VSS 2.07554f
C5922 a_45880_2844.n49 VSS 2.9832f
C5923 a_45880_2844.n50 VSS 1.03452f
C5924 a_45880_2844.t60 VSS 2.07554f
C5925 a_45880_2844.n51 VSS 2.96379f
C5926 a_45880_2844.t57 VSS 2.07554f
C5927 a_45880_2844.n52 VSS 3.19607f
C5928 a_45880_2844.t59 VSS 2.07554f
C5929 a_45880_2844.n53 VSS 3.19607f
C5930 a_45880_2844.t62 VSS 2.07554f
C5931 a_45880_2844.n54 VSS 3.19607f
C5932 a_45880_2844.t61 VSS 2.07554f
C5933 a_45880_2844.n55 VSS 3.19607f
C5934 a_45880_2844.t56 VSS 2.07554f
C5935 a_45880_2844.n56 VSS 2.62966f
C5936 a_45880_2844.t63 VSS 5.17116f
C5937 a_45880_2844.t54 VSS 2.07554f
C5938 a_45880_2844.n57 VSS 3.25226f
C5939 a_45880_2844.t55 VSS 2.07554f
C5940 a_45880_2844.n58 VSS 3.1962f
C5941 a_45880_2844.t58 VSS 2.07554f
C5942 a_45880_2844.n59 VSS 2.76874f
C5943 a_45880_2844.n60 VSS 1.5594f
C5944 a_45880_2844.n61 VSS 1.969f
C5945 a_45880_2844.n62 VSS 0.85232f
C5946 a_45880_2844.t3 VSS 1.76609f
C5947 a_45880_2844.n63 VSS 2.67222f
C5948 a_45880_2844.t4 VSS 4.38861f
C5949 a_45880_2844.t2 VSS 1.76609f
C5950 a_45880_2844.n64 VSS 2.79435f
C5951 a_45880_2844.n65 VSS 2.72896f
C5952 a_45880_2844.t0 VSS 1.76609f
C5953 VDD.t172 VSS 1.02192f
C5954 VDD.t171 VSS 0.40723f
C5955 VDD.n0 VSS 0.48007f
C5956 VDD.t214 VSS 1.02192f
C5957 VDD.t215 VSS 0.40723f
C5958 VDD.n1 VSS 0.57697f
C5959 VDD.t211 VSS 1.02192f
C5960 VDD.t212 VSS 0.40723f
C5961 VDD.n2 VSS 0.57136f
C5962 VDD.n3 VSS 0.12968f
C5963 VDD.t255 VSS 1.02192f
C5964 VDD.t254 VSS 0.40723f
C5965 VDD.n4 VSS 0.57136f
C5966 VDD.n5 VSS 0.08775f
C5967 VDD.n6 VSS 0.14618f
C5968 VDD.t590 VSS 1.02192f
C5969 VDD.t308 VSS 0.40723f
C5970 VDD.n7 VSS 0.48007f
C5971 VDD.t166 VSS 1.02192f
C5972 VDD.t15 VSS 0.40723f
C5973 VDD.n8 VSS 0.57697f
C5974 VDD.t17 VSS 1.02192f
C5975 VDD.t167 VSS 0.40723f
C5976 VDD.n9 VSS 0.57136f
C5977 VDD.n10 VSS 0.12968f
C5978 VDD.t387 VSS 1.02192f
C5979 VDD.t310 VSS 0.40723f
C5980 VDD.n11 VSS 0.57136f
C5981 VDD.n12 VSS 0.08775f
C5982 VDD.n13 VSS 0.14864f
C5983 VDD.n14 VSS 0.18714f
C5984 VDD.n15 VSS 0.0114f
C5985 VDD.n16 VSS 0.00649f
C5986 VDD.n17 VSS 0.31144f
C5987 VDD.n18 VSS 0.01021f
C5988 VDD.n19 VSS 0.01892f
C5989 VDD.n20 VSS 0.01598f
C5990 VDD.n21 VSS 0.05326f
C5991 VDD.t652 VSS 0.07897f
C5992 VDD.t709 VSS 0.07897f
C5993 VDD.n22 VSS 0.05322f
C5994 VDD.n23 VSS 0.05326f
C5995 VDD.t661 VSS 0.07897f
C5996 VDD.t711 VSS 0.07897f
C5997 VDD.n24 VSS 0.05322f
C5998 VDD.n25 VSS 0.06048f
C5999 VDD.n26 VSS 0.02802f
C6000 VDD.t47 VSS 0.07801f
C6001 VDD.n27 VSS 0.05428f
C6002 VDD.t48 VSS 0.00488f
C6003 VDD.n28 VSS 0.01728f
C6004 VDD.n29 VSS 0.028f
C6005 VDD.n30 VSS -0.00164f
C6006 VDD.n31 VSS 0.05436f
C6007 VDD.t63 VSS 0.07801f
C6008 VDD.t712 VSS 0.07801f
C6009 VDD.t548 VSS 0.07801f
C6010 VDD.t549 VSS 0.00488f
C6011 VDD.n32 VSS 0.0173f
C6012 VDD.n33 VSS 0.05428f
C6013 VDD.n34 VSS 0.05436f
C6014 VDD.n35 VSS -0.0017f
C6015 VDD.n36 VSS 0.02802f
C6016 VDD.t484 VSS 0.07801f
C6017 VDD.n37 VSS 0.05428f
C6018 VDD.t485 VSS 0.00488f
C6019 VDD.n38 VSS 0.01728f
C6020 VDD.n39 VSS 0.028f
C6021 VDD.n40 VSS -0.00164f
C6022 VDD.n41 VSS 0.05436f
C6023 VDD.t660 VSS 0.07801f
C6024 VDD.t710 VSS 0.07801f
C6025 VDD.t554 VSS 0.07801f
C6026 VDD.t555 VSS 0.00488f
C6027 VDD.n42 VSS 0.0173f
C6028 VDD.n43 VSS 0.05428f
C6029 VDD.n44 VSS 0.05436f
C6030 VDD.n45 VSS -0.0017f
C6031 VDD.n46 VSS 0.03567f
C6032 VDD.n47 VSS 0.09229f
C6033 VDD.n48 VSS 0.0124f
C6034 VDD.n49 VSS 0.0128f
C6035 VDD.n50 VSS 0.0277f
C6036 VDD.n51 VSS 0.02876f
C6037 VDD.n52 VSS 0.03158f
C6038 VDD.n53 VSS 0
C6039 VDD.n54 VSS 0.03187f
C6040 VDD.n55 VSS 0
C6041 VDD.n56 VSS 0
C6042 VDD.n57 VSS 0.02875f
C6043 VDD.n58 VSS 0.03158f
C6044 VDD.n59 VSS 1.45143f
C6045 VDD.n60 VSS 0.03187f
C6046 VDD.n61 VSS 0.41182f
C6047 VDD.n62 VSS 0.02875f
C6048 VDD.n63 VSS 0.03158f
C6049 VDD.n64 VSS 0.03187f
C6050 VDD.n65 VSS 0.41182f
C6051 VDD.n66 VSS 1.5329f
C6052 VDD.n67 VSS 0
C6053 VDD.n68 VSS 0.02875f
C6054 VDD.n69 VSS 0
C6055 VDD.n70 VSS 0.0277f
C6056 VDD.n71 VSS 0.03158f
C6057 VDD.n72 VSS 0.03187f
C6058 VDD.n73 VSS 0.03187f
C6059 VDD.n74 VSS 0.02876f
C6060 VDD.n75 VSS 0.03158f
C6061 VDD.n76 VSS 0.03187f
C6062 VDD.n77 VSS 0
C6063 VDD.n78 VSS 0.02875f
C6064 VDD.n79 VSS 0.03158f
C6065 VDD.n80 VSS 0.03187f
C6066 VDD.n81 VSS 0
C6067 VDD.n82 VSS 0.02875f
C6068 VDD.n83 VSS 0.03158f
C6069 VDD.n84 VSS 1.5329f
C6070 VDD.n85 VSS 0.03187f
C6071 VDD.n86 VSS 0
C6072 VDD.n87 VSS 0.02875f
C6073 VDD.n88 VSS 0.03158f
C6074 VDD.n89 VSS 1.5329f
C6075 VDD.n90 VSS 0.03187f
C6076 VDD.n91 VSS 0
C6077 VDD.n92 VSS 0.02875f
C6078 VDD.n93 VSS 0.03158f
C6079 VDD.n94 VSS 1.5329f
C6080 VDD.n95 VSS 0.03187f
C6081 VDD.n96 VSS 0
C6082 VDD.n97 VSS 0.02875f
C6083 VDD.n98 VSS 0.03158f
C6084 VDD.n99 VSS 1.5329f
C6085 VDD.n100 VSS 0.03187f
C6086 VDD.n101 VSS 0
C6087 VDD.n102 VSS 0.02875f
C6088 VDD.n103 VSS 0.03158f
C6089 VDD.n104 VSS 1.5329f
C6090 VDD.n105 VSS 0.03187f
C6091 VDD.n106 VSS 0
C6092 VDD.n107 VSS 0.02875f
C6093 VDD.n108 VSS 0.03158f
C6094 VDD.n109 VSS 1.5329f
C6095 VDD.n110 VSS 0.03187f
C6096 VDD.n111 VSS 0
C6097 VDD.n112 VSS 0.02875f
C6098 VDD.n113 VSS 0.03158f
C6099 VDD.n114 VSS 1.5329f
C6100 VDD.n115 VSS 0.03187f
C6101 VDD.n116 VSS 0
C6102 VDD.n117 VSS 0.02875f
C6103 VDD.n118 VSS 0.03158f
C6104 VDD.n119 VSS 1.5329f
C6105 VDD.n120 VSS 0.03187f
C6106 VDD.n121 VSS 0
C6107 VDD.n122 VSS 0.02875f
C6108 VDD.n123 VSS 0.03158f
C6109 VDD.n124 VSS 1.5329f
C6110 VDD.n125 VSS 0.03187f
C6111 VDD.n126 VSS 0
C6112 VDD.n127 VSS 0.02875f
C6113 VDD.n128 VSS 0.03158f
C6114 VDD.n129 VSS 1.5329f
C6115 VDD.n130 VSS 0.03187f
C6116 VDD.n131 VSS 0
C6117 VDD.n132 VSS 0.01321f
C6118 VDD.n133 VSS 0.01452f
C6119 VDD.n134 VSS 0
C6120 VDD.n135 VSS 0
C6121 VDD.n136 VSS 0.02875f
C6122 VDD.n137 VSS 0.03158f
C6123 VDD.n138 VSS 1.40123f
C6124 VDD.n139 VSS 0.03187f
C6125 VDD.n140 VSS 0.41197f
C6126 VDD.n141 VSS 0.02875f
C6127 VDD.n142 VSS 0.03158f
C6128 VDD.n143 VSS 0.03187f
C6129 VDD.n144 VSS 0.41197f
C6130 VDD.n145 VSS 0.01892f
C6131 VDD.n146 VSS 0.00637f
C6132 VDD.n147 VSS 0.01021f
C6133 VDD.n148 VSS 0.0114f
C6134 VDD.n149 VSS 0.04292f
C6135 VDD.n150 VSS 0.05684f
C6136 VDD.t640 VSS 0.07897f
C6137 VDD.t235 VSS 0.07897f
C6138 VDD.n151 VSS 0.05174f
C6139 VDD.n152 VSS 0.06019f
C6140 VDD.n153 VSS 0.0429f
C6141 VDD.n154 VSS 0.05178f
C6142 VDD.t642 VSS 0.07897f
C6143 VDD.t234 VSS 0.07897f
C6144 VDD.n155 VSS 0.05174f
C6145 VDD.n156 VSS 0.0429f
C6146 VDD.n157 VSS 0.01598f
C6147 VDD.n158 VSS 0.00649f
C6148 VDD.n159 VSS 0.01892f
C6149 VDD.n160 VSS 0.00637f
C6150 VDD.n161 VSS 0.01021f
C6151 VDD.n162 VSS 0.00798f
C6152 VDD.n163 VSS 0.01221f
C6153 VDD.t26 VSS 0.07801f
C6154 VDD.t64 VSS 0.07801f
C6155 VDD.n164 VSS 0.0122f
C6156 VDD.n165 VSS 0.01372f
C6157 VDD.t433 VSS 0.07801f
C6158 VDD.t631 VSS 0.09527f
C6159 VDD.t320 VSS 0.0079f
C6160 VDD.n166 VSS 0.00767f
C6161 VDD.n167 VSS 0.00649f
C6162 VDD.n168 VSS 0.01892f
C6163 VDD.n169 VSS 0.0128f
C6164 VDD.n170 VSS 0.28046f
C6165 VDD.n171 VSS 0.00336f
C6166 VDD.n172 VSS 0.00636f
C6167 VDD.t632 VSS 0.00789f
C6168 VDD.n173 VSS 0.01815f
C6169 VDD.n174 VSS 0.05953f
C6170 VDD.n175 VSS 0.05436f
C6171 VDD.n176 VSS 0.01221f
C6172 VDD.t316 VSS 0.0048f
C6173 VDD.n177 VSS 0.01164f
C6174 VDD.t75 VSS 0.0048f
C6175 VDD.n178 VSS 0.01532f
C6176 VDD.t263 VSS 0.0048f
C6177 VDD.n179 VSS 0.01532f
C6178 VDD.n180 VSS 0.00975f
C6179 VDD.t318 VSS 0.0048f
C6180 VDD.n181 VSS 0.013f
C6181 VDD.t182 VSS 0.0048f
C6182 VDD.n182 VSS 0.013f
C6183 VDD.n183 VSS 0.05436f
C6184 VDD.t636 VSS 0.0048f
C6185 VDD.n184 VSS 0.01532f
C6186 VDD.n185 VSS 0.00975f
C6187 VDD.n186 VSS 0.05436f
C6188 VDD.t420 VSS 0.0048f
C6189 VDD.n187 VSS 0.01532f
C6190 VDD.n188 VSS 0.01221f
C6191 VDD.n189 VSS 0.05953f
C6192 VDD.n190 VSS 0.01372f
C6193 VDD.t567 VSS 0.0079f
C6194 VDD.n191 VSS 0.00767f
C6195 VDD.t264 VSS 0.09527f
C6196 VDD.t510 VSS 0.07801f
C6197 VDD.n192 VSS 0.0122f
C6198 VDD.t129 VSS 0.07801f
C6199 VDD.n193 VSS 0.01221f
C6200 VDD.n194 VSS 0.00987f
C6201 VDD.n195 VSS 0.06674f
C6202 VDD.t487 VSS 0.0048f
C6203 VDD.n196 VSS 0.013f
C6204 VDD.n197 VSS 0.05436f
C6205 VDD.n198 VSS 0.0122f
C6206 VDD.t489 VSS 0.0048f
C6207 VDD.n199 VSS 0.01532f
C6208 VDD.n200 VSS 0.05436f
C6209 VDD.t366 VSS 0.0048f
C6210 VDD.n201 VSS 0.013f
C6211 VDD.n202 VSS 0.05436f
C6212 VDD.t386 VSS 0.0048f
C6213 VDD.n203 VSS 0.01532f
C6214 VDD.n204 VSS 0.00975f
C6215 VDD.n205 VSS 0.05436f
C6216 VDD.t646 VSS 0.0048f
C6217 VDD.n206 VSS 0.01532f
C6218 VDD.n207 VSS 0.01221f
C6219 VDD.t88 VSS 0.08758f
C6220 VDD.n208 VSS 0.00468f
C6221 VDD.n209 VSS 0.00127f
C6222 VDD.t72 VSS 0.07801f
C6223 VDD.n210 VSS 0.0122f
C6224 VDD.t421 VSS 0.07801f
C6225 VDD.n211 VSS 0.01221f
C6226 VDD.n212 VSS 0.00602f
C6227 VDD.n213 VSS 0.00273f
C6228 VDD.t70 VSS 0.07801f
C6229 VDD.n214 VSS 0.0122f
C6230 VDD.t494 VSS 0.07801f
C6231 VDD.n215 VSS 0.01221f
C6232 VDD.n216 VSS 0.00987f
C6233 VDD.n217 VSS 0.06674f
C6234 VDD.t33 VSS 0.0048f
C6235 VDD.n218 VSS 0.013f
C6236 VDD.n219 VSS 0.05436f
C6237 VDD.n220 VSS 0.0122f
C6238 VDD.t358 VSS 0.0048f
C6239 VDD.n221 VSS 0.01532f
C6240 VDD.n222 VSS 0.00979f
C6241 VDD.t348 VSS 0.0048f
C6242 VDD.n223 VSS 0.013f
C6243 VDD.n224 VSS 0.05436f
C6244 VDD.t613 VSS 0.0048f
C6245 VDD.n225 VSS 0.01532f
C6246 VDD.n226 VSS 0.00975f
C6247 VDD.n227 VSS 0.05436f
C6248 VDD.t499 VSS 0.0048f
C6249 VDD.n228 VSS 0.01532f
C6250 VDD.t666 VSS 0.07801f
C6251 VDD.t649 VSS 0.07932f
C6252 VDD.t650 VSS 0.0048f
C6253 VDD.n229 VSS 0.07224f
C6254 VDD.t667 VSS 0.0048f
C6255 VDD.n230 VSS 0.013f
C6256 VDD.n231 VSS 0.00979f
C6257 VDD.n232 VSS 0.01221f
C6258 VDD.t665 VSS 0.0048f
C6259 VDD.n233 VSS 0.06992f
C6260 VDD.t664 VSS 0.07932f
C6261 VDD.t498 VSS 0.07801f
C6262 VDD.n234 VSS 0.05436f
C6263 VDD.n235 VSS 0.01224f
C6264 VDD.n236 VSS 0.00528f
C6265 VDD.n237 VSS 0.01372f
C6266 VDD.t610 VSS 0.07801f
C6267 VDD.t353 VSS 0.07801f
C6268 VDD.t350 VSS 0.0079f
C6269 VDD.n238 VSS 0.00767f
C6270 VDD.n239 VSS 0.00273f
C6271 VDD.t357 VSS 0.07801f
C6272 VDD.t351 VSS 0.07762f
C6273 VDD.n240 VSS 0.06139f
C6274 VDD.n241 VSS 0.00713f
C6275 VDD.t352 VSS 0.0048f
C6276 VDD.n242 VSS 0.013f
C6277 VDD.n243 VSS 0.00655f
C6278 VDD.n244 VSS 0.00602f
C6279 VDD.t575 VSS 0.00789f
C6280 VDD.n245 VSS 0.01815f
C6281 VDD.n246 VSS 0.05953f
C6282 VDD.t574 VSS 0.09527f
C6283 VDD.n247 VSS 0.08847f
C6284 VDD.t349 VSS 0.08094f
C6285 VDD.n248 VSS 0.06551f
C6286 VDD.n249 VSS 0.01393f
C6287 VDD.t354 VSS 0.0048f
C6288 VDD.n250 VSS 0.013f
C6289 VDD.t611 VSS 0.0048f
C6290 VDD.n251 VSS 0.01532f
C6291 VDD.n252 VSS 0.00624f
C6292 VDD.n253 VSS 0.01224f
C6293 VDD.n254 VSS 0.0122f
C6294 VDD.n255 VSS 0.05436f
C6295 VDD.t612 VSS 0.07801f
C6296 VDD.t347 VSS 0.07931f
C6297 VDD.n256 VSS 0.07927f
C6298 VDD.t561 VSS 0.0048f
C6299 VDD.n257 VSS 0.013f
C6300 VDD.t312 VSS 0.0048f
C6301 VDD.n258 VSS 0.01532f
C6302 VDD.n259 VSS 0.07923f
C6303 VDD.t311 VSS 0.07931f
C6304 VDD.t560 VSS 0.07801f
C6305 VDD.n260 VSS 0.00975f
C6306 VDD.t569 VSS 0.0048f
C6307 VDD.n261 VSS 0.01532f
C6308 VDD.t106 VSS 0.0048f
C6309 VDD.n262 VSS 0.013f
C6310 VDD.t19 VSS 0.0048f
C6311 VDD.n263 VSS 0.01532f
C6312 VDD.t77 VSS 0.0048f
C6313 VDD.n264 VSS 0.013f
C6314 VDD.n265 VSS 0.00979f
C6315 VDD.n266 VSS 0.00975f
C6316 VDD.t657 VSS 0.0048f
C6317 VDD.n267 VSS 0.01532f
C6318 VDD.t426 VSS 0.0048f
C6319 VDD.n268 VSS 0.013f
C6320 VDD.t625 VSS 0.0048f
C6321 VDD.n269 VSS 0.01532f
C6322 VDD.t452 VSS 0.0048f
C6323 VDD.n270 VSS 0.013f
C6324 VDD.n271 VSS 0.00979f
C6325 VDD.n272 VSS 0.00975f
C6326 VDD.t267 VSS 0.0048f
C6327 VDD.n273 VSS 0.01532f
C6328 VDD.t414 VSS 0.0048f
C6329 VDD.n274 VSS 0.013f
C6330 VDD.n275 VSS 0.00979f
C6331 VDD.t644 VSS 0.0048f
C6332 VDD.n276 VSS 0.013f
C6333 VDD.t37 VSS 0.0048f
C6334 VDD.n277 VSS 0.01532f
C6335 VDD.t643 VSS 0.07801f
C6336 VDD.t36 VSS 0.07931f
C6337 VDD.n278 VSS 0.07907f
C6338 VDD.n279 VSS 0.0791f
C6339 VDD.t413 VSS 0.07931f
C6340 VDD.t266 VSS 0.07801f
C6341 VDD.n280 VSS 0.05436f
C6342 VDD.n281 VSS 0.05436f
C6343 VDD.t451 VSS 0.07801f
C6344 VDD.t624 VSS 0.07931f
C6345 VDD.n282 VSS 0.07923f
C6346 VDD.n283 VSS 0.07927f
C6347 VDD.t425 VSS 0.07931f
C6348 VDD.t656 VSS 0.07801f
C6349 VDD.n284 VSS 0.05436f
C6350 VDD.n285 VSS 0.05436f
C6351 VDD.t76 VSS 0.07801f
C6352 VDD.t18 VSS 0.07931f
C6353 VDD.n286 VSS 0.07907f
C6354 VDD.n287 VSS 0.0791f
C6355 VDD.t105 VSS 0.07931f
C6356 VDD.t568 VSS 0.07801f
C6357 VDD.n288 VSS 0.05436f
C6358 VDD.n289 VSS 0.05436f
C6359 VDD.n290 VSS 0.01221f
C6360 VDD.n291 VSS 0.01224f
C6361 VDD.n292 VSS 0.00624f
C6362 VDD.t393 VSS 0.0048f
C6363 VDD.n293 VSS 0.01532f
C6364 VDD.n294 VSS 0.00624f
C6365 VDD.n295 VSS 0.01224f
C6366 VDD.n296 VSS 0.05436f
C6367 VDD.t392 VSS 0.07801f
C6368 VDD.t32 VSS 0.07801f
C6369 VDD.t103 VSS 0.08053f
C6370 VDD.n297 VSS 0.06551f
C6371 VDD.n298 VSS 0.01393f
C6372 VDD.t104 VSS 0.0079f
C6373 VDD.n299 VSS 0.00767f
C6374 VDD.n300 VSS 0.01372f
C6375 VDD.n301 VSS 0.00468f
C6376 VDD.n302 VSS 0.00187f
C6377 VDD.n303 VSS 0.00127f
C6378 VDD.n304 VSS 0.01202f
C6379 VDD.n305 VSS 0.07796f
C6380 VDD.t83 VSS 0.08758f
C6381 VDD.t101 VSS 0.07995f
C6382 VDD.n306 VSS 0.0876f
C6383 VDD.n307 VSS 0.01001f
C6384 VDD.t102 VSS 0.0048f
C6385 VDD.n308 VSS 0.013f
C6386 VDD.t495 VSS 0.0048f
C6387 VDD.n309 VSS 0.01532f
C6388 VDD.n310 VSS 0.00624f
C6389 VDD.n311 VSS 0.01224f
C6390 VDD.n312 VSS 0.05436f
C6391 VDD.t654 VSS 0.07801f
C6392 VDD.n313 VSS 0.05436f
C6393 VDD.n314 VSS 0.01224f
C6394 VDD.n315 VSS 0.00624f
C6395 VDD.t655 VSS 0.0048f
C6396 VDD.n316 VSS 0.01532f
C6397 VDD.t71 VSS 0.0048f
C6398 VDD.n317 VSS 0.013f
C6399 VDD.n318 VSS 0.00713f
C6400 VDD.t428 VSS 0.0079f
C6401 VDD.n319 VSS 0.00767f
C6402 VDD.n320 VSS 0.01372f
C6403 VDD.n321 VSS 0.01393f
C6404 VDD.n322 VSS 0.06551f
C6405 VDD.t427 VSS 0.08094f
C6406 VDD.n323 VSS 0.08847f
C6407 VDD.t286 VSS 0.09527f
C6408 VDD.t287 VSS 0.00789f
C6409 VDD.n324 VSS 0.01815f
C6410 VDD.n325 VSS 0.05953f
C6411 VDD.t429 VSS 0.07762f
C6412 VDD.n326 VSS 0.06139f
C6413 VDD.n327 VSS 0.00655f
C6414 VDD.t430 VSS 0.0048f
C6415 VDD.n328 VSS 0.013f
C6416 VDD.t422 VSS 0.0048f
C6417 VDD.n329 VSS 0.01532f
C6418 VDD.n330 VSS 0.00624f
C6419 VDD.n331 VSS 0.01224f
C6420 VDD.n332 VSS 0.05436f
C6421 VDD.t570 VSS 0.07801f
C6422 VDD.n333 VSS 0.05436f
C6423 VDD.n334 VSS 0.01224f
C6424 VDD.n335 VSS 0.00624f
C6425 VDD.t571 VSS 0.0048f
C6426 VDD.n336 VSS 0.01532f
C6427 VDD.t73 VSS 0.0048f
C6428 VDD.n337 VSS 0.013f
C6429 VDD.t412 VSS 0.0079f
C6430 VDD.n338 VSS 0.00187f
C6431 VDD.n339 VSS 0.00767f
C6432 VDD.n340 VSS 0.01372f
C6433 VDD.n341 VSS 0.01393f
C6434 VDD.n342 VSS 0.06551f
C6435 VDD.t411 VSS 0.08053f
C6436 VDD.n343 VSS 0.06674f
C6437 VDD.n344 VSS 0.07796f
C6438 VDD.n345 VSS 0.01202f
C6439 VDD.n346 VSS 0.00987f
C6440 VDD.t410 VSS 0.0048f
C6441 VDD.n347 VSS 0.013f
C6442 VDD.n348 VSS 0.01001f
C6443 VDD.n349 VSS 0.0876f
C6444 VDD.t409 VSS 0.07995f
C6445 VDD.t645 VSS 0.07801f
C6446 VDD.n350 VSS 0.05436f
C6447 VDD.n351 VSS 0.01224f
C6448 VDD.n352 VSS 0.00624f
C6449 VDD.n353 VSS 0.01372f
C6450 VDD.t383 VSS 0.07801f
C6451 VDD.t490 VSS 0.07801f
C6452 VDD.t294 VSS 0.09527f
C6453 VDD.t368 VSS 0.0079f
C6454 VDD.n354 VSS 0.00767f
C6455 VDD.t370 VSS 0.0048f
C6456 VDD.n355 VSS 0.013f
C6457 VDD.n356 VSS 0.00655f
C6458 VDD.t488 VSS 0.07801f
C6459 VDD.t369 VSS 0.07762f
C6460 VDD.n357 VSS 0.06139f
C6461 VDD.n358 VSS 0.05953f
C6462 VDD.t295 VSS 0.00789f
C6463 VDD.n359 VSS 0.01815f
C6464 VDD.n360 VSS 0.00602f
C6465 VDD.n361 VSS 0.00713f
C6466 VDD.n362 VSS 0.00273f
C6467 VDD.n363 VSS 0.08847f
C6468 VDD.t367 VSS 0.08094f
C6469 VDD.n364 VSS 0.06551f
C6470 VDD.n365 VSS 0.01393f
C6471 VDD.t491 VSS 0.0048f
C6472 VDD.n366 VSS 0.013f
C6473 VDD.t384 VSS 0.0048f
C6474 VDD.n367 VSS 0.01532f
C6475 VDD.n368 VSS 0.00624f
C6476 VDD.n369 VSS 0.01224f
C6477 VDD.n370 VSS 0.0122f
C6478 VDD.n371 VSS 0.05436f
C6479 VDD.t385 VSS 0.07801f
C6480 VDD.t365 VSS 0.07931f
C6481 VDD.n372 VSS 0.07927f
C6482 VDD.t496 VSS 0.07801f
C6483 VDD.t445 VSS 0.07931f
C6484 VDD.n373 VSS 0.07923f
C6485 VDD.t446 VSS 0.0048f
C6486 VDD.n374 VSS 0.01532f
C6487 VDD.t497 VSS 0.0048f
C6488 VDD.n375 VSS 0.013f
C6489 VDD.t707 VSS 0.0048f
C6490 VDD.n376 VSS 0.01532f
C6491 VDD.t147 VSS 0.0048f
C6492 VDD.n377 VSS 0.013f
C6493 VDD.n378 VSS 0.00979f
C6494 VDD.n379 VSS 0.00975f
C6495 VDD.t202 VSS 0.0048f
C6496 VDD.n380 VSS 0.01532f
C6497 VDD.t565 VSS 0.0048f
C6498 VDD.n381 VSS 0.013f
C6499 VDD.n382 VSS 0.00979f
C6500 VDD.t9 VSS 0.0048f
C6501 VDD.n383 VSS 0.013f
C6502 VDD.t408 VSS 0.0048f
C6503 VDD.n384 VSS 0.01532f
C6504 VDD.t8 VSS 0.07801f
C6505 VDD.t407 VSS 0.07931f
C6506 VDD.n385 VSS 0.07923f
C6507 VDD.n386 VSS 0.07927f
C6508 VDD.t564 VSS 0.07931f
C6509 VDD.t201 VSS 0.07801f
C6510 VDD.n387 VSS 0.05436f
C6511 VDD.n388 VSS 0.05436f
C6512 VDD.t146 VSS 0.07801f
C6513 VDD.t706 VSS 0.07931f
C6514 VDD.n389 VSS 0.07907f
C6515 VDD.n390 VSS 0.05436f
C6516 VDD.t633 VSS 0.07801f
C6517 VDD.t550 VSS 0.07931f
C6518 VDD.n391 VSS 0.0791f
C6519 VDD.t551 VSS 0.0048f
C6520 VDD.n392 VSS 0.013f
C6521 VDD.t634 VSS 0.0048f
C6522 VDD.n393 VSS 0.01532f
C6523 VDD.n394 VSS 0.00975f
C6524 VDD.n395 VSS 0.00979f
C6525 VDD.n396 VSS 0.01221f
C6526 VDD.n397 VSS 0.01224f
C6527 VDD.n398 VSS 0.00624f
C6528 VDD.t269 VSS 0.0048f
C6529 VDD.n399 VSS 0.01532f
C6530 VDD.n400 VSS 0.00624f
C6531 VDD.n401 VSS 0.01224f
C6532 VDD.n402 VSS 0.05436f
C6533 VDD.t268 VSS 0.07801f
C6534 VDD.t486 VSS 0.07801f
C6535 VDD.t539 VSS 0.08053f
C6536 VDD.n403 VSS 0.06551f
C6537 VDD.n404 VSS 0.01393f
C6538 VDD.t540 VSS 0.0079f
C6539 VDD.n405 VSS 0.00767f
C6540 VDD.n406 VSS 0.01372f
C6541 VDD.n407 VSS 0.00468f
C6542 VDD.n408 VSS 0.00187f
C6543 VDD.n409 VSS 0.00127f
C6544 VDD.n410 VSS 0.01202f
C6545 VDD.n411 VSS 0.07796f
C6546 VDD.t87 VSS 0.08758f
C6547 VDD.t552 VSS 0.07995f
C6548 VDD.n412 VSS 0.0876f
C6549 VDD.n413 VSS 0.01001f
C6550 VDD.t553 VSS 0.0048f
C6551 VDD.n414 VSS 0.013f
C6552 VDD.t130 VSS 0.0048f
C6553 VDD.n415 VSS 0.01532f
C6554 VDD.n416 VSS 0.00624f
C6555 VDD.n417 VSS 0.01224f
C6556 VDD.n418 VSS 0.05436f
C6557 VDD.t199 VSS 0.07801f
C6558 VDD.n419 VSS 0.05436f
C6559 VDD.n420 VSS 0.01224f
C6560 VDD.n421 VSS 0.00624f
C6561 VDD.t200 VSS 0.0048f
C6562 VDD.n422 VSS 0.01532f
C6563 VDD.t511 VSS 0.0048f
C6564 VDD.n423 VSS 0.013f
C6565 VDD.n424 VSS 0.01393f
C6566 VDD.n425 VSS 0.06551f
C6567 VDD.t566 VSS 0.08094f
C6568 VDD.n426 VSS 0.08847f
C6569 VDD.n427 VSS 0.00273f
C6570 VDD.n428 VSS 0.00713f
C6571 VDD.t265 VSS 0.00789f
C6572 VDD.n429 VSS 0.01815f
C6573 VDD.n430 VSS 0.00602f
C6574 VDD.t563 VSS 0.0048f
C6575 VDD.n431 VSS 0.013f
C6576 VDD.n432 VSS 0.00655f
C6577 VDD.n433 VSS 0.06139f
C6578 VDD.t562 VSS 0.07762f
C6579 VDD.t419 VSS 0.07801f
C6580 VDD.n434 VSS 0.05436f
C6581 VDD.n435 VSS 0.01224f
C6582 VDD.n436 VSS 0.00624f
C6583 VDD.n437 VSS 0.01372f
C6584 VDD.t290 VSS 0.07801f
C6585 VDD.t49 VSS 0.07801f
C6586 VDD.n438 VSS 0.07796f
C6587 VDD.t222 VSS 0.0079f
C6588 VDD.n439 VSS 0.00767f
C6589 VDD.n440 VSS 0.00187f
C6590 VDD.n441 VSS 0.00468f
C6591 VDD.n442 VSS 0.01598f
C6592 VDD.n443 VSS 0.00649f
C6593 VDD.n444 VSS 0.01892f
C6594 VDD.n445 VSS 0.36773f
C6595 VDD.n446 VSS 0.02432f
C6596 VDD.n447 VSS 0.01024f
C6597 VDD.t56 VSS 0.0048f
C6598 VDD.n448 VSS 0.00958f
C6599 VDD.t85 VSS 0.08758f
C6600 VDD.t55 VSS 0.07995f
C6601 VDD.n449 VSS 0.0876f
C6602 VDD.n450 VSS 0.01001f
C6603 VDD.n451 VSS 0.00987f
C6604 VDD.n452 VSS 0.01202f
C6605 VDD.n453 VSS 0.00127f
C6606 VDD.n454 VSS 0.06674f
C6607 VDD.t221 VSS 0.08053f
C6608 VDD.n455 VSS 0.06551f
C6609 VDD.n456 VSS 0.01393f
C6610 VDD.t50 VSS 0.0048f
C6611 VDD.n457 VSS 0.013f
C6612 VDD.t291 VSS 0.0048f
C6613 VDD.n458 VSS 0.01532f
C6614 VDD.n459 VSS 0.00624f
C6615 VDD.n460 VSS 0.01224f
C6616 VDD.n461 VSS 0.0122f
C6617 VDD.n462 VSS 0.05436f
C6618 VDD.t635 VSS 0.07801f
C6619 VDD.t181 VSS 0.07931f
C6620 VDD.n463 VSS 0.0791f
C6621 VDD.t67 VSS 0.0048f
C6622 VDD.n464 VSS 0.01532f
C6623 VDD.n465 VSS 0.00975f
C6624 VDD.n466 VSS 0.00979f
C6625 VDD.t404 VSS 0.0048f
C6626 VDD.n467 VSS 0.013f
C6627 VDD.t659 VSS 0.0048f
C6628 VDD.n468 VSS 0.01532f
C6629 VDD.n469 VSS 0.07907f
C6630 VDD.t658 VSS 0.07931f
C6631 VDD.t403 VSS 0.07801f
C6632 VDD.n470 VSS 0.05436f
C6633 VDD.n471 VSS 0.05436f
C6634 VDD.t66 VSS 0.07801f
C6635 VDD.t317 VSS 0.07931f
C6636 VDD.n472 VSS 0.07927f
C6637 VDD.n473 VSS 0.00979f
C6638 VDD.t69 VSS 0.0048f
C6639 VDD.n474 VSS 0.013f
C6640 VDD.t314 VSS 0.0048f
C6641 VDD.n475 VSS 0.01532f
C6642 VDD.n476 VSS 0.07923f
C6643 VDD.t313 VSS 0.07931f
C6644 VDD.t68 VSS 0.07801f
C6645 VDD.n477 VSS 0.05436f
C6646 VDD.t628 VSS 0.0048f
C6647 VDD.n478 VSS 0.01532f
C6648 VDD.t474 VSS 0.0048f
C6649 VDD.n479 VSS 0.013f
C6650 VDD.t639 VSS 0.0048f
C6651 VDD.n480 VSS 0.01532f
C6652 VDD.n481 VSS 0.05436f
C6653 VDD.n482 VSS 0.01224f
C6654 VDD.t406 VSS 0.0048f
C6655 VDD.n483 VSS 0.013f
C6656 VDD.t298 VSS 0.0048f
C6657 VDD.n484 VSS 0.01532f
C6658 VDD.n485 VSS 0.05436f
C6659 VDD.n486 VSS 0.00804f
C6660 VDD.n487 VSS 0.00649f
C6661 VDD.n488 VSS 0.01021f
C6662 VDD.n489 VSS 0.01892f
C6663 VDD.n490 VSS 0.01598f
C6664 VDD.n491 VSS 0.0128f
C6665 VDD.n492 VSS 0.01021f
C6666 VDD.n493 VSS 0.01892f
C6667 VDD.n494 VSS 0.01077f
C6668 VDD.n495 VSS 0.01598f
C6669 VDD.n496 VSS 0.90422f
C6670 VDD.n497 VSS 0.00637f
C6671 VDD.n498 VSS 0.00988f
C6672 VDD.n499 VSS 0.00966f
C6673 VDD.t42 VSS 0.07801f
C6674 VDD.n500 VSS 0.05436f
C6675 VDD.t5 VSS 0.0048f
C6676 VDD.n501 VSS 0.02198f
C6677 VDD.t513 VSS 0.0048f
C6678 VDD.n502 VSS 0.02189f
C6679 VDD.n503 VSS 0.0114f
C6680 VDD.n504 VSS 0.00649f
C6681 VDD.n505 VSS 0.28239f
C6682 VDD.n506 VSS 0.01021f
C6683 VDD.n507 VSS 0.01892f
C6684 VDD.n508 VSS 0.01598f
C6685 VDD.n509 VSS 0.0128f
C6686 VDD.n510 VSS 0.0277f
C6687 VDD.n511 VSS 0.41405f
C6688 VDD.n512 VSS 0.03158f
C6689 VDD.n513 VSS 0
C6690 VDD.n514 VSS 0.03187f
C6691 VDD.n515 VSS 0.02875f
C6692 VDD.n516 VSS 0
C6693 VDD.n517 VSS 0
C6694 VDD.n518 VSS 0.02875f
C6695 VDD.n519 VSS 0.03158f
C6696 VDD.n520 VSS 1.5329f
C6697 VDD.n521 VSS 0.03187f
C6698 VDD.n522 VSS 0.43714f
C6699 VDD.n523 VSS 0.01892f
C6700 VDD.n524 VSS 0.00637f
C6701 VDD.n525 VSS 0.01021f
C6702 VDD.n526 VSS 0.0114f
C6703 VDD.t29 VSS 0.00488f
C6704 VDD.n527 VSS 0.01734f
C6705 VDD.n528 VSS 0.05428f
C6706 VDD.n529 VSS 0.01798f
C6707 VDD.n530 VSS 0.01739f
C6708 VDD.t114 VSS 0.07801f
C6709 VDD.t245 VSS 0.07801f
C6710 VDD.n531 VSS -0.00166f
C6711 VDD.n532 VSS 0.05436f
C6712 VDD.t459 VSS 0.07801f
C6713 VDD.t120 VSS 0.07801f
C6714 VDD.n533 VSS 0.05428f
C6715 VDD.n534 VSS 0.00954f
C6716 VDD.t121 VSS 0.0048f
C6717 VDD.n535 VSS 0.01422f
C6718 VDD.n536 VSS 7.82318f
C6719 VDD.t99 VSS 8.7024f
C6720 VDD.t95 VSS 9.61987f
C6721 VDD.t155 VSS 9.6392f
C6722 VDD.t543 VSS 11.2909f
C6723 VDD.n537 VSS 7.9787f
C6724 VDD.n538 VSS 0.09144f
C6725 VDD.n539 VSS 0.16037f
C6726 VDD.t156 VSS 0.69617f
C6727 VDD.t98 VSS 0.69617f
C6728 VDD.t96 VSS 0.81532f
C6729 VDD.t521 VSS 0.32661f
C6730 VDD.n540 VSS 0.50874f
C6731 VDD.t97 VSS 0.32661f
C6732 VDD.n541 VSS 0.50199f
C6733 VDD.t690 VSS 0.32661f
C6734 VDD.n542 VSS 0.50199f
C6735 VDD.t691 VSS 0.32661f
C6736 VDD.n543 VSS 0.45484f
C6737 VDD.n544 VSS 0.17417f
C6738 VDD.t109 VSS 0.69617f
C6739 VDD.t100 VSS 0.81532f
C6740 VDD.t112 VSS 0.32661f
C6741 VDD.n545 VSS 0.50874f
C6742 VDD.t692 VSS 0.32661f
C6743 VDD.n546 VSS 0.50199f
C6744 VDD.t110 VSS 0.32661f
C6745 VDD.n547 VSS 0.50199f
C6746 VDD.t111 VSS 0.32661f
C6747 VDD.n548 VSS 0.45484f
C6748 VDD.n549 VSS 0.17304f
C6749 VDD.n550 VSS 0.02035f
C6750 VDD.t544 VSS 0.69612f
C6751 VDD.t722 VSS 0.81532f
C6752 VDD.t547 VSS 0.32661f
C6753 VDD.n551 VSS 0.50874f
C6754 VDD.t723 VSS 0.32661f
C6755 VDD.n552 VSS 0.50199f
C6756 VDD.t545 VSS 0.32661f
C6757 VDD.n553 VSS 0.50199f
C6758 VDD.t546 VSS 0.32661f
C6759 VDD.n554 VSS 0.45488f
C6760 VDD.n555 VSS 0.17578f
C6761 VDD.n556 VSS 0.03018f
C6762 VDD.n557 VSS 0.11611f
C6763 VDD.t175 VSS 0.81532f
C6764 VDD.t159 VSS 0.32661f
C6765 VDD.n558 VSS 0.50874f
C6766 VDD.t177 VSS 0.32661f
C6767 VDD.n559 VSS 0.50199f
C6768 VDD.t157 VSS 0.32661f
C6769 VDD.n560 VSS 0.50199f
C6770 VDD.t158 VSS 0.32661f
C6771 VDD.n561 VSS 0.40279f
C6772 VDD.n562 VSS 0.10899f
C6773 VDD.n563 VSS 0.05756f
C6774 VDD.t242 VSS 0.69617f
C6775 VDD.t23 VSS 0.69612f
C6776 VDD.t44 VSS 0.81532f
C6777 VDD.t43 VSS 0.32661f
C6778 VDD.n564 VSS 0.50874f
C6779 VDD.t45 VSS 0.32661f
C6780 VDD.n565 VSS 0.50199f
C6781 VDD.t24 VSS 0.32661f
C6782 VDD.n566 VSS 0.50199f
C6783 VDD.t25 VSS 0.32661f
C6784 VDD.n567 VSS 0.45488f
C6785 VDD.n568 VSS 0.17578f
C6786 VDD.t176 VSS 0.69617f
C6787 VDD.t161 VSS 0.81532f
C6788 VDD.t180 VSS 0.32661f
C6789 VDD.n569 VSS 0.50874f
C6790 VDD.t162 VSS 0.32661f
C6791 VDD.n570 VSS 0.50199f
C6792 VDD.t178 VSS 0.32661f
C6793 VDD.n571 VSS 0.50199f
C6794 VDD.t179 VSS 0.32661f
C6795 VDD.n572 VSS 0.45484f
C6796 VDD.n573 VSS 0.17304f
C6797 VDD.n574 VSS 0.03018f
C6798 VDD.t671 VSS 0.69617f
C6799 VDD.t240 VSS 0.81532f
C6800 VDD.t252 VSS 0.32661f
C6801 VDD.n575 VSS 0.50874f
C6802 VDD.t241 VSS 0.32661f
C6803 VDD.n576 VSS 0.50199f
C6804 VDD.t673 VSS 0.32661f
C6805 VDD.n577 VSS 0.50199f
C6806 VDD.t251 VSS 0.32661f
C6807 VDD.n578 VSS 0.45484f
C6808 VDD.n579 VSS 0.17304f
C6809 VDD.n580 VSS 0.02035f
C6810 VDD.n581 VSS 0.11724f
C6811 VDD.t672 VSS 0.81532f
C6812 VDD.t238 VSS 0.32661f
C6813 VDD.n582 VSS 0.50874f
C6814 VDD.t250 VSS 0.32661f
C6815 VDD.n583 VSS 0.50199f
C6816 VDD.t243 VSS 0.32661f
C6817 VDD.n584 VSS 0.50199f
C6818 VDD.t244 VSS 0.32661f
C6819 VDD.n585 VSS 0.40279f
C6820 VDD.n586 VSS 0.10915f
C6821 VDD.t237 VSS 7.07469f
C6822 VDD.t22 VSS 11.2909f
C6823 VDD.n587 VSS 7.9787f
C6824 VDD.t239 VSS 8.7024f
C6825 VDD.t160 VSS 9.6392f
C6826 VDD.n588 VSS 7.97017f
C6827 VDD.n589 VSS 0.12438f
C6828 VDD.n590 VSS 5.22705f
C6829 VDD.n591 VSS 0.03134f
C6830 VDD.n592 VSS 0.21489f
C6831 VDD.n593 VSS 0.1971f
C6832 VDD.t460 VSS 0.0048f
C6833 VDD.n594 VSS 0.01409f
C6834 VDD.n595 VSS 0.0095f
C6835 VDD.n596 VSS 0.01598f
C6836 VDD.n597 VSS 0.00649f
C6837 VDD.n598 VSS 0.01892f
C6838 VDD.n599 VSS 0.00637f
C6839 VDD.n600 VSS 0.01021f
C6840 VDD.t302 VSS 0.0048f
C6841 VDD.n601 VSS 0.01532f
C6842 VDD.n602 VSS 0.0122f
C6843 VDD.n603 VSS 0.05436f
C6844 VDD.t375 VSS 0.08094f
C6845 VDD.t54 VSS 0.0048f
C6846 VDD.n604 VSS 0.013f
C6847 VDD.n605 VSS 0.00713f
C6848 VDD.t376 VSS 0.0079f
C6849 VDD.n606 VSS 0.06139f
C6850 VDD.n607 VSS 0.00649f
C6851 VDD.n608 VSS 0.01892f
C6852 VDD.n609 VSS 0.0128f
C6853 VDD.n610 VSS 1.20642f
C6854 VDD.n611 VSS 0.01221f
C6855 VDD.t373 VSS 0.07762f
C6856 VDD.t270 VSS 0.07801f
C6857 VDD.t576 VSS 0.07801f
C6858 VDD.n612 VSS 0.0122f
C6859 VDD.n613 VSS 0.01372f
C6860 VDD.t558 VSS 0.07801f
C6861 VDD.n614 VSS 0.07796f
C6862 VDD.t684 VSS 0.0079f
C6863 VDD.n615 VSS 0.00767f
C6864 VDD.n616 VSS 0.00187f
C6865 VDD.n617 VSS 0.00468f
C6866 VDD.n618 VSS 0.00667f
C6867 VDD.n619 VSS 0.01262f
C6868 VDD.n620 VSS 0.01892f
C6869 VDD.n621 VSS 0.0128f
C6870 VDD.n622 VSS 0.0277f
C6871 VDD.n623 VSS 0.41167f
C6872 VDD.n624 VSS 0.03158f
C6873 VDD.n625 VSS 0.41242f
C6874 VDD.n626 VSS 0.02875f
C6875 VDD.n627 VSS 0
C6876 VDD.n628 VSS 0
C6877 VDD.n629 VSS 0.0277f
C6878 VDD.n630 VSS 0.41167f
C6879 VDD.n631 VSS 0.03158f
C6880 VDD.n632 VSS 0.41242f
C6881 VDD.n633 VSS 0.02875f
C6882 VDD.n634 VSS 0
C6883 VDD.n635 VSS 0
C6884 VDD.n636 VSS 0.0277f
C6885 VDD.n637 VSS 0.41167f
C6886 VDD.n638 VSS 0.03158f
C6887 VDD.n639 VSS 0.41242f
C6888 VDD.n640 VSS 0.02875f
C6889 VDD.n641 VSS 0
C6890 VDD.n642 VSS 0
C6891 VDD.n643 VSS 0.0277f
C6892 VDD.n644 VSS 0.41167f
C6893 VDD.n645 VSS 0.03158f
C6894 VDD.n646 VSS 0.41242f
C6895 VDD.n647 VSS 0.02875f
C6896 VDD.n648 VSS 0
C6897 VDD.n649 VSS 0
C6898 VDD.n650 VSS 0.0277f
C6899 VDD.n651 VSS 0.41167f
C6900 VDD.n652 VSS 0.03158f
C6901 VDD.n653 VSS 0.41242f
C6902 VDD.n654 VSS 0.02875f
C6903 VDD.n655 VSS 0
C6904 VDD.n656 VSS 0
C6905 VDD.n657 VSS 0.0277f
C6906 VDD.n658 VSS 0.41167f
C6907 VDD.n659 VSS 0.03158f
C6908 VDD.n660 VSS 0.41242f
C6909 VDD.n661 VSS 0.02875f
C6910 VDD.n662 VSS 0
C6911 VDD.n663 VSS 0
C6912 VDD.n664 VSS 0.0277f
C6913 VDD.n665 VSS 0
C6914 VDD.n666 VSS 0.0277f
C6915 VDD.n667 VSS 0.03187f
C6916 VDD.n668 VSS 0.03158f
C6917 VDD.n669 VSS 1.98359f
C6918 VDD.n670 VSS 0.43714f
C6919 VDD.n671 VSS 0.03187f
C6920 VDD.n672 VSS 0.02875f
C6921 VDD.n673 VSS 0.03158f
C6922 VDD.n674 VSS 0.03187f
C6923 VDD.n675 VSS 0.41197f
C6924 VDD.n676 VSS 1.36594f
C6925 VDD.n677 VSS 0
C6926 VDD.n678 VSS 0.02875f
C6927 VDD.n679 VSS 0
C6928 VDD.n680 VSS 0.0277f
C6929 VDD.n681 VSS 0.03187f
C6930 VDD.n682 VSS 0.03158f
C6931 VDD.n683 VSS 1.61839f
C6932 VDD.n684 VSS 0.41197f
C6933 VDD.n685 VSS 0.03187f
C6934 VDD.n686 VSS 0.02875f
C6935 VDD.n687 VSS 0.03158f
C6936 VDD.n688 VSS 0.03187f
C6937 VDD.n689 VSS 0.43714f
C6938 VDD.n690 VSS 1.7511f
C6939 VDD.n691 VSS 0
C6940 VDD.n692 VSS 0.02875f
C6941 VDD.n693 VSS 0
C6942 VDD.n694 VSS 0.0277f
C6943 VDD.n695 VSS 0.03187f
C6944 VDD.n696 VSS 0.03158f
C6945 VDD.n697 VSS 1.36594f
C6946 VDD.n698 VSS 0.41435f
C6947 VDD.n699 VSS 0.03187f
C6948 VDD.n700 VSS 0.02875f
C6949 VDD.n701 VSS 0.03158f
C6950 VDD.n702 VSS 0.03187f
C6951 VDD.n703 VSS 0.41197f
C6952 VDD.n704 VSS 1.45143f
C6953 VDD.n705 VSS 0
C6954 VDD.n706 VSS 0.02875f
C6955 VDD.n707 VSS 0
C6956 VDD.n708 VSS 0.0277f
C6957 VDD.n709 VSS 0.03187f
C6958 VDD.n710 VSS 0.03158f
C6959 VDD.n711 VSS 1.7511f
C6960 VDD.n712 VSS 0.41197f
C6961 VDD.n713 VSS 0.03187f
C6962 VDD.n714 VSS 0.02875f
C6963 VDD.n715 VSS 0.03158f
C6964 VDD.n716 VSS 0.03187f
C6965 VDD.n717 VSS 0.41435f
C6966 VDD.n718 VSS 1.40123f
C6967 VDD.n719 VSS 0
C6968 VDD.n720 VSS 0.02875f
C6969 VDD.n721 VSS 0
C6970 VDD.n722 VSS 0.0277f
C6971 VDD.n723 VSS 0.03187f
C6972 VDD.n724 VSS 0.03158f
C6973 VDD.n725 VSS 1.45143f
C6974 VDD.n726 VSS 0.41182f
C6975 VDD.n727 VSS 0.03187f
C6976 VDD.n728 VSS 0.02875f
C6977 VDD.n729 VSS 0.03158f
C6978 VDD.n730 VSS 0.03187f
C6979 VDD.n731 VSS 0.41197f
C6980 VDD.n732 VSS 1.5329f
C6981 VDD.n733 VSS 0
C6982 VDD.n734 VSS 0.02875f
C6983 VDD.n735 VSS 0
C6984 VDD.n736 VSS 0.0277f
C6985 VDD.n737 VSS 0.03187f
C6986 VDD.n738 VSS 0.0277f
C6987 VDD.n739 VSS 0.41167f
C6988 VDD.n740 VSS 0.03158f
C6989 VDD.n741 VSS 0
C6990 VDD.n742 VSS 0.03187f
C6991 VDD.n743 VSS 0.0277f
C6992 VDD.n744 VSS 0.41167f
C6993 VDD.n745 VSS 0.03158f
C6994 VDD.n746 VSS 0
C6995 VDD.n747 VSS 0.03187f
C6996 VDD.n748 VSS 0.02875f
C6997 VDD.n749 VSS 0
C6998 VDD.n750 VSS 0
C6999 VDD.n751 VSS 0.02875f
C7000 VDD.n752 VSS 0.03158f
C7001 VDD.n753 VSS 0.0277f
C7002 VDD.n754 VSS 0.41152f
C7003 VDD.n755 VSS 0.03158f
C7004 VDD.n756 VSS 0
C7005 VDD.n757 VSS 0.03187f
C7006 VDD.n758 VSS 0.02875f
C7007 VDD.n759 VSS 0
C7008 VDD.n760 VSS 0
C7009 VDD.n761 VSS 0.02875f
C7010 VDD.n762 VSS 0.03158f
C7011 VDD.n763 VSS 0.0277f
C7012 VDD.n764 VSS 0.41167f
C7013 VDD.n765 VSS 0.03158f
C7014 VDD.n766 VSS 0
C7015 VDD.n767 VSS 0.03187f
C7016 VDD.n768 VSS 0.02875f
C7017 VDD.n769 VSS 0
C7018 VDD.n770 VSS 0
C7019 VDD.n771 VSS 0.02875f
C7020 VDD.n772 VSS 0.03158f
C7021 VDD.n773 VSS 0.0277f
C7022 VDD.n774 VSS 0
C7023 VDD.n775 VSS 0.0277f
C7024 VDD.n776 VSS 0.03187f
C7025 VDD.n777 VSS 0.03158f
C7026 VDD.n778 VSS 1.98717f
C7027 VDD.n779 VSS 0
C7028 VDD.n780 VSS 0.0277f
C7029 VDD.n781 VSS 0.03187f
C7030 VDD.n782 VSS 0.03158f
C7031 VDD.n783 VSS 1.98657f
C7032 VDD.n784 VSS 0.41182f
C7033 VDD.n785 VSS 0.03187f
C7034 VDD.n786 VSS 0.02875f
C7035 VDD.n787 VSS 0.03158f
C7036 VDD.n788 VSS 0.03187f
C7037 VDD.n789 VSS 0.41197f
C7038 VDD.n790 VSS 0.03158f
C7039 VDD.n791 VSS 1.36594f
C7040 VDD.n792 VSS 1.36594f
C7041 VDD.n793 VSS 0
C7042 VDD.n794 VSS 0.02875f
C7043 VDD.n795 VSS 0
C7044 VDD.n796 VSS 0.0277f
C7045 VDD.n797 VSS 0.03187f
C7046 VDD.n798 VSS 0.03158f
C7047 VDD.n799 VSS 1.61839f
C7048 VDD.n800 VSS 0.41197f
C7049 VDD.n801 VSS 0.03187f
C7050 VDD.n802 VSS 0.02875f
C7051 VDD.n803 VSS 0.03158f
C7052 VDD.n804 VSS 0.03187f
C7053 VDD.n805 VSS 0.41182f
C7054 VDD.n806 VSS 0.03158f
C7055 VDD.n807 VSS 1.7511f
C7056 VDD.n808 VSS 1.7511f
C7057 VDD.n809 VSS 0
C7058 VDD.n810 VSS 0.02875f
C7059 VDD.n811 VSS 0
C7060 VDD.n812 VSS 0.0277f
C7061 VDD.n813 VSS 0.03187f
C7062 VDD.n814 VSS 0.03158f
C7063 VDD.n815 VSS 1.36594f
C7064 VDD.n816 VSS 3.25942f
C7065 VDD.n817 VSS 0.03187f
C7066 VDD.n818 VSS 0.02875f
C7067 VDD.n819 VSS 0.03158f
C7068 VDD.n820 VSS 0.03187f
C7069 VDD.n821 VSS 0.41197f
C7070 VDD.n822 VSS 1.45143f
C7071 VDD.n823 VSS 0
C7072 VDD.n824 VSS 0.02875f
C7073 VDD.n825 VSS 0
C7074 VDD.n826 VSS 0.0277f
C7075 VDD.n827 VSS 0.03187f
C7076 VDD.n828 VSS 0.03158f
C7077 VDD.n829 VSS 1.7511f
C7078 VDD.n830 VSS 0.41197f
C7079 VDD.n831 VSS 0.03187f
C7080 VDD.n832 VSS 0.02875f
C7081 VDD.n833 VSS 0.03158f
C7082 VDD.n834 VSS 0.03187f
C7083 VDD.n835 VSS 2.21594f
C7084 VDD.n836 VSS 1.40123f
C7085 VDD.n837 VSS 0
C7086 VDD.n838 VSS 0.02875f
C7087 VDD.n839 VSS 0
C7088 VDD.n840 VSS 0.0277f
C7089 VDD.n841 VSS 0.03187f
C7090 VDD.n842 VSS 0.03158f
C7091 VDD.n843 VSS 1.45143f
C7092 VDD.n844 VSS 0.41182f
C7093 VDD.n845 VSS 0.03187f
C7094 VDD.n846 VSS 0.02875f
C7095 VDD.n847 VSS 0.03158f
C7096 VDD.n848 VSS 0.03187f
C7097 VDD.n849 VSS 0
C7098 VDD.n850 VSS 0.02875f
C7099 VDD.n851 VSS 0.03158f
C7100 VDD.n852 VSS 0.03187f
C7101 VDD.n853 VSS 0
C7102 VDD.n854 VSS 0.01321f
C7103 VDD.n855 VSS 0.01452f
C7104 VDD.n856 VSS 2.21579f
C7105 VDD.n857 VSS 0.97641f
C7106 VDD.n858 VSS 1.52556f
C7107 VDD.n859 VSS 0.12437f
C7108 VDD.t362 VSS 0.95052f
C7109 VDD.n860 VSS -0.03539f
C7110 VDD.t148 VSS 2.58394f
C7111 VDD.t149 VSS 1.48884f
C7112 VDD.n861 VSS 1.88721f
C7113 VDD.t150 VSS 3.87592f
C7114 VDD.t151 VSS 2.23327f
C7115 VDD.n862 VSS -0.03288f
C7116 VDD.n863 VSS 0.20268f
C7117 VDD.n864 VSS -0.07133f
C7118 VDD.n865 VSS 2.88609f
C7119 VDD.n866 VSS 3.86054f
C7120 VDD.t364 VSS 1.42117f
C7121 VDD.t647 VSS 4.40837f
C7122 VDD.n867 VSS 3.03192f
C7123 VDD.n868 VSS 0.11807f
C7124 VDD.n869 VSS -0.0694f
C7125 VDD.n870 VSS 1.97642f
C7126 VDD.t648 VSS 2.40553f
C7127 VDD.n871 VSS 1.56422f
C7128 VDD.n872 VSS -0.03279f
C7129 VDD.n873 VSS 0.11665f
C7130 VDD.n874 VSS 0.33761f
C7131 VDD.t165 VSS 13.7416f
C7132 VDD.n875 VSS 0.12385f
C7133 VDD.t117 VSS 7.40744f
C7134 VDD.t118 VSS 0.46371f
C7135 VDD.t589 VSS 0.18811f
C7136 VDD.n876 VSS 0.2985f
C7137 VDD.t588 VSS 0.46371f
C7138 VDD.t587 VSS 0.18811f
C7139 VDD.n877 VSS 0.30403f
C7140 VDD.t119 VSS 0.18811f
C7141 VDD.n878 VSS 0.2063f
C7142 VDD.n879 VSS 0.09199f
C7143 VDD.n880 VSS 2.5462f
C7144 VDD.t131 VSS 7.39131f
C7145 VDD.n881 VSS 2.55632f
C7146 VDD.t218 VSS 0.46371f
C7147 VDD.t217 VSS 0.18811f
C7148 VDD.n882 VSS 0.29828f
C7149 VDD.t132 VSS 0.46371f
C7150 VDD.t220 VSS 0.18811f
C7151 VDD.n883 VSS 0.30403f
C7152 VDD.t219 VSS 0.18811f
C7153 VDD.n884 VSS 0.20652f
C7154 VDD.n885 VSS 0.09199f
C7155 VDD.n886 VSS 0.03216f
C7156 VDD.t133 VSS 7.3923f
C7157 VDD.n887 VSS 2.55656f
C7158 VDD.t138 VSS 0.46575f
C7159 VDD.t135 VSS 0.18811f
C7160 VDD.n888 VSS 0.30066f
C7161 VDD.t136 VSS 0.46561f
C7162 VDD.t134 VSS 0.18811f
C7163 VDD.n889 VSS 0.30651f
C7164 VDD.t137 VSS 0.18811f
C7165 VDD.n890 VSS 0.20777f
C7166 VDD.n891 VSS 0.09311f
C7167 VDD.n892 VSS 0.35378f
C7168 VDD.n893 VSS 2.50187f
C7169 VDD.t363 VSS 0.95052f
C7170 VDD.t123 VSS 2.58394f
C7171 VDD.t209 VSS 1.48884f
C7172 VDD.n894 VSS 1.88721f
C7173 VDD.t122 VSS 3.87592f
C7174 VDD.t208 VSS 2.23327f
C7175 VDD.n895 VSS 0.01214f
C7176 VDD.n896 VSS 2.88657f
C7177 VDD.n897 VSS 3.86054f
C7178 VDD.t361 VSS 1.42117f
C7179 VDD.t20 VSS 3.62106f
C7180 VDD.n898 VSS 3.03249f
C7181 VDD.n899 VSS 0.01296f
C7182 VDD.n900 VSS 1.97642f
C7183 VDD.t21 VSS 2.40593f
C7184 VDD.n901 VSS 1.57782f
C7185 VDD.n902 VSS -0.0028f
C7186 VDD.n903 VSS 2.30871f
C7187 VDD.t61 VSS 0.70815f
C7188 VDD.t233 VSS 0.28423f
C7189 VDD.n904 VSS 0.44539f
C7190 VDD.t94 VSS 0.28423f
C7191 VDD.n905 VSS 0.4377f
C7192 VDD.t79 VSS 0.28423f
C7193 VDD.n906 VSS 0.43768f
C7194 VDD.t90 VSS 0.28423f
C7195 VDD.n907 VSS 0.43768f
C7196 VDD.t703 VSS 0.28423f
C7197 VDD.n908 VSS 0.43768f
C7198 VDD.t705 VSS 0.28423f
C7199 VDD.n909 VSS 0.43768f
C7200 VDD.t80 VSS 0.28423f
C7201 VDD.n910 VSS 0.43768f
C7202 VDD.t92 VSS 0.28423f
C7203 VDD.n911 VSS 0.43768f
C7204 VDD.t702 VSS 0.28423f
C7205 VDD.n912 VSS 0.40412f
C7206 VDD.t82 VSS 0.70819f
C7207 VDD.t704 VSS 0.28423f
C7208 VDD.n913 VSS 0.44539f
C7209 VDD.t232 VSS 0.28423f
C7210 VDD.n914 VSS 0.4377f
C7211 VDD.t58 VSS 0.28423f
C7212 VDD.n915 VSS 0.43768f
C7213 VDD.t229 VSS 0.28423f
C7214 VDD.n916 VSS 0.43768f
C7215 VDD.t89 VSS 0.28423f
C7216 VDD.n917 VSS 0.43768f
C7217 VDD.t91 VSS 0.28423f
C7218 VDD.n918 VSS 0.43768f
C7219 VDD.t59 VSS 0.28423f
C7220 VDD.n919 VSS 0.43768f
C7221 VDD.t230 VSS 0.28423f
C7222 VDD.n920 VSS 0.43768f
C7223 VDD.t62 VSS 0.28423f
C7224 VDD.n921 VSS 0.3987f
C7225 VDD.n922 VSS 0.09436f
C7226 VDD.t194 VSS 0.71143f
C7227 VDD.t598 VSS 0.28423f
C7228 VDD.n923 VSS 0.44898f
C7229 VDD.t188 VSS 0.28423f
C7230 VDD.n924 VSS 0.44113f
C7231 VDD.t189 VSS 0.28423f
C7232 VDD.n925 VSS 0.44111f
C7233 VDD.t585 VSS 0.28423f
C7234 VDD.n926 VSS 0.44111f
C7235 VDD.t192 VSS 0.28423f
C7236 VDD.n927 VSS 0.44111f
C7237 VDD.t592 VSS 0.28423f
C7238 VDD.n928 VSS 0.44111f
C7239 VDD.t190 VSS 0.28423f
C7240 VDD.n929 VSS 0.44111f
C7241 VDD.t184 VSS 0.28423f
C7242 VDD.n930 VSS 0.44111f
C7243 VDD.t191 VSS 0.28423f
C7244 VDD.n931 VSS 0.40177f
C7245 VDD.n932 VSS 0.09848f
C7246 VDD.t523 VSS 0.28423f
C7247 VDD.n933 VSS 0.40602f
C7248 VDD.t689 VSS 0.28423f
C7249 VDD.n934 VSS 0.43768f
C7250 VDD.t522 VSS 0.28423f
C7251 VDD.n935 VSS 0.43768f
C7252 VDD.t525 VSS 0.28423f
C7253 VDD.n936 VSS 0.43768f
C7254 VDD.t524 VSS 0.28423f
C7255 VDD.n937 VSS 0.43768f
C7256 VDD.t174 VSS 0.28423f
C7257 VDD.n938 VSS 0.3523f
C7258 VDD.t519 VSS 0.70819f
C7259 VDD.t526 VSS 0.28423f
C7260 VDD.n939 VSS 0.44537f
C7261 VDD.t528 VSS 0.28423f
C7262 VDD.n940 VSS 0.4377f
C7263 VDD.t520 VSS 0.28423f
C7264 VDD.n941 VSS 0.38692f
C7265 VDD.n942 VSS 0.13616f
C7266 VDD.n943 VSS 0.10186f
C7267 VDD.n944 VSS 0.00936f
C7268 VDD.n945 VSS 2.93819f
C7269 VDD.t183 VSS 10.6875f
C7270 VDD.n946 VSS 0.02492f
C7271 VDD.t60 VSS 3.73615f
C7272 VDD.t81 VSS 2.27761f
C7273 VDD.t518 VSS 2.39777f
C7274 VDD.n947 VSS 2.70526f
C7275 VDD.t193 VSS 3.16854f
C7276 VDD.n948 VSS 2.69852f
C7277 VDD.n949 VSS 0.02133f
C7278 VDD.t78 VSS 13.0765f
C7279 VDD.t57 VSS 7.97165f
C7280 VDD.t93 VSS 1.86782f
C7281 VDD.t231 VSS 1.13865f
C7282 VDD.n950 VSS 0.3979f
C7283 VDD.t527 VSS 1.15807f
C7284 VDD.n951 VSS 1.33181f
C7285 VDD.t187 VSS 1.52658f
C7286 VDD.n952 VSS 0.99189f
C7287 VDD.n953 VSS 6.94113f
C7288 VDD.n954 VSS 2.78591f
C7289 VDD.n955 VSS 0.11149f
C7290 VDD.n956 VSS 0.13784f
C7291 VDD.n957 VSS 0.12769f
C7292 VDD.n958 VSS 9.32418f
C7293 VDD.t173 VSS 11.0899f
C7294 VDD.n959 VSS 7.01064f
C7295 VDD.n960 VSS 1.2885f
C7296 VDD.n961 VSS 0.13291f
C7297 VDD.n962 VSS 0.09639f
C7298 VDD.t343 VSS 0.70815f
C7299 VDD.t345 VSS 0.28423f
C7300 VDD.n963 VSS 0.44539f
C7301 VDD.t337 VSS 0.28423f
C7302 VDD.n964 VSS 0.4377f
C7303 VDD.t335 VSS 0.28423f
C7304 VDD.n965 VSS 0.43768f
C7305 VDD.t339 VSS 0.28423f
C7306 VDD.n966 VSS 0.43768f
C7307 VDD.t331 VSS 0.28423f
C7308 VDD.n967 VSS 0.43768f
C7309 VDD.t330 VSS 0.28423f
C7310 VDD.n968 VSS 0.43768f
C7311 VDD.t334 VSS 0.28423f
C7312 VDD.n969 VSS 0.43768f
C7313 VDD.t338 VSS 0.28423f
C7314 VDD.n970 VSS 0.43768f
C7315 VDD.t332 VSS 0.28423f
C7316 VDD.n971 VSS 0.40412f
C7317 VDD.t326 VSS 0.70819f
C7318 VDD.t333 VSS 0.28423f
C7319 VDD.n972 VSS 0.44539f
C7320 VDD.t324 VSS 0.28423f
C7321 VDD.n973 VSS 0.4377f
C7322 VDD.t322 VSS 0.28423f
C7323 VDD.n974 VSS 0.43768f
C7324 VDD.t328 VSS 0.28423f
C7325 VDD.n975 VSS 0.43768f
C7326 VDD.t341 VSS 0.28423f
C7327 VDD.n976 VSS 0.43768f
C7328 VDD.t340 VSS 0.28423f
C7329 VDD.n977 VSS 0.43768f
C7330 VDD.t346 VSS 0.28423f
C7331 VDD.n978 VSS 0.43768f
C7332 VDD.t327 VSS 0.28423f
C7333 VDD.n979 VSS 0.43768f
C7334 VDD.t344 VSS 0.28423f
C7335 VDD.n980 VSS 0.3987f
C7336 VDD.n981 VSS 0.09436f
C7337 VDD.t595 VSS 0.71143f
C7338 VDD.t594 VSS 0.28423f
C7339 VDD.n982 VSS 0.44898f
C7340 VDD.t600 VSS 0.28423f
C7341 VDD.n983 VSS 0.44113f
C7342 VDD.t582 VSS 0.28423f
C7343 VDD.n984 VSS 0.44111f
C7344 VDD.t596 VSS 0.28423f
C7345 VDD.n985 VSS 0.44111f
C7346 VDD.t586 VSS 0.28423f
C7347 VDD.n986 VSS 0.44111f
C7348 VDD.t186 VSS 0.28423f
C7349 VDD.n987 VSS 0.44111f
C7350 VDD.t583 VSS 0.28423f
C7351 VDD.n988 VSS 0.44111f
C7352 VDD.t597 VSS 0.28423f
C7353 VDD.n989 VSS 0.44111f
C7354 VDD.t584 VSS 0.28423f
C7355 VDD.n990 VSS 0.40177f
C7356 VDD.n991 VSS 0.09848f
C7357 VDD.t616 VSS 0.28423f
C7358 VDD.n992 VSS 0.40602f
C7359 VDD.t609 VSS 0.28423f
C7360 VDD.n993 VSS 0.43768f
C7361 VDD.t615 VSS 0.28423f
C7362 VDD.n994 VSS 0.43768f
C7363 VDD.t618 VSS 0.28423f
C7364 VDD.n995 VSS 0.43768f
C7365 VDD.t617 VSS 0.28423f
C7366 VDD.n996 VSS 0.43768f
C7367 VDD.t608 VSS 0.28423f
C7368 VDD.n997 VSS 0.3523f
C7369 VDD.t619 VSS 0.70819f
C7370 VDD.t604 VSS 0.28423f
C7371 VDD.n998 VSS 0.44537f
C7372 VDD.t606 VSS 0.28423f
C7373 VDD.n999 VSS 0.4377f
C7374 VDD.t614 VSS 0.28423f
C7375 VDD.n1000 VSS 0.38692f
C7376 VDD.n1001 VSS 0.13616f
C7377 VDD.n1002 VSS 0.09634f
C7378 VDD.n1003 VSS -0.04654f
C7379 VDD.n1004 VSS 2.93819f
C7380 VDD.t185 VSS 10.6875f
C7381 VDD.n1005 VSS 0.02492f
C7382 VDD.t342 VSS 3.73615f
C7383 VDD.t325 VSS 2.27761f
C7384 VDD.t603 VSS 2.39777f
C7385 VDD.n1006 VSS 2.70526f
C7386 VDD.t593 VSS 3.16854f
C7387 VDD.n1007 VSS 2.69852f
C7388 VDD.n1008 VSS 0.02133f
C7389 VDD.t329 VSS 13.0765f
C7390 VDD.t321 VSS 7.97165f
C7391 VDD.t336 VSS 1.86782f
C7392 VDD.t323 VSS 1.13865f
C7393 VDD.n1009 VSS 0.3979f
C7394 VDD.t605 VSS 1.15807f
C7395 VDD.n1010 VSS 1.33181f
C7396 VDD.t599 VSS 1.52658f
C7397 VDD.n1011 VSS 0.99189f
C7398 VDD.n1012 VSS 6.94113f
C7399 VDD.n1013 VSS 2.78591f
C7400 VDD.n1014 VSS 0.11149f
C7401 VDD.n1015 VSS 0.028f
C7402 VDD.t537 VSS 0.07801f
C7403 VDD.n1016 VSS 0.05428f
C7404 VDD.t538 VSS 0.00488f
C7405 VDD.n1017 VSS 0.0173f
C7406 VDD.n1018 VSS 0.02802f
C7407 VDD.n1019 VSS -0.00166f
C7408 VDD.n1020 VSS 0.05436f
C7409 VDD.t681 VSS 0.07792f
C7410 VDD.t127 VSS 0.07792f
C7411 VDD.t225 VSS 0.07801f
C7412 VDD.t226 VSS 0.00488f
C7413 VDD.n1021 VSS 0.01728f
C7414 VDD.n1022 VSS 0.05428f
C7415 VDD.n1023 VSS 0.05436f
C7416 VDD.n1024 VSS -0.0017f
C7417 VDD.n1025 VSS 0.24449f
C7418 VDD.n1026 VSS 0.10917f
C7419 VDD.n1027 VSS 0.12769f
C7420 VDD.n1028 VSS 9.32418f
C7421 VDD.t607 VSS 11.0899f
C7422 VDD.n1029 VSS 7.01064f
C7423 VDD.n1030 VSS 1.28848f
C7424 VDD.n1031 VSS 0.13291f
C7425 VDD.n1032 VSS 0.02149f
C7426 VDD.n1033 VSS 0.10789f
C7427 VDD.n1034 VSS 0.05328f
C7428 VDD.t480 VSS 0.07897f
C7429 VDD.t206 VSS 0.07897f
C7430 VDD.n1035 VSS 0.05287f
C7431 VDD.n1036 VSS 0.08999f
C7432 VDD.n1037 VSS 0.05328f
C7433 VDD.t679 VSS 0.07897f
C7434 VDD.t602 VSS 0.07897f
C7435 VDD.n1038 VSS 0.05307f
C7436 VDD.n1039 VSS 0.04214f
C7437 VDD.n1040 VSS 0.05328f
C7438 VDD.t677 VSS 0.07897f
C7439 VDD.t128 VSS 0.07897f
C7440 VDD.n1041 VSS 0.05305f
C7441 VDD.n1042 VSS 0.02232f
C7442 VDD.n1043 VSS 0.10617f
C7443 VDD.n1044 VSS 0.46046f
C7444 VDD.n1045 VSS 0.05328f
C7445 VDD.t478 VSS 0.07897f
C7446 VDD.t203 VSS 0.07897f
C7447 VDD.n1046 VSS 0.05308f
C7448 VDD.n1047 VSS 0.04224f
C7449 VDD.n1048 VSS 0.05328f
C7450 VDD.t682 VSS 0.07897f
C7451 VDD.t557 VSS 0.07897f
C7452 VDD.n1049 VSS 0.05308f
C7453 VDD.n1050 VSS 0.0224f
C7454 VDD.n1051 VSS 0.10615f
C7455 VDD.n1052 VSS 0.27581f
C7456 VDD.n1053 VSS 0.05328f
C7457 VDD.t674 VSS 0.07897f
C7458 VDD.t126 VSS 0.07897f
C7459 VDD.n1054 VSS 0.05319f
C7460 VDD.n1055 VSS 0.0426f
C7461 VDD.n1056 VSS 0.05328f
C7462 VDD.t481 VSS 0.07897f
C7463 VDD.t207 VSS 0.07897f
C7464 VDD.n1057 VSS 0.05318f
C7465 VDD.n1058 VSS 0.02269f
C7466 VDD.n1059 VSS 0.10613f
C7467 VDD.n1060 VSS 0.26597f
C7468 VDD.n1061 VSS 0.02802f
C7469 VDD.t685 VSS 0.07801f
C7470 VDD.t686 VSS 0.00488f
C7471 VDD.n1062 VSS 0.0173f
C7472 VDD.n1063 VSS 0.05428f
C7473 VDD.t700 VSS 0.07801f
C7474 VDD.n1064 VSS 0.05428f
C7475 VDD.t701 VSS 0.00488f
C7476 VDD.n1065 VSS 0.01728f
C7477 VDD.n1066 VSS 0.028f
C7478 VDD.n1067 VSS -0.00164f
C7479 VDD.n1068 VSS 0.05436f
C7480 VDD.t626 VSS 0.07792f
C7481 VDD.t479 VSS 0.07792f
C7482 VDD.n1069 VSS 0.05436f
C7483 VDD.n1070 VSS -0.00172f
C7484 VDD.n1071 VSS 0.02802f
C7485 VDD.t535 VSS 0.07801f
C7486 VDD.t536 VSS 0.00488f
C7487 VDD.n1072 VSS 0.0173f
C7488 VDD.n1073 VSS 0.05428f
C7489 VDD.t696 VSS 0.07801f
C7490 VDD.n1074 VSS 0.05428f
C7491 VDD.t697 VSS 0.00488f
C7492 VDD.n1075 VSS 0.01728f
C7493 VDD.n1076 VSS 0.028f
C7494 VDD.n1077 VSS -0.00164f
C7495 VDD.n1078 VSS 0.05436f
C7496 VDD.t601 VSS 0.07792f
C7497 VDD.t680 VSS 0.07792f
C7498 VDD.n1079 VSS 0.05436f
C7499 VDD.n1080 VSS -0.00172f
C7500 VDD.n1081 VSS 0.06365f
C7501 VDD.n1082 VSS 0.86799f
C7502 VDD.n1083 VSS 1.24967f
C7503 VDD.n1084 VSS 0.6039f
C7504 VDD.n1085 VSS 0.03766f
C7505 VDD.n1086 VSS 0.01321f
C7506 VDD.n1087 VSS 0
C7507 VDD.n1088 VSS 0
C7508 VDD.n1089 VSS 0
C7509 VDD.n1090 VSS 0.02875f
C7510 VDD.n1091 VSS 0.03158f
C7511 VDD.n1092 VSS 0.03187f
C7512 VDD.n1093 VSS 0.41197f
C7513 VDD.n1094 VSS 0
C7514 VDD.n1095 VSS 0.03187f
C7515 VDD.n1096 VSS 0.0277f
C7516 VDD.n1097 VSS 0.0277f
C7517 VDD.n1098 VSS 0
C7518 VDD.n1099 VSS 0.03158f
C7519 VDD.n1100 VSS 1.45143f
C7520 VDD.n1101 VSS 0.02875f
C7521 VDD.n1102 VSS 1.04259f
C7522 VDD.n1103 VSS 1.04288f
C7523 VDD.n1104 VSS 0.40014f
C7524 VDD.n1105 VSS 0.39883f
C7525 VDD.n1106 VSS 2.21654f
C7526 VDD.n1107 VSS 2.21669f
C7527 VDD.n1108 VSS 0
C7528 VDD.n1109 VSS 0.03187f
C7529 VDD.n1110 VSS 0.0277f
C7530 VDD.n1111 VSS 0.0277f
C7531 VDD.n1112 VSS 0
C7532 VDD.n1113 VSS 0.03158f
C7533 VDD.n1114 VSS 1.40123f
C7534 VDD.n1115 VSS 0.02875f
C7535 VDD.n1116 VSS 0.41167f
C7536 VDD.n1117 VSS 0.41197f
C7537 VDD.n1118 VSS 0
C7538 VDD.n1119 VSS 0.02875f
C7539 VDD.n1120 VSS 0
C7540 VDD.n1121 VSS 0.0277f
C7541 VDD.n1122 VSS 0.03187f
C7542 VDD.n1123 VSS 0.03158f
C7543 VDD.n1124 VSS 1.40123f
C7544 VDD.n1125 VSS 0
C7545 VDD.n1126 VSS 0.0277f
C7546 VDD.n1127 VSS 0.03187f
C7547 VDD.n1128 VSS 0.03158f
C7548 VDD.n1129 VSS 1.40123f
C7549 VDD.n1130 VSS 0
C7550 VDD.n1131 VSS 0.0277f
C7551 VDD.n1132 VSS 0.03187f
C7552 VDD.n1133 VSS 0.03158f
C7553 VDD.n1134 VSS 0.20435f
C7554 VDD.n1135 VSS 0
C7555 VDD.n1136 VSS 0.0277f
C7556 VDD.n1137 VSS 0.03187f
C7557 VDD.n1138 VSS 0.03158f
C7558 VDD.n1139 VSS 1.40123f
C7559 VDD.n1140 VSS 0
C7560 VDD.n1141 VSS 0.0277f
C7561 VDD.n1142 VSS 0.03187f
C7562 VDD.n1143 VSS 0.03158f
C7563 VDD.n1144 VSS 1.40123f
C7564 VDD.n1145 VSS 0
C7565 VDD.n1146 VSS 0.0277f
C7566 VDD.n1147 VSS 0.03187f
C7567 VDD.n1148 VSS 0.03158f
C7568 VDD.n1149 VSS 1.40123f
C7569 VDD.n1150 VSS 0
C7570 VDD.n1151 VSS 0.0277f
C7571 VDD.n1152 VSS 0.03187f
C7572 VDD.n1153 VSS 0.03158f
C7573 VDD.n1154 VSS 1.40123f
C7574 VDD.n1155 VSS 0
C7575 VDD.n1156 VSS 0.0277f
C7576 VDD.n1157 VSS 0.03187f
C7577 VDD.n1158 VSS 0.0277f
C7578 VDD.n1159 VSS 0.41152f
C7579 VDD.n1160 VSS 0.03158f
C7580 VDD.n1161 VSS 0
C7581 VDD.n1162 VSS 0.03187f
C7582 VDD.n1163 VSS 0.02875f
C7583 VDD.n1164 VSS 0
C7584 VDD.n1165 VSS 0
C7585 VDD.n1166 VSS 0.02875f
C7586 VDD.n1167 VSS 0.03158f
C7587 VDD.n1168 VSS 1.45143f
C7588 VDD.n1169 VSS 0.03187f
C7589 VDD.n1170 VSS 0
C7590 VDD.n1171 VSS 0.02875f
C7591 VDD.n1172 VSS 0.03158f
C7592 VDD.n1173 VSS 1.45143f
C7593 VDD.n1174 VSS 0.03187f
C7594 VDD.n1175 VSS 0
C7595 VDD.n1176 VSS 0.02875f
C7596 VDD.n1177 VSS 0.03158f
C7597 VDD.n1178 VSS 1.45143f
C7598 VDD.n1179 VSS 0.03187f
C7599 VDD.n1180 VSS 0
C7600 VDD.n1181 VSS 0.02875f
C7601 VDD.n1182 VSS 0.03158f
C7602 VDD.n1183 VSS 1.45143f
C7603 VDD.n1184 VSS 0.03187f
C7604 VDD.n1185 VSS 0
C7605 VDD.n1186 VSS 0.02875f
C7606 VDD.n1187 VSS 0.03158f
C7607 VDD.n1188 VSS 1.45143f
C7608 VDD.n1189 VSS 0.03187f
C7609 VDD.n1190 VSS 0
C7610 VDD.n1191 VSS 0.02875f
C7611 VDD.n1192 VSS 0.03158f
C7612 VDD.n1193 VSS 1.45143f
C7613 VDD.n1194 VSS 0.03187f
C7614 VDD.n1195 VSS 0
C7615 VDD.n1196 VSS 0.02875f
C7616 VDD.n1197 VSS 0.03158f
C7617 VDD.n1198 VSS 0.0277f
C7618 VDD.n1199 VSS 0.41167f
C7619 VDD.n1200 VSS 0.03158f
C7620 VDD.n1201 VSS 0
C7621 VDD.n1202 VSS 0.03187f
C7622 VDD.n1203 VSS 0.02875f
C7623 VDD.n1204 VSS 0
C7624 VDD.n1205 VSS 0
C7625 VDD.n1206 VSS 0.02875f
C7626 VDD.n1207 VSS 0.03158f
C7627 VDD.n1208 VSS 0.0277f
C7628 VDD.n1209 VSS 0.41152f
C7629 VDD.n1210 VSS 0.03158f
C7630 VDD.n1211 VSS 0
C7631 VDD.n1212 VSS 0.03187f
C7632 VDD.n1213 VSS 0.02875f
C7633 VDD.n1214 VSS 0
C7634 VDD.n1215 VSS 0
C7635 VDD.n1216 VSS 0.02875f
C7636 VDD.n1217 VSS 0.03158f
C7637 VDD.n1218 VSS 0.0277f
C7638 VDD.n1219 VSS 0.41167f
C7639 VDD.n1220 VSS 0.03158f
C7640 VDD.n1221 VSS 0
C7641 VDD.n1222 VSS 0.03187f
C7642 VDD.n1223 VSS 0.02875f
C7643 VDD.n1224 VSS 0
C7644 VDD.n1225 VSS 0
C7645 VDD.n1226 VSS 0.02875f
C7646 VDD.n1227 VSS 0.03158f
C7647 VDD.n1228 VSS 0.0277f
C7648 VDD.n1229 VSS 0
C7649 VDD.n1230 VSS 0.0277f
C7650 VDD.n1231 VSS 0.03187f
C7651 VDD.n1232 VSS 0.03158f
C7652 VDD.n1233 VSS 1.9824f
C7653 VDD.n1234 VSS 0
C7654 VDD.n1235 VSS 0.0277f
C7655 VDD.n1236 VSS 0.03187f
C7656 VDD.n1237 VSS 0.03158f
C7657 VDD.n1238 VSS 1.98181f
C7658 VDD.n1239 VSS 0.41182f
C7659 VDD.n1240 VSS 0.03187f
C7660 VDD.n1241 VSS 0.02875f
C7661 VDD.n1242 VSS 0.03158f
C7662 VDD.n1243 VSS 0.03187f
C7663 VDD.n1244 VSS 0.41197f
C7664 VDD.n1245 VSS 0.03158f
C7665 VDD.n1246 VSS 1.36594f
C7666 VDD.n1247 VSS 1.36594f
C7667 VDD.n1248 VSS 0
C7668 VDD.n1249 VSS 0.02875f
C7669 VDD.n1250 VSS 0
C7670 VDD.n1251 VSS 0.0277f
C7671 VDD.n1252 VSS 0.03187f
C7672 VDD.n1253 VSS 0.03158f
C7673 VDD.n1254 VSS 1.61839f
C7674 VDD.n1255 VSS 0.41197f
C7675 VDD.n1256 VSS 0.03187f
C7676 VDD.n1257 VSS 0.02875f
C7677 VDD.n1258 VSS 0.03158f
C7678 VDD.n1259 VSS 0.03187f
C7679 VDD.n1260 VSS 0.41182f
C7680 VDD.n1261 VSS 0.03158f
C7681 VDD.n1262 VSS 1.7511f
C7682 VDD.n1263 VSS 1.7511f
C7683 VDD.n1264 VSS 0
C7684 VDD.n1265 VSS 0.02875f
C7685 VDD.n1266 VSS 0
C7686 VDD.n1267 VSS 0.0277f
C7687 VDD.n1268 VSS 0.03187f
C7688 VDD.n1269 VSS 0.03158f
C7689 VDD.n1270 VSS 1.36594f
C7690 VDD.n1271 VSS 0.41242f
C7691 VDD.n1272 VSS 0.03187f
C7692 VDD.n1273 VSS 0.02875f
C7693 VDD.n1274 VSS 0.03158f
C7694 VDD.n1275 VSS 0.03187f
C7695 VDD.n1276 VSS 0.41197f
C7696 VDD.n1277 VSS 0
C7697 VDD.n1278 VSS 0.02875f
C7698 VDD.n1279 VSS 0
C7699 VDD.n1280 VSS 0.0277f
C7700 VDD.n1281 VSS 0.03187f
C7701 VDD.n1282 VSS 0.03158f
C7702 VDD.n1283 VSS 1.7511f
C7703 VDD.n1284 VSS 0
C7704 VDD.n1285 VSS 0.0277f
C7705 VDD.n1286 VSS 0.03187f
C7706 VDD.n1287 VSS 0.03158f
C7707 VDD.n1288 VSS 1.7511f
C7708 VDD.n1289 VSS 0
C7709 VDD.n1290 VSS 0.0277f
C7710 VDD.n1291 VSS 0.03187f
C7711 VDD.n1292 VSS 0.03158f
C7712 VDD.n1293 VSS 1.7511f
C7713 VDD.n1294 VSS 0
C7714 VDD.n1295 VSS 0.0277f
C7715 VDD.n1296 VSS 0.03187f
C7716 VDD.n1297 VSS 0.03158f
C7717 VDD.n1298 VSS 1.7511f
C7718 VDD.n1299 VSS 0
C7719 VDD.n1300 VSS 0.0277f
C7720 VDD.n1301 VSS 0.03187f
C7721 VDD.n1302 VSS 0.03158f
C7722 VDD.n1303 VSS 1.7511f
C7723 VDD.n1304 VSS 0
C7724 VDD.n1305 VSS 0.0277f
C7725 VDD.n1306 VSS 0.03187f
C7726 VDD.n1307 VSS 0.03158f
C7727 VDD.n1308 VSS 1.7511f
C7728 VDD.n1309 VSS 0
C7729 VDD.n1310 VSS 0.0277f
C7730 VDD.n1311 VSS 0.03187f
C7731 VDD.n1312 VSS 0.03158f
C7732 VDD.n1313 VSS 1.7511f
C7733 VDD.n1314 VSS 0
C7734 VDD.n1315 VSS 0.0277f
C7735 VDD.n1316 VSS 0.03187f
C7736 VDD.n1317 VSS 0.0277f
C7737 VDD.n1318 VSS 0.02876f
C7738 VDD.n1319 VSS 0.03158f
C7739 VDD.n1320 VSS 0
C7740 VDD.n1321 VSS 0.03187f
C7741 VDD.n1322 VSS 0
C7742 VDD.n1323 VSS 0
C7743 VDD.n1324 VSS 0.02875f
C7744 VDD.n1325 VSS 0.03158f
C7745 VDD.n1326 VSS 1.36594f
C7746 VDD.n1327 VSS 0.03187f
C7747 VDD.n1328 VSS 0
C7748 VDD.n1329 VSS 0.02875f
C7749 VDD.n1330 VSS 0.03158f
C7750 VDD.n1331 VSS 1.36594f
C7751 VDD.n1332 VSS 0.03187f
C7752 VDD.n1333 VSS 0
C7753 VDD.n1334 VSS 0.02875f
C7754 VDD.n1335 VSS 0.03158f
C7755 VDD.n1336 VSS 1.36594f
C7756 VDD.n1337 VSS 0.03187f
C7757 VDD.n1338 VSS 0
C7758 VDD.n1339 VSS 0.02875f
C7759 VDD.n1340 VSS 0.03158f
C7760 VDD.n1341 VSS 1.36594f
C7761 VDD.n1342 VSS 0.03187f
C7762 VDD.n1343 VSS 0
C7763 VDD.n1344 VSS 0.02875f
C7764 VDD.n1345 VSS 0.03158f
C7765 VDD.n1346 VSS 1.36594f
C7766 VDD.n1347 VSS 0.03187f
C7767 VDD.n1348 VSS 0
C7768 VDD.n1349 VSS 0.02875f
C7769 VDD.n1350 VSS 0.03158f
C7770 VDD.n1351 VSS 1.36594f
C7771 VDD.n1352 VSS 0.03187f
C7772 VDD.n1353 VSS 0
C7773 VDD.n1354 VSS 0.02875f
C7774 VDD.n1355 VSS 0.03158f
C7775 VDD.n1356 VSS 0.0277f
C7776 VDD.n1357 VSS 0.41167f
C7777 VDD.n1358 VSS 0.03158f
C7778 VDD.n1359 VSS 0
C7779 VDD.n1360 VSS 0.03187f
C7780 VDD.n1361 VSS 0.02875f
C7781 VDD.n1362 VSS 0
C7782 VDD.n1363 VSS 0
C7783 VDD.n1364 VSS 0.02875f
C7784 VDD.n1365 VSS 0.03158f
C7785 VDD.n1366 VSS 0.0277f
C7786 VDD.n1367 VSS 0
C7787 VDD.n1368 VSS 0.0277f
C7788 VDD.n1369 VSS 0.03187f
C7789 VDD.n1370 VSS 0.03158f
C7790 VDD.n1371 VSS 1.9821f
C7791 VDD.n1372 VSS 0
C7792 VDD.n1373 VSS 0.0277f
C7793 VDD.n1374 VSS 0.03187f
C7794 VDD.n1375 VSS 0.03158f
C7795 VDD.n1376 VSS 1.98151f
C7796 VDD.n1377 VSS 0.43714f
C7797 VDD.n1378 VSS 0.03187f
C7798 VDD.n1379 VSS 0.02875f
C7799 VDD.n1380 VSS 0.03158f
C7800 VDD.n1381 VSS 0.03187f
C7801 VDD.n1382 VSS 0.41197f
C7802 VDD.n1383 VSS 0
C7803 VDD.n1384 VSS 0.02875f
C7804 VDD.n1385 VSS 0
C7805 VDD.n1386 VSS 0.0277f
C7806 VDD.n1387 VSS 0.03187f
C7807 VDD.n1388 VSS 0.03158f
C7808 VDD.n1389 VSS 1.61839f
C7809 VDD.n1390 VSS 0
C7810 VDD.n1391 VSS 0.0277f
C7811 VDD.n1392 VSS 0.03187f
C7812 VDD.n1393 VSS 0.03158f
C7813 VDD.n1394 VSS 1.61839f
C7814 VDD.n1395 VSS 0
C7815 VDD.n1396 VSS 0.0277f
C7816 VDD.n1397 VSS 0.03187f
C7817 VDD.n1398 VSS 0.03158f
C7818 VDD.n1399 VSS 1.61839f
C7819 VDD.n1400 VSS 0
C7820 VDD.n1401 VSS 0.0277f
C7821 VDD.n1402 VSS 0.03187f
C7822 VDD.n1403 VSS 0.03158f
C7823 VDD.n1404 VSS 1.61839f
C7824 VDD.n1405 VSS 0
C7825 VDD.n1406 VSS 0.0277f
C7826 VDD.n1407 VSS 0.03187f
C7827 VDD.n1408 VSS 0.03158f
C7828 VDD.n1409 VSS 1.61839f
C7829 VDD.n1410 VSS 0
C7830 VDD.n1411 VSS 0.0277f
C7831 VDD.n1412 VSS 0.03187f
C7832 VDD.n1413 VSS 0.0277f
C7833 VDD.n1414 VSS 0.02876f
C7834 VDD.n1415 VSS 0.03158f
C7835 VDD.n1416 VSS 0
C7836 VDD.n1417 VSS 0.03187f
C7837 VDD.n1418 VSS 1.98151f
C7838 VDD.n1419 VSS 0.03158f
C7839 VDD.n1420 VSS 0
C7840 VDD.n1421 VSS 0
C7841 VDD.n1422 VSS 0.02875f
C7842 VDD.n1423 VSS 0.03158f
C7843 VDD.n1424 VSS 0.03187f
C7844 VDD.n1425 VSS 0
C7845 VDD.n1426 VSS 0.02875f
C7846 VDD.n1427 VSS 0.03158f
C7847 VDD.n1428 VSS 0.03187f
C7848 VDD.n1429 VSS 0
C7849 VDD.n1430 VSS 0.02875f
C7850 VDD.n1431 VSS 0.03158f
C7851 VDD.n1432 VSS 0.03187f
C7852 VDD.n1433 VSS 0
C7853 VDD.n1434 VSS 0.02875f
C7854 VDD.n1435 VSS 0.03158f
C7855 VDD.n1436 VSS 0.03187f
C7856 VDD.n1437 VSS 0
C7857 VDD.n1438 VSS 0.02875f
C7858 VDD.n1439 VSS 0.03158f
C7859 VDD.n1440 VSS 0.03187f
C7860 VDD.n1441 VSS 1.61839f
C7861 VDD.n1442 VSS 0
C7862 VDD.n1443 VSS 0.03187f
C7863 VDD.n1444 VSS 0.0277f
C7864 VDD.n1445 VSS 0.0277f
C7865 VDD.n1446 VSS 0
C7866 VDD.n1447 VSS 0.03158f
C7867 VDD.n1448 VSS 1.97525f
C7868 VDD.n1449 VSS 0.02875f
C7869 VDD.n1450 VSS 0.41167f
C7870 VDD.n1451 VSS 0.41197f
C7871 VDD.n1452 VSS 1.61839f
C7872 VDD.n1453 VSS 0
C7873 VDD.n1454 VSS 0.03187f
C7874 VDD.n1455 VSS 0.0277f
C7875 VDD.n1456 VSS 0.0277f
C7876 VDD.n1457 VSS 0
C7877 VDD.n1458 VSS 0.03158f
C7878 VDD.n1459 VSS 1.97466f
C7879 VDD.n1460 VSS 0.02875f
C7880 VDD.n1461 VSS 0.41405f
C7881 VDD.n1462 VSS 0.41435f
C7882 VDD.n1463 VSS 1.61839f
C7883 VDD.n1464 VSS 0
C7884 VDD.n1465 VSS 0.03187f
C7885 VDD.n1466 VSS 0.0277f
C7886 VDD.n1467 VSS 0.0277f
C7887 VDD.n1468 VSS 0
C7888 VDD.n1469 VSS 0.03158f
C7889 VDD.n1470 VSS 1.98508f
C7890 VDD.n1471 VSS 0.02875f
C7891 VDD.n1472 VSS 0.41167f
C7892 VDD.n1473 VSS 0.41197f
C7893 VDD.n1474 VSS 1.61839f
C7894 VDD.n1475 VSS 0
C7895 VDD.n1476 VSS 0.03187f
C7896 VDD.n1477 VSS 0.0277f
C7897 VDD.n1478 VSS 0.0277f
C7898 VDD.n1479 VSS 0
C7899 VDD.n1480 VSS 0.03158f
C7900 VDD.n1481 VSS 1.98449f
C7901 VDD.n1482 VSS 0.02875f
C7902 VDD.n1483 VSS 0.41152f
C7903 VDD.n1484 VSS 0.41182f
C7904 VDD.n1485 VSS 1.61839f
C7905 VDD.n1486 VSS 0
C7906 VDD.n1487 VSS 0.03187f
C7907 VDD.n1488 VSS 0.0277f
C7908 VDD.n1489 VSS 0.0277f
C7909 VDD.n1490 VSS 0
C7910 VDD.n1491 VSS 0.03158f
C7911 VDD.n1492 VSS 1.9821f
C7912 VDD.n1493 VSS 0.02875f
C7913 VDD.n1494 VSS 0.41167f
C7914 VDD.n1495 VSS 0.41197f
C7915 VDD.n1496 VSS 0.02875f
C7916 VDD.n1497 VSS 0.0277f
C7917 VDD.n1498 VSS 0.03187f
C7918 VDD.n1499 VSS 0.50862f
C7919 VDD.n1500 VSS 1.61839f
C7920 VDD.n1501 VSS 0.03158f
C7921 VDD.n1502 VSS 1.61839f
C7922 VDD.n1503 VSS 0.03187f
C7923 VDD.n1504 VSS 0.03158f
C7924 VDD.n1505 VSS 1.36594f
C7925 VDD.n1506 VSS 0.03158f
C7926 VDD.n1507 VSS 0
C7927 VDD.n1508 VSS 0.0277f
C7928 VDD.n1509 VSS 1.36594f
C7929 VDD.n1510 VSS 0.50862f
C7930 VDD.n1511 VSS 0.02876f
C7931 VDD.n1512 VSS 0.02875f
C7932 VDD.n1513 VSS 0.41197f
C7933 VDD.n1514 VSS 0.0277f
C7934 VDD.n1515 VSS 0
C7935 VDD.n1516 VSS 0.03158f
C7936 VDD.n1517 VSS 0.03187f
C7937 VDD.n1518 VSS 0
C7938 VDD.n1519 VSS 0.41167f
C7939 VDD.n1520 VSS 0.02875f
C7940 VDD.n1521 VSS 0.02875f
C7941 VDD.n1522 VSS 0.41182f
C7942 VDD.n1523 VSS 0.0277f
C7943 VDD.n1524 VSS 0
C7944 VDD.n1525 VSS 0.03158f
C7945 VDD.n1526 VSS 0.03187f
C7946 VDD.n1527 VSS 0
C7947 VDD.n1528 VSS 0.41152f
C7948 VDD.n1529 VSS 0.02875f
C7949 VDD.n1530 VSS 0.02875f
C7950 VDD.n1531 VSS 0.41197f
C7951 VDD.n1532 VSS 0.0277f
C7952 VDD.n1533 VSS 0
C7953 VDD.n1534 VSS 0.03158f
C7954 VDD.n1535 VSS 0.03187f
C7955 VDD.n1536 VSS 0
C7956 VDD.n1537 VSS 0.41167f
C7957 VDD.n1538 VSS 0.02875f
C7958 VDD.n1539 VSS 0.02875f
C7959 VDD.n1540 VSS 0.41435f
C7960 VDD.n1541 VSS 0.0277f
C7961 VDD.n1542 VSS 0
C7962 VDD.n1543 VSS 0.03158f
C7963 VDD.n1544 VSS 0.03187f
C7964 VDD.n1545 VSS 0
C7965 VDD.n1546 VSS 0.41405f
C7966 VDD.n1547 VSS 0.02875f
C7967 VDD.n1548 VSS 0.02875f
C7968 VDD.n1549 VSS 0.41197f
C7969 VDD.n1550 VSS 0.0277f
C7970 VDD.n1551 VSS 0
C7971 VDD.n1552 VSS 0.03158f
C7972 VDD.n1553 VSS 0.03187f
C7973 VDD.n1554 VSS 0
C7974 VDD.n1555 VSS 0.41167f
C7975 VDD.n1556 VSS 0.02875f
C7976 VDD.n1557 VSS 0.02875f
C7977 VDD.n1558 VSS 0.43714f
C7978 VDD.n1559 VSS 0.43684f
C7979 VDD.n1560 VSS 0
C7980 VDD.n1561 VSS 0.03187f
C7981 VDD.n1562 VSS 0.0277f
C7982 VDD.n1563 VSS 0.0277f
C7983 VDD.n1564 VSS 0
C7984 VDD.n1565 VSS 0.03158f
C7985 VDD.n1566 VSS 1.61839f
C7986 VDD.n1567 VSS 0.03158f
C7987 VDD.n1568 VSS 0
C7988 VDD.n1569 VSS 0.0277f
C7989 VDD.n1570 VSS 1.61839f
C7990 VDD.n1571 VSS 0
C7991 VDD.n1572 VSS 0.43684f
C7992 VDD.n1573 VSS 0.02875f
C7993 VDD.n1574 VSS 0.02875f
C7994 VDD.n1575 VSS 0.41197f
C7995 VDD.n1576 VSS 0.03187f
C7996 VDD.n1577 VSS 0.03158f
C7997 VDD.n1578 VSS 1.61839f
C7998 VDD.n1579 VSS 0.03158f
C7999 VDD.n1580 VSS 0
C8000 VDD.n1581 VSS 0.0277f
C8001 VDD.n1582 VSS 1.61839f
C8002 VDD.n1583 VSS 0
C8003 VDD.n1584 VSS 0.41167f
C8004 VDD.n1585 VSS 0.02875f
C8005 VDD.n1586 VSS 0.02875f
C8006 VDD.n1587 VSS 0.41242f
C8007 VDD.n1588 VSS 0.41212f
C8008 VDD.n1589 VSS 0.03158f
C8009 VDD.n1590 VSS 0
C8010 VDD.n1591 VSS 0.03187f
C8011 VDD.n1592 VSS 0.02875f
C8012 VDD.n1593 VSS 1.97883f
C8013 VDD.n1594 VSS 0.03158f
C8014 VDD.n1595 VSS 0
C8015 VDD.n1596 VSS 0
C8016 VDD.n1597 VSS 0.02875f
C8017 VDD.n1598 VSS 0.03158f
C8018 VDD.n1599 VSS 0.03187f
C8019 VDD.n1600 VSS 1.61839f
C8020 VDD.n1601 VSS 0
C8021 VDD.n1602 VSS 0.03187f
C8022 VDD.n1603 VSS 0.0277f
C8023 VDD.n1604 VSS 0.0277f
C8024 VDD.n1605 VSS 0
C8025 VDD.n1606 VSS 0.03158f
C8026 VDD.n1607 VSS 1.97942f
C8027 VDD.n1608 VSS 0.02875f
C8028 VDD.n1609 VSS 0.41167f
C8029 VDD.n1610 VSS 0.41197f
C8030 VDD.n1611 VSS 0.02875f
C8031 VDD.n1612 VSS 0.0277f
C8032 VDD.n1613 VSS 0.03187f
C8033 VDD.n1614 VSS 0
C8034 VDD.n1615 VSS 1.61839f
C8035 VDD.n1616 VSS 0.03187f
C8036 VDD.n1617 VSS 1.36594f
C8037 VDD.n1618 VSS 0
C8038 VDD.n1619 VSS 0.03187f
C8039 VDD.n1620 VSS 0.0277f
C8040 VDD.n1621 VSS 0.0277f
C8041 VDD.n1622 VSS 0
C8042 VDD.n1623 VSS 0.03158f
C8043 VDD.n1624 VSS 1.61839f
C8044 VDD.n1625 VSS 0.02875f
C8045 VDD.n1626 VSS 0.41212f
C8046 VDD.n1627 VSS 0.41242f
C8047 VDD.n1628 VSS 0.02875f
C8048 VDD.n1629 VSS 0.0277f
C8049 VDD.n1630 VSS 0.03187f
C8050 VDD.n1631 VSS 0
C8051 VDD.n1632 VSS 1.36594f
C8052 VDD.n1633 VSS 0.03187f
C8053 VDD.n1634 VSS 1.7511f
C8054 VDD.n1635 VSS 0
C8055 VDD.n1636 VSS 0.03187f
C8056 VDD.n1637 VSS 0.0277f
C8057 VDD.n1638 VSS 0.0277f
C8058 VDD.n1639 VSS 0
C8059 VDD.n1640 VSS 0.03158f
C8060 VDD.n1641 VSS 1.36594f
C8061 VDD.n1642 VSS 0.02875f
C8062 VDD.n1643 VSS 0.41167f
C8063 VDD.n1644 VSS 0.41197f
C8064 VDD.n1645 VSS 1.7511f
C8065 VDD.n1646 VSS 0
C8066 VDD.n1647 VSS 0.03187f
C8067 VDD.n1648 VSS 0.0277f
C8068 VDD.n1649 VSS 0.0277f
C8069 VDD.n1650 VSS 0
C8070 VDD.n1651 VSS 0.03158f
C8071 VDD.n1652 VSS 1.36594f
C8072 VDD.n1653 VSS 0.02875f
C8073 VDD.n1654 VSS 0.43684f
C8074 VDD.n1655 VSS 0.43714f
C8075 VDD.n1656 VSS 1.7511f
C8076 VDD.n1657 VSS 0
C8077 VDD.n1658 VSS 0.03187f
C8078 VDD.n1659 VSS 0.0277f
C8079 VDD.n1660 VSS 0.0277f
C8080 VDD.n1661 VSS 0
C8081 VDD.n1662 VSS 0.03158f
C8082 VDD.n1663 VSS 1.36594f
C8083 VDD.n1664 VSS 0.02875f
C8084 VDD.n1665 VSS 0.41167f
C8085 VDD.n1666 VSS 0.41197f
C8086 VDD.n1667 VSS 1.7511f
C8087 VDD.n1668 VSS 0
C8088 VDD.n1669 VSS 0.03187f
C8089 VDD.n1670 VSS 0.0277f
C8090 VDD.n1671 VSS 0.0277f
C8091 VDD.n1672 VSS 0
C8092 VDD.n1673 VSS 0.03158f
C8093 VDD.n1674 VSS 1.36594f
C8094 VDD.n1675 VSS 0.02875f
C8095 VDD.n1676 VSS 0.41405f
C8096 VDD.n1677 VSS 0.41435f
C8097 VDD.n1678 VSS 1.7511f
C8098 VDD.n1679 VSS 0
C8099 VDD.n1680 VSS 0.03187f
C8100 VDD.n1681 VSS 0.0277f
C8101 VDD.n1682 VSS 0.0277f
C8102 VDD.n1683 VSS 0
C8103 VDD.n1684 VSS 0.03158f
C8104 VDD.n1685 VSS 1.36594f
C8105 VDD.n1686 VSS 0.02875f
C8106 VDD.n1687 VSS 0.41167f
C8107 VDD.n1688 VSS 0.41197f
C8108 VDD.n1689 VSS 1.7511f
C8109 VDD.n1690 VSS 0
C8110 VDD.n1691 VSS 0.03187f
C8111 VDD.n1692 VSS 0.0277f
C8112 VDD.n1693 VSS 0.0277f
C8113 VDD.n1694 VSS 0
C8114 VDD.n1695 VSS 0.03158f
C8115 VDD.n1696 VSS 1.36594f
C8116 VDD.n1697 VSS 0.02875f
C8117 VDD.n1698 VSS 0.41152f
C8118 VDD.n1699 VSS 0.41182f
C8119 VDD.n1700 VSS 1.7511f
C8120 VDD.n1701 VSS 0
C8121 VDD.n1702 VSS 0.03187f
C8122 VDD.n1703 VSS 0.0277f
C8123 VDD.n1704 VSS 0.0277f
C8124 VDD.n1705 VSS 0
C8125 VDD.n1706 VSS 0.03158f
C8126 VDD.n1707 VSS 1.36594f
C8127 VDD.n1708 VSS 0.02875f
C8128 VDD.n1709 VSS 0.41167f
C8129 VDD.n1710 VSS 0.41197f
C8130 VDD.n1711 VSS 0.02875f
C8131 VDD.n1712 VSS 0.0277f
C8132 VDD.n1713 VSS 0.03187f
C8133 VDD.n1714 VSS 0.50862f
C8134 VDD.n1715 VSS 1.7511f
C8135 VDD.n1716 VSS 0.03158f
C8136 VDD.n1717 VSS 1.7511f
C8137 VDD.n1718 VSS 0.03187f
C8138 VDD.n1719 VSS 0.03158f
C8139 VDD.n1720 VSS 1.45143f
C8140 VDD.n1721 VSS 0.03158f
C8141 VDD.n1722 VSS 0
C8142 VDD.n1723 VSS 0.0277f
C8143 VDD.n1724 VSS 1.45143f
C8144 VDD.n1725 VSS 0.50862f
C8145 VDD.n1726 VSS 0.02876f
C8146 VDD.n1727 VSS 0.02875f
C8147 VDD.n1728 VSS 0.41197f
C8148 VDD.n1729 VSS 0.0277f
C8149 VDD.n1730 VSS 0
C8150 VDD.n1731 VSS 0.03158f
C8151 VDD.n1732 VSS 0.03187f
C8152 VDD.n1733 VSS 0
C8153 VDD.n1734 VSS 0.41167f
C8154 VDD.n1735 VSS 0.02875f
C8155 VDD.n1736 VSS 0.02875f
C8156 VDD.n1737 VSS 0.41182f
C8157 VDD.n1738 VSS 0.03187f
C8158 VDD.n1739 VSS 0.03158f
C8159 VDD.n1740 VSS 1.45143f
C8160 VDD.n1741 VSS 0.03158f
C8161 VDD.n1742 VSS 0
C8162 VDD.n1743 VSS 0.0277f
C8163 VDD.n1744 VSS 1.45143f
C8164 VDD.n1745 VSS 0
C8165 VDD.n1746 VSS 0.41152f
C8166 VDD.n1747 VSS 0.02875f
C8167 VDD.n1748 VSS 0.02875f
C8168 VDD.n1749 VSS 0.41197f
C8169 VDD.n1750 VSS 0.0277f
C8170 VDD.n1751 VSS 0
C8171 VDD.n1752 VSS 0.03158f
C8172 VDD.n1753 VSS 0.03187f
C8173 VDD.n1754 VSS 0
C8174 VDD.n1755 VSS 0.41167f
C8175 VDD.n1756 VSS 0.02875f
C8176 VDD.n1757 VSS 0.02875f
C8177 VDD.n1758 VSS 0.41435f
C8178 VDD.n1759 VSS 0.0277f
C8179 VDD.n1760 VSS 0
C8180 VDD.n1761 VSS 0.03158f
C8181 VDD.n1762 VSS 0.03187f
C8182 VDD.n1763 VSS 0
C8183 VDD.n1764 VSS 0.41405f
C8184 VDD.n1765 VSS 0.02875f
C8185 VDD.n1766 VSS 0.02875f
C8186 VDD.n1767 VSS 0.41197f
C8187 VDD.n1768 VSS 0.0277f
C8188 VDD.n1769 VSS 0
C8189 VDD.n1770 VSS 0.03158f
C8190 VDD.n1771 VSS 0.03187f
C8191 VDD.n1772 VSS 0
C8192 VDD.n1773 VSS 0.41167f
C8193 VDD.n1774 VSS 0.02875f
C8194 VDD.n1775 VSS 0.02875f
C8195 VDD.n1776 VSS 0.43714f
C8196 VDD.n1777 VSS 0.0277f
C8197 VDD.n1778 VSS 0
C8198 VDD.n1779 VSS 0.03158f
C8199 VDD.n1780 VSS 0.03187f
C8200 VDD.n1781 VSS 0
C8201 VDD.n1782 VSS 0.43684f
C8202 VDD.n1783 VSS 0.02875f
C8203 VDD.n1784 VSS 0.02875f
C8204 VDD.n1785 VSS 0.41197f
C8205 VDD.n1786 VSS 0.0277f
C8206 VDD.n1787 VSS 0
C8207 VDD.n1788 VSS 0.03158f
C8208 VDD.n1789 VSS 0.03187f
C8209 VDD.n1790 VSS 0
C8210 VDD.n1791 VSS 0.41167f
C8211 VDD.n1792 VSS 0.02875f
C8212 VDD.n1793 VSS 0.02875f
C8213 VDD.n1794 VSS 0.41242f
C8214 VDD.n1795 VSS 0.41212f
C8215 VDD.n1796 VSS 0
C8216 VDD.n1797 VSS 0.03187f
C8217 VDD.n1798 VSS 0.0277f
C8218 VDD.n1799 VSS 0.0277f
C8219 VDD.n1800 VSS 0
C8220 VDD.n1801 VSS 0.03158f
C8221 VDD.n1802 VSS 1.7511f
C8222 VDD.n1803 VSS 0.03158f
C8223 VDD.n1804 VSS 0
C8224 VDD.n1805 VSS 0.0277f
C8225 VDD.n1806 VSS 1.7511f
C8226 VDD.n1807 VSS 0
C8227 VDD.n1808 VSS 0.41212f
C8228 VDD.n1809 VSS 0.02875f
C8229 VDD.n1810 VSS 0.02875f
C8230 VDD.n1811 VSS 0.41197f
C8231 VDD.n1812 VSS 0.41167f
C8232 VDD.n1813 VSS 0
C8233 VDD.n1814 VSS 0.03187f
C8234 VDD.n1815 VSS 0.0277f
C8235 VDD.n1816 VSS 0.0277f
C8236 VDD.n1817 VSS 0
C8237 VDD.n1818 VSS 0.03158f
C8238 VDD.n1819 VSS 1.36594f
C8239 VDD.n1820 VSS 0.03158f
C8240 VDD.n1821 VSS 0
C8241 VDD.n1822 VSS 0.0277f
C8242 VDD.n1823 VSS 1.36594f
C8243 VDD.n1824 VSS 0
C8244 VDD.n1825 VSS 0.41167f
C8245 VDD.n1826 VSS 0.02875f
C8246 VDD.n1827 VSS 0.02875f
C8247 VDD.n1828 VSS 0.41182f
C8248 VDD.n1829 VSS 0.41152f
C8249 VDD.n1830 VSS 0
C8250 VDD.n1831 VSS 0.03187f
C8251 VDD.n1832 VSS 0.0277f
C8252 VDD.n1833 VSS 0.0277f
C8253 VDD.n1834 VSS 0
C8254 VDD.n1835 VSS 0.03158f
C8255 VDD.n1836 VSS 1.61839f
C8256 VDD.n1837 VSS 0.03158f
C8257 VDD.n1838 VSS 0
C8258 VDD.n1839 VSS 0.0277f
C8259 VDD.n1840 VSS 1.61839f
C8260 VDD.n1841 VSS 0
C8261 VDD.n1842 VSS 0.41152f
C8262 VDD.n1843 VSS 0.02875f
C8263 VDD.n1844 VSS 0.02875f
C8264 VDD.n1845 VSS 0.41197f
C8265 VDD.n1846 VSS 0.03187f
C8266 VDD.n1847 VSS 0.03158f
C8267 VDD.n1848 VSS 1.61839f
C8268 VDD.n1849 VSS 0.03158f
C8269 VDD.n1850 VSS 0
C8270 VDD.n1851 VSS 0.0277f
C8271 VDD.n1852 VSS 1.61839f
C8272 VDD.n1853 VSS 0
C8273 VDD.n1854 VSS 0.41167f
C8274 VDD.n1855 VSS 0.02875f
C8275 VDD.n1856 VSS 0.02875f
C8276 VDD.n1857 VSS 3.25942f
C8277 VDD.n1858 VSS 3.25912f
C8278 VDD.n1859 VSS 0.03158f
C8279 VDD.n1860 VSS 0
C8280 VDD.n1861 VSS 0.03187f
C8281 VDD.n1862 VSS 0.02875f
C8282 VDD.n1863 VSS 1.98359f
C8283 VDD.n1864 VSS 0.03158f
C8284 VDD.n1865 VSS 0
C8285 VDD.n1866 VSS 0
C8286 VDD.n1867 VSS 0.02875f
C8287 VDD.n1868 VSS 0.03158f
C8288 VDD.n1869 VSS 0.03187f
C8289 VDD.n1870 VSS 1.61839f
C8290 VDD.n1871 VSS 0
C8291 VDD.n1872 VSS 0.03187f
C8292 VDD.n1873 VSS 0.0277f
C8293 VDD.n1874 VSS 0.0277f
C8294 VDD.n1875 VSS 0
C8295 VDD.n1876 VSS 0.03158f
C8296 VDD.n1877 VSS 1.98419f
C8297 VDD.n1878 VSS 0.02875f
C8298 VDD.n1879 VSS 0.41167f
C8299 VDD.n1880 VSS 0.41197f
C8300 VDD.n1881 VSS 0.02875f
C8301 VDD.n1882 VSS 0.0277f
C8302 VDD.n1883 VSS 0.03187f
C8303 VDD.n1884 VSS 0
C8304 VDD.n1885 VSS 1.61839f
C8305 VDD.n1886 VSS 0.03187f
C8306 VDD.n1887 VSS 1.36594f
C8307 VDD.n1888 VSS 0
C8308 VDD.n1889 VSS 0.03187f
C8309 VDD.n1890 VSS 0.0277f
C8310 VDD.n1891 VSS 0.0277f
C8311 VDD.n1892 VSS 0
C8312 VDD.n1893 VSS 0.03158f
C8313 VDD.n1894 VSS 1.61839f
C8314 VDD.n1895 VSS 0.02875f
C8315 VDD.n1896 VSS 3.25912f
C8316 VDD.n1897 VSS 3.25942f
C8317 VDD.n1898 VSS 0.02875f
C8318 VDD.n1899 VSS 0.0277f
C8319 VDD.n1900 VSS 0.03187f
C8320 VDD.n1901 VSS 0
C8321 VDD.n1902 VSS 1.36594f
C8322 VDD.n1903 VSS 0.03187f
C8323 VDD.n1904 VSS 1.7511f
C8324 VDD.n1905 VSS 0
C8325 VDD.n1906 VSS 0.03187f
C8326 VDD.n1907 VSS 0.0277f
C8327 VDD.n1908 VSS 0.0277f
C8328 VDD.n1909 VSS 0
C8329 VDD.n1910 VSS 0.03158f
C8330 VDD.n1911 VSS 1.36594f
C8331 VDD.n1912 VSS 0.02875f
C8332 VDD.n1913 VSS 0.41167f
C8333 VDD.n1914 VSS 0.41197f
C8334 VDD.n1915 VSS 0.02875f
C8335 VDD.n1916 VSS 0.0277f
C8336 VDD.n1917 VSS 0.03187f
C8337 VDD.n1918 VSS 0
C8338 VDD.n1919 VSS 1.7511f
C8339 VDD.n1920 VSS 0.03187f
C8340 VDD.n1921 VSS 1.45143f
C8341 VDD.n1922 VSS 0
C8342 VDD.n1923 VSS 0.03187f
C8343 VDD.n1924 VSS 0.0277f
C8344 VDD.n1925 VSS 0.0277f
C8345 VDD.n1926 VSS 0
C8346 VDD.n1927 VSS 0.03158f
C8347 VDD.n1928 VSS 1.7511f
C8348 VDD.n1929 VSS 0.02875f
C8349 VDD.n1930 VSS 0.41152f
C8350 VDD.n1931 VSS 0.41182f
C8351 VDD.n1932 VSS 0.02875f
C8352 VDD.n1933 VSS 0.0277f
C8353 VDD.n1934 VSS 0.03187f
C8354 VDD.n1935 VSS 0
C8355 VDD.n1936 VSS 1.45143f
C8356 VDD.n1937 VSS 0.03187f
C8357 VDD.n1938 VSS 1.40123f
C8358 VDD.n1939 VSS 0
C8359 VDD.n1940 VSS 0.03187f
C8360 VDD.n1941 VSS 0.0277f
C8361 VDD.n1942 VSS 0.0277f
C8362 VDD.n1943 VSS 0
C8363 VDD.n1944 VSS 0.03158f
C8364 VDD.n1945 VSS 1.45143f
C8365 VDD.n1946 VSS 0.02875f
C8366 VDD.n1947 VSS 0.41167f
C8367 VDD.n1948 VSS 0.41197f
C8368 VDD.n1949 VSS 1.40123f
C8369 VDD.n1950 VSS 0
C8370 VDD.n1951 VSS 0.03187f
C8371 VDD.n1952 VSS 0.0277f
C8372 VDD.n1953 VSS 0.0277f
C8373 VDD.n1954 VSS 0
C8374 VDD.n1955 VSS 0.03158f
C8375 VDD.n1956 VSS 1.45143f
C8376 VDD.n1957 VSS 0.02875f
C8377 VDD.n1958 VSS 0.41212f
C8378 VDD.n1959 VSS 0.41242f
C8379 VDD.n1960 VSS 0.01892f
C8380 VDD.n1961 VSS 0.01262f
C8381 VDD.n1962 VSS 0.01021f
C8382 VDD.n1963 VSS 0.05326f
C8383 VDD.t35 VSS 0.07897f
C8384 VDD.t169 VSS 0.07897f
C8385 VDD.n1964 VSS 0.05176f
C8386 VDD.n1965 VSS 0.02851f
C8387 VDD.n1966 VSS 0.01262f
C8388 VDD.n1967 VSS 0.01892f
C8389 VDD.n1968 VSS 0.2042f
C8390 VDD.n1969 VSS 0.02432f
C8391 VDD.n1970 VSS 0.0073f
C8392 VDD.n1971 VSS 0.01494f
C8393 VDD.n1972 VSS 0.01313f
C8394 VDD.t107 VSS 0.07801f
C8395 VDD.t415 VSS 0.07801f
C8396 VDD.n1973 VSS 0.05428f
C8397 VDD.n1974 VSS 0.02812f
C8398 VDD.t416 VSS 0.00488f
C8399 VDD.n1975 VSS 0.01551f
C8400 VDD.n1976 VSS 0.03531f
C8401 VDD.n1977 VSS 0.04005f
C8402 VDD.t274 VSS 4.63283f
C8403 VDD.t258 VSS 0.07545f
C8404 VDD.n1978 VSS 0.07641f
C8405 VDD.t296 VSS 0.07545f
C8406 VDD.n1979 VSS -0.01214f
C8407 VDD.t687 VSS 0.07545f
C8408 VDD.n1980 VSS -0.01214f
C8409 VDD.t688 VSS 0.07545f
C8410 VDD.n1981 VSS -0.01214f
C8411 VDD.t256 VSS 5.59932f
C8412 VDD.t591 VSS 0.07545f
C8413 VDD.n1982 VSS 0.02577f
C8414 VDD.t260 VSS 0.07545f
C8415 VDD.n1983 VSS 0.01596f
C8416 VDD.t259 VSS 0.07545f
C8417 VDD.n1984 VSS 0.02996f
C8418 VDD.t257 VSS 0.07545f
C8419 VDD.n1985 VSS 0.07074f
C8420 VDD.n1986 VSS 0.00854f
C8421 VDD.n1987 VSS 0.05204f
C8422 VDD.n1988 VSS 0.00854f
C8423 VDD.n1989 VSS 0.01302f
C8424 VDD.n1990 VSS 0.00854f
C8425 VDD.n1991 VSS 0.0174f
C8426 VDD.n1992 VSS 0.02393f
C8427 VDD.n1993 VSS 0.00854f
C8428 VDD.n1994 VSS 0.05204f
C8429 VDD.n1995 VSS 0.00854f
C8430 VDD.n1996 VSS 0.0174f
C8431 VDD.n1997 VSS 0.02393f
C8432 VDD.n1998 VSS 0.00854f
C8433 VDD.n1999 VSS 0.06603f
C8434 VDD.n2000 VSS 0.00854f
C8435 VDD.n2001 VSS 0.0174f
C8436 VDD.n2002 VSS 0.02393f
C8437 VDD.n2003 VSS 0.00854f
C8438 VDD.n2004 VSS 0.04195f
C8439 VDD.t277 VSS 0.07545f
C8440 VDD.n2005 VSS 0.09574f
C8441 VDD.n2006 VSS 0.04819f
C8442 VDD.t280 VSS 0.07545f
C8443 VDD.n2007 VSS 0.16494f
C8444 VDD.t398 VSS 0.07545f
C8445 VDD.n2008 VSS 0.07663f
C8446 VDD.t448 VSS 0.07545f
C8447 VDD.n2009 VSS 0.07074f
C8448 VDD.t278 VSS 0.07545f
C8449 VDD.n2010 VSS -0.01214f
C8450 VDD.t275 VSS 0.07545f
C8451 VDD.n2011 VSS 0.02996f
C8452 VDD.t281 VSS 0.07545f
C8453 VDD.n2012 VSS -0.01214f
C8454 VDD.t276 VSS 0.07545f
C8455 VDD.n2013 VSS 0.01596f
C8456 VDD.t447 VSS 0.07545f
C8457 VDD.n2014 VSS -0.01214f
C8458 VDD.n2015 VSS 0.04504f
C8459 VDD.n2016 VSS 0.02393f
C8460 VDD.n2017 VSS 0.00854f
C8461 VDD.n2018 VSS 0.05198f
C8462 VDD.n2019 VSS 0.00854f
C8463 VDD.n2020 VSS 0.06603f
C8464 VDD.n2021 VSS 0.00854f
C8465 VDD.n2022 VSS 0.00854f
C8466 VDD.n2023 VSS 0.05204f
C8467 VDD.n2024 VSS 0.00854f
C8468 VDD.n2025 VSS 0.05204f
C8469 VDD.n2026 VSS 0.00854f
C8470 VDD.n2027 VSS 0.00854f
C8471 VDD.n2028 VSS 0.05204f
C8472 VDD.n2029 VSS 0.00854f
C8473 VDD.n2030 VSS 0.00854f
C8474 VDD.n2031 VSS 0.05204f
C8475 VDD.n2032 VSS 0.00854f
C8476 VDD.n2033 VSS 0.02244f
C8477 VDD.n2034 VSS 0.13045f
C8478 VDD.n2035 VSS 0.06319f
C8479 VDD.n2036 VSS 0.00854f
C8480 VDD.n2037 VSS 0.02393f
C8481 VDD.n2038 VSS 0.02393f
C8482 VDD.n2039 VSS 0.05204f
C8483 VDD.n2040 VSS 0.0174f
C8484 VDD.n2041 VSS 0.0174f
C8485 VDD.n2042 VSS 0.00854f
C8486 VDD.n2043 VSS 0.02393f
C8487 VDD.n2044 VSS 0.02393f
C8488 VDD.n2045 VSS 0.01274f
C8489 VDD.n2046 VSS 0.03467f
C8490 VDD.n2047 VSS 0.03467f
C8491 VDD.n2048 VSS 0.10676f
C8492 VDD.n2049 VSS 0.02393f
C8493 VDD.n2050 VSS 0.01274f
C8494 VDD.n2051 VSS 0.00854f
C8495 VDD.n2052 VSS 0.05198f
C8496 VDD.n2053 VSS 0.0174f
C8497 VDD.n2054 VSS 0.0174f
C8498 VDD.n2055 VSS 0.00854f
C8499 VDD.n2056 VSS 0.02393f
C8500 VDD.n2057 VSS 0.02393f
C8501 VDD.n2058 VSS 0.04504f
C8502 VDD.n2059 VSS 0.02181f
C8503 VDD.n2060 VSS 0.02181f
C8504 VDD.n2061 VSS 0.03368f
C8505 VDD.n2062 VSS 0.02393f
C8506 VDD.n2063 VSS 0.02393f
C8507 VDD.n2064 VSS 0.00854f
C8508 VDD.n2065 VSS 0.0174f
C8509 VDD.n2066 VSS 0.0174f
C8510 VDD.n2067 VSS 0.05204f
C8511 VDD.n2068 VSS 0.02393f
C8512 VDD.n2069 VSS 0.01274f
C8513 VDD.n2070 VSS 0.00854f
C8514 VDD.n2071 VSS 0.05198f
C8515 VDD.n2072 VSS 0.0174f
C8516 VDD.n2073 VSS 0.0174f
C8517 VDD.n2074 VSS 0.00854f
C8518 VDD.n2075 VSS 0.02393f
C8519 VDD.n2076 VSS 0.02393f
C8520 VDD.n2077 VSS 0.04504f
C8521 VDD.n2078 VSS 0.0174f
C8522 VDD.n2079 VSS 0.0174f
C8523 VDD.n2080 VSS 0.01969f
C8524 VDD.n2081 VSS 0.02393f
C8525 VDD.n2082 VSS 0.02393f
C8526 VDD.n2083 VSS 0.00854f
C8527 VDD.n2084 VSS 0.02181f
C8528 VDD.n2085 VSS 0.02181f
C8529 VDD.n2086 VSS 0.06603f
C8530 VDD.n2087 VSS 0.02393f
C8531 VDD.n2088 VSS 0.01274f
C8532 VDD.n2089 VSS 0.00854f
C8533 VDD.n2090 VSS 0.0174f
C8534 VDD.n2091 VSS 0.0174f
C8535 VDD.n2092 VSS 0.05204f
C8536 VDD.n2093 VSS 0.02393f
C8537 VDD.n2094 VSS 0.02393f
C8538 VDD.n2095 VSS 0.00854f
C8539 VDD.n2096 VSS 0.02049f
C8540 VDD.n2097 VSS 0.08176f
C8541 VDD.n2098 VSS 0.03531f
C8542 VDD.n2099 VSS 0.02393f
C8543 VDD.n2100 VSS 0.00854f
C8544 VDD.n2101 VSS 0.00854f
C8545 VDD.n2102 VSS 0.02049f
C8546 VDD.n2103 VSS 0.0295f
C8547 VDD.t279 VSS 0.07545f
C8548 VDD.n2104 VSS 0.02577f
C8549 VDD.n2105 VSS 3.96598f
C8550 VDD.t465 VSS 4.49626f
C8551 VDD.t461 VSS 3.33018f
C8552 VDD.n2106 VSS 2.99949f
C8553 VDD.n2107 VSS 0.00854f
C8554 VDD.n2108 VSS 0.0295f
C8555 VDD.n2109 VSS 0.00854f
C8556 VDD.n2110 VSS 0.05204f
C8557 VDD.n2111 VSS 0.00854f
C8558 VDD.n2112 VSS 0.06603f
C8559 VDD.n2113 VSS 0.00854f
C8560 VDD.n2114 VSS 0.01969f
C8561 VDD.n2115 VSS 0.00854f
C8562 VDD.n2116 VSS 0.05204f
C8563 VDD.n2117 VSS 0.00854f
C8564 VDD.n2118 VSS 0.05204f
C8565 VDD.n2119 VSS 0.00854f
C8566 VDD.n2120 VSS 0.03368f
C8567 VDD.n2121 VSS 0.00854f
C8568 VDD.n2122 VSS 0.05204f
C8569 VDD.n2123 VSS 0.00854f
C8570 VDD.n2124 VSS 0.10676f
C8571 VDD.n2125 VSS 0.00854f
C8572 VDD.n2126 VSS 0.05204f
C8573 VDD.n2127 VSS 0.00854f
C8574 VDD.n2128 VSS 0.02244f
C8575 VDD.t503 VSS 0.07545f
C8576 VDD.n2129 VSS 0.16494f
C8577 VDD.t509 VSS 0.07545f
C8578 VDD.n2130 VSS 0.07663f
C8579 VDD.n2131 VSS 0.13045f
C8580 VDD.n2132 VSS 0.06319f
C8581 VDD.n2133 VSS 0.00854f
C8582 VDD.n2134 VSS 0.02393f
C8583 VDD.n2135 VSS 0.02393f
C8584 VDD.n2136 VSS 0.05204f
C8585 VDD.n2137 VSS 0.0174f
C8586 VDD.n2138 VSS 0.0174f
C8587 VDD.n2139 VSS 0.00854f
C8588 VDD.n2140 VSS 0.02393f
C8589 VDD.n2141 VSS 0.02393f
C8590 VDD.t508 VSS 0.07545f
C8591 VDD.n2142 VSS 0.07074f
C8592 VDD.n2143 VSS 0.01274f
C8593 VDD.n2144 VSS 0.03467f
C8594 VDD.n2145 VSS 0.03467f
C8595 VDD.n2146 VSS 0.00854f
C8596 VDD.n2147 VSS 0.02393f
C8597 VDD.n2148 VSS 0.01274f
C8598 VDD.t469 VSS 0.07545f
C8599 VDD.n2149 VSS -0.01214f
C8600 VDD.n2150 VSS 0.05198f
C8601 VDD.n2151 VSS 0.0174f
C8602 VDD.n2152 VSS 0.0174f
C8603 VDD.n2153 VSS 0.00854f
C8604 VDD.n2154 VSS 0.02393f
C8605 VDD.n2155 VSS 0.02393f
C8606 VDD.t462 VSS 0.07545f
C8607 VDD.n2156 VSS 0.02996f
C8608 VDD.n2157 VSS 0.04504f
C8609 VDD.n2158 VSS 0.02181f
C8610 VDD.n2159 VSS 0.02181f
C8611 VDD.n2160 VSS 0.00854f
C8612 VDD.n2161 VSS 0.02393f
C8613 VDD.n2162 VSS 0.02393f
C8614 VDD.n2163 VSS 0.05204f
C8615 VDD.n2164 VSS 0.0174f
C8616 VDD.n2165 VSS 0.0174f
C8617 VDD.n2166 VSS 0.00854f
C8618 VDD.n2167 VSS 0.02393f
C8619 VDD.n2168 VSS 0.01274f
C8620 VDD.t504 VSS 0.07545f
C8621 VDD.n2169 VSS -0.01214f
C8622 VDD.n2170 VSS 0.05198f
C8623 VDD.n2171 VSS 0.0174f
C8624 VDD.n2172 VSS 0.0174f
C8625 VDD.n2173 VSS 0.00854f
C8626 VDD.n2174 VSS 0.02393f
C8627 VDD.n2175 VSS 0.02393f
C8628 VDD.t463 VSS 0.07545f
C8629 VDD.n2176 VSS 0.01596f
C8630 VDD.n2177 VSS 0.04504f
C8631 VDD.n2178 VSS 0.0174f
C8632 VDD.n2179 VSS 0.0174f
C8633 VDD.n2180 VSS 0.00854f
C8634 VDD.n2181 VSS 0.02393f
C8635 VDD.n2182 VSS 0.02393f
C8636 VDD.n2183 VSS 0.06603f
C8637 VDD.n2184 VSS 0.02181f
C8638 VDD.n2185 VSS 0.02181f
C8639 VDD.n2186 VSS 0.00854f
C8640 VDD.n2187 VSS 0.02393f
C8641 VDD.n2188 VSS 0.01274f
C8642 VDD.t505 VSS 0.07545f
C8643 VDD.n2189 VSS -0.01214f
C8644 VDD.n2190 VSS 0.05198f
C8645 VDD.n2191 VSS 0.0174f
C8646 VDD.n2192 VSS 0.0174f
C8647 VDD.n2193 VSS 0.00854f
C8648 VDD.n2194 VSS 0.02393f
C8649 VDD.n2195 VSS 0.02393f
C8650 VDD.t470 VSS 0.07545f
C8651 VDD.n2196 VSS 0.02577f
C8652 VDD.n2197 VSS 0.04504f
C8653 VDD.n2198 VSS 0.02049f
C8654 VDD.n2199 VSS 0.02049f
C8655 VDD.n2200 VSS 0.00854f
C8656 VDD.n2201 VSS 0.02393f
C8657 VDD.n2202 VSS 0.02393f
C8658 VDD.n2203 VSS 0.0419f
C8659 VDD.n2204 VSS 0.03531f
C8660 VDD.n2205 VSS 0.08176f
C8661 VDD.t464 VSS 0.07545f
C8662 VDD.n2206 VSS 0.09574f
C8663 VDD.n2207 VSS 0.03846f
C8664 VDD.t466 VSS 0.17036f
C8665 VDD.t693 VSS 0.07545f
C8666 VDD.n2208 VSS 0.14561f
C8667 VDD.t471 VSS 0.07545f
C8668 VDD.n2209 VSS 0.12314f
C8669 VDD.t506 VSS 0.07545f
C8670 VDD.n2210 VSS 0.12314f
C8671 VDD.t500 VSS 0.07545f
C8672 VDD.n2211 VSS 0.12314f
C8673 VDD.t467 VSS 0.07545f
C8674 VDD.n2212 VSS 0.12314f
C8675 VDD.t501 VSS 0.07545f
C8676 VDD.n2213 VSS 0.12314f
C8677 VDD.t468 VSS 0.07545f
C8678 VDD.n2214 VSS 0.12314f
C8679 VDD.t507 VSS 0.07545f
C8680 VDD.n2215 VSS 0.11633f
C8681 VDD.t502 VSS 0.11074f
C8682 VDD.n2216 VSS 0.08889f
C8683 VDD.n2217 VSS 0.00892f
C8684 VDD.n2218 VSS 0.03188f
C8685 VDD.n2219 VSS 0.03681f
C8686 VDD.n2220 VSS 0.04618f
C8687 VDD.n2221 VSS 0.0318f
C8688 VDD.n2222 VSS 0.04964f
C8689 VDD.n2223 VSS 0.04223f
C8690 VDD.n2224 VSS 0.00854f
C8691 VDD.n2225 VSS 0.02393f
C8692 VDD.n2226 VSS 0.02393f
C8693 VDD.n2227 VSS 0.02922f
C8694 VDD.n2228 VSS 0.02049f
C8695 VDD.n2229 VSS 0.04531f
C8696 VDD.n2230 VSS 0.02049f
C8697 VDD.n2231 VSS 0.00854f
C8698 VDD.n2232 VSS 0.00854f
C8699 VDD.n2233 VSS 0.02393f
C8700 VDD.n2234 VSS 0.05204f
C8701 VDD.n2235 VSS 0.0517f
C8702 VDD.n2236 VSS 0.0174f
C8703 VDD.n2237 VSS 0.00854f
C8704 VDD.n2238 VSS 0.01302f
C8705 VDD.n2239 VSS 0.02393f
C8706 VDD.n2240 VSS 0.06603f
C8707 VDD.n2241 VSS 0.02181f
C8708 VDD.n2242 VSS 0.02181f
C8709 VDD.n2243 VSS 0.00854f
C8710 VDD.n2244 VSS 0.02393f
C8711 VDD.n2245 VSS 0.02393f
C8712 VDD.n2246 VSS 0.01941f
C8713 VDD.n2247 VSS 0.0174f
C8714 VDD.n2248 VSS 0.04531f
C8715 VDD.n2249 VSS 0.0174f
C8716 VDD.n2250 VSS 0.00854f
C8717 VDD.n2251 VSS 0.00854f
C8718 VDD.n2252 VSS 0.02393f
C8719 VDD.n2253 VSS 0.05204f
C8720 VDD.n2254 VSS 0.0517f
C8721 VDD.n2255 VSS 0.0174f
C8722 VDD.n2256 VSS 0.00854f
C8723 VDD.n2257 VSS 0.01302f
C8724 VDD.n2258 VSS 0.02393f
C8725 VDD.n2259 VSS 0.05204f
C8726 VDD.n2260 VSS 0.0174f
C8727 VDD.n2261 VSS 0.0174f
C8728 VDD.n2262 VSS 0.00854f
C8729 VDD.n2263 VSS 0.02393f
C8730 VDD.n2264 VSS 0.02393f
C8731 VDD.n2265 VSS 0.03341f
C8732 VDD.n2266 VSS 0.02181f
C8733 VDD.n2267 VSS 0.04531f
C8734 VDD.n2268 VSS 0.02181f
C8735 VDD.n2269 VSS 0.00854f
C8736 VDD.n2270 VSS 0.00854f
C8737 VDD.n2271 VSS 0.02393f
C8738 VDD.n2272 VSS 0.05204f
C8739 VDD.n2273 VSS 0.0517f
C8740 VDD.n2274 VSS 0.0174f
C8741 VDD.n2275 VSS 0.00854f
C8742 VDD.n2276 VSS 0.01302f
C8743 VDD.n2277 VSS 0.02393f
C8744 VDD.n2278 VSS 0.10648f
C8745 VDD.n2279 VSS 0.03467f
C8746 VDD.n2280 VSS 0.03467f
C8747 VDD.n2281 VSS 0.00854f
C8748 VDD.n2282 VSS 0.02393f
C8749 VDD.n2283 VSS 0.02393f
C8750 VDD.n2284 VSS 0.05204f
C8751 VDD.n2285 VSS 0.0174f
C8752 VDD.n2286 VSS 0.0174f
C8753 VDD.n2287 VSS 0.00854f
C8754 VDD.n2288 VSS 0.02393f
C8755 VDD.n2289 VSS 0.02393f
C8756 VDD.n2290 VSS 0.02217f
C8757 VDD.n2291 VSS 0.06317f
C8758 VDD.n2292 VSS 0.1306f
C8759 VDD.t670 VSS 0.07545f
C8760 VDD.n2293 VSS 0.16458f
C8761 VDD.n2294 VSS 3.96598f
C8762 VDD.t261 VSS 0.07545f
C8763 VDD.n2295 VSS 0.09584f
C8764 VDD.n2296 VSS 0.08185f
C8765 VDD.n2297 VSS 0.01421f
C8766 VDD.n2298 VSS 0.01666f
C8767 VDD.n2299 VSS -0.00164f
C8768 VDD.n2300 VSS 0.05436f
C8769 VDD.t34 VSS 0.07801f
C8770 VDD.t168 VSS 0.07801f
C8771 VDD.n2301 VSS -0.00166f
C8772 VDD.n2302 VSS 0.05436f
C8773 VDD.n2303 VSS 0.05428f
C8774 VDD.n2304 VSS 0.00952f
C8775 VDD.t108 VSS 0.0048f
C8776 VDD.n2305 VSS 0.00798f
C8777 VDD.n2306 VSS 0.01014f
C8778 VDD.n2307 VSS 0.0128f
C8779 VDD.n2308 VSS 0.00667f
C8780 VDD.n2309 VSS 1.17797f
C8781 VDD.n2310 VSS 1.17812f
C8782 VDD.n2311 VSS 0
C8783 VDD.n2312 VSS 0.03187f
C8784 VDD.n2313 VSS 0.0277f
C8785 VDD.n2314 VSS 0.0277f
C8786 VDD.n2315 VSS 0
C8787 VDD.n2316 VSS 0.03158f
C8788 VDD.n2317 VSS 1.45143f
C8789 VDD.n2318 VSS 0.02875f
C8790 VDD.n2319 VSS 0.41167f
C8791 VDD.n2320 VSS 0.41197f
C8792 VDD.n2321 VSS 1.40123f
C8793 VDD.n2322 VSS 0
C8794 VDD.n2323 VSS 0.03187f
C8795 VDD.n2324 VSS 0.0277f
C8796 VDD.n2325 VSS 0.0277f
C8797 VDD.n2326 VSS 0
C8798 VDD.n2327 VSS 0.03158f
C8799 VDD.n2328 VSS 1.45143f
C8800 VDD.n2329 VSS 0.02875f
C8801 VDD.n2330 VSS 0.43684f
C8802 VDD.n2331 VSS 0.43714f
C8803 VDD.n2332 VSS 1.40123f
C8804 VDD.n2333 VSS 0
C8805 VDD.n2334 VSS 0.03187f
C8806 VDD.n2335 VSS 0.0277f
C8807 VDD.n2336 VSS 0.0277f
C8808 VDD.n2337 VSS 0
C8809 VDD.n2338 VSS 0.03158f
C8810 VDD.n2339 VSS 1.45143f
C8811 VDD.n2340 VSS 0.02875f
C8812 VDD.n2341 VSS 0.41167f
C8813 VDD.n2342 VSS 0.41197f
C8814 VDD.n2343 VSS 1.40123f
C8815 VDD.n2344 VSS 0
C8816 VDD.n2345 VSS 0.03187f
C8817 VDD.n2346 VSS 0.0277f
C8818 VDD.n2347 VSS 0.0277f
C8819 VDD.n2348 VSS 0
C8820 VDD.n2349 VSS 0.03158f
C8821 VDD.n2350 VSS 1.45143f
C8822 VDD.n2351 VSS 0.02875f
C8823 VDD.n2352 VSS 0.41405f
C8824 VDD.n2353 VSS 0.41435f
C8825 VDD.n2354 VSS 1.40123f
C8826 VDD.n2355 VSS 0
C8827 VDD.n2356 VSS 0.03187f
C8828 VDD.n2357 VSS 0.0277f
C8829 VDD.n2358 VSS 0.0277f
C8830 VDD.n2359 VSS 0
C8831 VDD.n2360 VSS 0.03158f
C8832 VDD.n2361 VSS 1.45143f
C8833 VDD.n2362 VSS 0.02875f
C8834 VDD.n2363 VSS 0.41167f
C8835 VDD.n2364 VSS 0.41197f
C8836 VDD.n2365 VSS 0.02875f
C8837 VDD.n2366 VSS 0.0277f
C8838 VDD.n2367 VSS 0.03187f
C8839 VDD.n2368 VSS 0
C8840 VDD.n2369 VSS 1.40123f
C8841 VDD.n2370 VSS 0.03158f
C8842 VDD.n2371 VSS 1.40123f
C8843 VDD.n2372 VSS 0.0277f
C8844 VDD.n2373 VSS 0
C8845 VDD.n2374 VSS 0.03158f
C8846 VDD.n2375 VSS 0.03187f
C8847 VDD.n2376 VSS 0
C8848 VDD.n2377 VSS 0.41152f
C8849 VDD.n2378 VSS 0.02875f
C8850 VDD.n2379 VSS 0.02875f
C8851 VDD.n2380 VSS 0.41197f
C8852 VDD.n2381 VSS 0.0277f
C8853 VDD.n2382 VSS 0
C8854 VDD.n2383 VSS 0.03158f
C8855 VDD.n2384 VSS 0.03187f
C8856 VDD.n2385 VSS 0
C8857 VDD.n2386 VSS 0.41167f
C8858 VDD.n2387 VSS 0.02875f
C8859 VDD.n2388 VSS 0.02875f
C8860 VDD.n2389 VSS 0.41435f
C8861 VDD.n2390 VSS 0.0277f
C8862 VDD.n2391 VSS 0
C8863 VDD.n2392 VSS 0.03158f
C8864 VDD.n2393 VSS 0.03187f
C8865 VDD.n2394 VSS 0
C8866 VDD.n2395 VSS 0.41405f
C8867 VDD.n2396 VSS 0.02875f
C8868 VDD.n2397 VSS 0.02875f
C8869 VDD.n2398 VSS 0.41197f
C8870 VDD.n2399 VSS 0.0277f
C8871 VDD.n2400 VSS 0
C8872 VDD.n2401 VSS 0.03158f
C8873 VDD.n2402 VSS 0.03187f
C8874 VDD.n2403 VSS 0
C8875 VDD.n2404 VSS 0.41167f
C8876 VDD.n2405 VSS 0.02875f
C8877 VDD.n2406 VSS 0.02875f
C8878 VDD.n2407 VSS 0.43714f
C8879 VDD.n2408 VSS 0.0277f
C8880 VDD.n2409 VSS 0
C8881 VDD.n2410 VSS 0.03158f
C8882 VDD.n2411 VSS 0.03187f
C8883 VDD.n2412 VSS 0
C8884 VDD.n2413 VSS 0.43684f
C8885 VDD.n2414 VSS 0.02875f
C8886 VDD.n2415 VSS 0.02875f
C8887 VDD.n2416 VSS 0.41197f
C8888 VDD.n2417 VSS 0.0277f
C8889 VDD.n2418 VSS 0
C8890 VDD.n2419 VSS 0.03158f
C8891 VDD.n2420 VSS 0.03187f
C8892 VDD.n2421 VSS 0
C8893 VDD.n2422 VSS 0.41167f
C8894 VDD.n2423 VSS 0.02875f
C8895 VDD.n2424 VSS 0.02875f
C8896 VDD.n2425 VSS 0.41242f
C8897 VDD.n2426 VSS 0.0277f
C8898 VDD.n2427 VSS 0
C8899 VDD.n2428 VSS 0.03158f
C8900 VDD.n2429 VSS 0.03187f
C8901 VDD.n2430 VSS 0
C8902 VDD.n2431 VSS 0.41212f
C8903 VDD.n2432 VSS 0.02875f
C8904 VDD.n2433 VSS 0.02875f
C8905 VDD.n2434 VSS 0.41197f
C8906 VDD.n2435 VSS 0.0277f
C8907 VDD.n2436 VSS 0
C8908 VDD.n2437 VSS 0.03158f
C8909 VDD.n2438 VSS 0.03187f
C8910 VDD.n2439 VSS 0
C8911 VDD.n2440 VSS 0.41167f
C8912 VDD.n2441 VSS 0.02875f
C8913 VDD.n2442 VSS 0.02875f
C8914 VDD.n2443 VSS 0.41182f
C8915 VDD.n2444 VSS 0.41152f
C8916 VDD.n2445 VSS 0
C8917 VDD.n2446 VSS 0.03187f
C8918 VDD.n2447 VSS 0.0277f
C8919 VDD.n2448 VSS 0.0277f
C8920 VDD.n2449 VSS 0
C8921 VDD.n2450 VSS 0.03158f
C8922 VDD.n2451 VSS 1.40123f
C8923 VDD.n2452 VSS 0.03158f
C8924 VDD.n2453 VSS 0
C8925 VDD.n2454 VSS 0.0277f
C8926 VDD.n2455 VSS 1.40123f
C8927 VDD.n2456 VSS 0
C8928 VDD.n2457 VSS 0.41152f
C8929 VDD.n2458 VSS 0.02875f
C8930 VDD.n2459 VSS 0.02875f
C8931 VDD.n2460 VSS 0.41197f
C8932 VDD.n2461 VSS 0.41167f
C8933 VDD.n2462 VSS 0
C8934 VDD.n2463 VSS 0.03187f
C8935 VDD.n2464 VSS 0.0277f
C8936 VDD.n2465 VSS 0.0277f
C8937 VDD.n2466 VSS 0
C8938 VDD.n2467 VSS 0.03158f
C8939 VDD.n2468 VSS 1.45143f
C8940 VDD.n2469 VSS 0.03158f
C8941 VDD.n2470 VSS 0
C8942 VDD.n2471 VSS 0.0277f
C8943 VDD.n2472 VSS 1.45143f
C8944 VDD.n2473 VSS 0
C8945 VDD.n2474 VSS 0.41167f
C8946 VDD.n2475 VSS 0.02875f
C8947 VDD.n2476 VSS 0.02875f
C8948 VDD.n2477 VSS 3.25942f
C8949 VDD.n2478 VSS 3.25912f
C8950 VDD.n2479 VSS 0
C8951 VDD.n2480 VSS 0.03187f
C8952 VDD.n2481 VSS 0.0277f
C8953 VDD.n2482 VSS 0.0277f
C8954 VDD.n2483 VSS 0
C8955 VDD.n2484 VSS 0.03158f
C8956 VDD.n2485 VSS 1.7511f
C8957 VDD.n2486 VSS 0.03158f
C8958 VDD.n2487 VSS 0
C8959 VDD.n2488 VSS 0.0277f
C8960 VDD.n2489 VSS 1.7511f
C8961 VDD.n2490 VSS 0
C8962 VDD.n2491 VSS 3.25912f
C8963 VDD.n2492 VSS 0.02875f
C8964 VDD.n2493 VSS 0.02875f
C8965 VDD.n2494 VSS 0.41197f
C8966 VDD.n2495 VSS 0.41167f
C8967 VDD.n2496 VSS 0
C8968 VDD.n2497 VSS 0.03187f
C8969 VDD.n2498 VSS 0.0277f
C8970 VDD.n2499 VSS 0.0277f
C8971 VDD.n2500 VSS 0
C8972 VDD.n2501 VSS 0.03158f
C8973 VDD.n2502 VSS 1.36594f
C8974 VDD.n2503 VSS 0.03158f
C8975 VDD.n2504 VSS 0
C8976 VDD.n2505 VSS 0.0277f
C8977 VDD.n2506 VSS 1.36594f
C8978 VDD.n2507 VSS 0
C8979 VDD.n2508 VSS 0.41167f
C8980 VDD.n2509 VSS 0.02875f
C8981 VDD.n2510 VSS 0.02875f
C8982 VDD.n2511 VSS 0.41182f
C8983 VDD.n2512 VSS 0.41152f
C8984 VDD.n2513 VSS 0
C8985 VDD.n2514 VSS 0.03187f
C8986 VDD.n2515 VSS 0.0277f
C8987 VDD.n2516 VSS 0.0277f
C8988 VDD.n2517 VSS 0
C8989 VDD.n2518 VSS 0.03158f
C8990 VDD.n2519 VSS 1.61839f
C8991 VDD.n2520 VSS 0.03158f
C8992 VDD.n2521 VSS 0
C8993 VDD.n2522 VSS 0.0277f
C8994 VDD.n2523 VSS 1.61839f
C8995 VDD.n2524 VSS 0
C8996 VDD.n2525 VSS 0.41152f
C8997 VDD.n2526 VSS 0.02875f
C8998 VDD.n2527 VSS 0.02875f
C8999 VDD.n2528 VSS 0.41197f
C9000 VDD.n2529 VSS 0.03187f
C9001 VDD.n2530 VSS 0.03158f
C9002 VDD.n2531 VSS 1.61839f
C9003 VDD.n2532 VSS 0.03158f
C9004 VDD.n2533 VSS 0
C9005 VDD.n2534 VSS 0.0277f
C9006 VDD.n2535 VSS 1.61839f
C9007 VDD.n2536 VSS 0
C9008 VDD.n2537 VSS 0.41167f
C9009 VDD.n2538 VSS 0.02875f
C9010 VDD.n2539 VSS 0.02875f
C9011 VDD.n2540 VSS 0.41435f
C9012 VDD.n2541 VSS 0.41405f
C9013 VDD.n2542 VSS 0.03158f
C9014 VDD.n2543 VSS 0
C9015 VDD.n2544 VSS 0.03187f
C9016 VDD.n2545 VSS 0.02875f
C9017 VDD.n2546 VSS 1.97674f
C9018 VDD.n2547 VSS 0.03158f
C9019 VDD.n2548 VSS 0
C9020 VDD.n2549 VSS 0
C9021 VDD.n2550 VSS 0.02875f
C9022 VDD.n2551 VSS 0.03158f
C9023 VDD.n2552 VSS 0.03187f
C9024 VDD.n2553 VSS 1.61839f
C9025 VDD.n2554 VSS 0
C9026 VDD.n2555 VSS 0.03187f
C9027 VDD.n2556 VSS 0.0277f
C9028 VDD.n2557 VSS 0.0277f
C9029 VDD.n2558 VSS 0
C9030 VDD.n2559 VSS 0.03158f
C9031 VDD.n2560 VSS 1.97734f
C9032 VDD.n2561 VSS 0.02875f
C9033 VDD.n2562 VSS 0.41167f
C9034 VDD.n2563 VSS 0.41197f
C9035 VDD.n2564 VSS 0.02875f
C9036 VDD.n2565 VSS 0.0277f
C9037 VDD.n2566 VSS 0.03187f
C9038 VDD.n2567 VSS 0
C9039 VDD.n2568 VSS 1.61839f
C9040 VDD.n2569 VSS 0.03187f
C9041 VDD.n2570 VSS 1.36594f
C9042 VDD.n2571 VSS 0
C9043 VDD.n2572 VSS 0.03187f
C9044 VDD.n2573 VSS 0.0277f
C9045 VDD.n2574 VSS 0.0277f
C9046 VDD.n2575 VSS 0
C9047 VDD.n2576 VSS 0.03158f
C9048 VDD.n2577 VSS 1.61839f
C9049 VDD.n2578 VSS 0.02875f
C9050 VDD.n2579 VSS 0.41405f
C9051 VDD.n2580 VSS 0.41435f
C9052 VDD.n2581 VSS 0.02875f
C9053 VDD.n2582 VSS 0.0277f
C9054 VDD.n2583 VSS 0.03187f
C9055 VDD.n2584 VSS 0
C9056 VDD.n2585 VSS 1.36594f
C9057 VDD.n2586 VSS 0.03187f
C9058 VDD.n2587 VSS 1.7511f
C9059 VDD.n2588 VSS 0
C9060 VDD.n2589 VSS 0.03187f
C9061 VDD.n2590 VSS 0.0277f
C9062 VDD.n2591 VSS 0.0277f
C9063 VDD.n2592 VSS 0
C9064 VDD.n2593 VSS 0.03158f
C9065 VDD.n2594 VSS 1.36594f
C9066 VDD.n2595 VSS 0.02875f
C9067 VDD.n2596 VSS 0.41167f
C9068 VDD.n2597 VSS 0.41197f
C9069 VDD.n2598 VSS 0.02875f
C9070 VDD.n2599 VSS 0.0277f
C9071 VDD.n2600 VSS 0.03187f
C9072 VDD.n2601 VSS 0
C9073 VDD.n2602 VSS 1.7511f
C9074 VDD.n2603 VSS 0.03187f
C9075 VDD.n2604 VSS 1.45143f
C9076 VDD.n2605 VSS 0
C9077 VDD.n2606 VSS 0.03187f
C9078 VDD.n2607 VSS 0.0277f
C9079 VDD.n2608 VSS 0.0277f
C9080 VDD.n2609 VSS 0
C9081 VDD.n2610 VSS 0.03158f
C9082 VDD.n2611 VSS 1.7511f
C9083 VDD.n2612 VSS 0.02875f
C9084 VDD.n2613 VSS 0.41152f
C9085 VDD.n2614 VSS 0.41182f
C9086 VDD.n2615 VSS 0.02875f
C9087 VDD.n2616 VSS 0.0277f
C9088 VDD.n2617 VSS 0.03187f
C9089 VDD.n2618 VSS 0
C9090 VDD.n2619 VSS 1.45143f
C9091 VDD.n2620 VSS 0
C9092 VDD.n2621 VSS 0.03158f
C9093 VDD.n2622 VSS 1.45143f
C9094 VDD.n2623 VSS 0.02875f
C9095 VDD.n2624 VSS 0.02875f
C9096 VDD.n2625 VSS 0.0277f
C9097 VDD.n2626 VSS 0.03187f
C9098 VDD.n2627 VSS 0
C9099 VDD.n2628 VSS 1.40123f
C9100 VDD.n2629 VSS 0.03158f
C9101 VDD.n2630 VSS 1.40123f
C9102 VDD.n2631 VSS 0.03187f
C9103 VDD.n2632 VSS 0.02875f
C9104 VDD.n2633 VSS 0.03158f
C9105 VDD.n2634 VSS 0.03187f
C9106 VDD.n2635 VSS 0.41182f
C9107 VDD.n2636 VSS 0.01892f
C9108 VDD.n2637 VSS 0.01892f
C9109 VDD.n2638 VSS 0.00637f
C9110 VDD.n2639 VSS 0.01021f
C9111 VDD.n2640 VSS 0.05176f
C9112 VDD.t154 VSS 0.07897f
C9113 VDD.t248 VSS 0.07897f
C9114 VDD.n2641 VSS 0.05174f
C9115 VDD.n2642 VSS 0.02603f
C9116 VDD.n2643 VSS 0.01249f
C9117 VDD.n2644 VSS 0.02432f
C9118 VDD.n2645 VSS 0.00649f
C9119 VDD.n2646 VSS 0.01598f
C9120 VDD.n2647 VSS 0.0114f
C9121 VDD.n2648 VSS 0.00859f
C9122 VDD.t529 VSS 0.07801f
C9123 VDD.t637 VSS 0.07801f
C9124 VDD.n2649 VSS 0.00961f
C9125 VDD.n2650 VSS 0.00966f
C9126 VDD.t236 VSS 0.07801f
C9127 VDD.t113 VSS 0.07801f
C9128 VDD.n2651 VSS 0.00382f
C9129 VDD.n2652 VSS -0.00164f
C9130 VDD.n2653 VSS 0.05436f
C9131 VDD.t1 VSS 0.0048f
C9132 VDD.n2654 VSS 0.01425f
C9133 VDD.t653 VSS 11.0008f
C9134 VDD.n2655 VSS 7.58032f
C9135 VDD.t483 VSS 1.28075f
C9136 VDD.t382 VSS 1.3735f
C9137 VDD.n2656 VSS 0.23442f
C9138 VDD.n2657 VSS 0.13998f
C9139 VDD.t381 VSS 3.24612f
C9140 VDD.n2658 VSS 2.20122f
C9141 VDD.t482 VSS 3.09016f
C9142 VDD.n2659 VSS 1.72277f
C9143 VDD.n2660 VSS 6.34346f
C9144 VDD.t623 VSS 5.8134f
C9145 VDD.t622 VSS 8.47877f
C9146 VDD.t46 VSS 9.3915f
C9147 VDD.n2661 VSS 7.7279f
C9148 VDD.n2662 VSS 0.17818f
C9149 VDD.n2663 VSS 0.18088f
C9150 VDD.t477 VSS 6.99484f
C9151 VDD.t139 VSS 8.47877f
C9152 VDD.t472 VSS 11.0008f
C9153 VDD.n2664 VSS 7.73004f
C9154 VDD.t216 VSS 9.3915f
C9155 VDD.n2665 VSS 7.72792f
C9156 VDD.n2666 VSS 0.14618f
C9157 VDD.n2667 VSS 4.97265f
C9158 VDD.n2668 VSS 0.19572f
C9159 VDD.n2669 VSS 0.15651f
C9160 VDD.t39 VSS 0.0048f
C9161 VDD.n2670 VSS 0.01425f
C9162 VDD.n2671 VSS 0.00804f
C9163 VDD.n2672 VSS 0.05428f
C9164 VDD.t38 VSS 0.07801f
C9165 VDD.t0 VSS 0.07801f
C9166 VDD.n2673 VSS 0.05428f
C9167 VDD.n2674 VSS 0.05436f
C9168 VDD.n2675 VSS -0.00166f
C9169 VDD.n2676 VSS 0.02645f
C9170 VDD.n2677 VSS 0.00667f
C9171 VDD.n2678 VSS 0.0277f
C9172 VDD.n2679 VSS 0.41152f
C9173 VDD.n2680 VSS 0.03158f
C9174 VDD.n2681 VSS 0
C9175 VDD.n2682 VSS 0.03187f
C9176 VDD.n2683 VSS 0.02875f
C9177 VDD.n2684 VSS 1.5329f
C9178 VDD.n2685 VSS 0.03158f
C9179 VDD.n2686 VSS 0
C9180 VDD.n2687 VSS 0
C9181 VDD.n2688 VSS 0.02875f
C9182 VDD.n2689 VSS 0.03158f
C9183 VDD.n2690 VSS 0.0277f
C9184 VDD.n2691 VSS 0.41167f
C9185 VDD.n2692 VSS 0.03158f
C9186 VDD.n2693 VSS 0
C9187 VDD.n2694 VSS 0.03187f
C9188 VDD.n2695 VSS 0.02875f
C9189 VDD.n2696 VSS 1.40123f
C9190 VDD.n2697 VSS 0.03158f
C9191 VDD.n2698 VSS 0
C9192 VDD.n2699 VSS 0
C9193 VDD.n2700 VSS 0.02875f
C9194 VDD.n2701 VSS 0.03158f
C9195 VDD.n2702 VSS 1.40123f
C9196 VDD.n2703 VSS 0.03187f
C9197 VDD.n2704 VSS 0
C9198 VDD.n2705 VSS 0.02875f
C9199 VDD.n2706 VSS 0.03158f
C9200 VDD.n2707 VSS 1.40123f
C9201 VDD.n2708 VSS 0.03187f
C9202 VDD.n2709 VSS 0
C9203 VDD.n2710 VSS 0.02875f
C9204 VDD.n2711 VSS 0.03158f
C9205 VDD.n2712 VSS 0.0277f
C9206 VDD.n2713 VSS 0.43684f
C9207 VDD.n2714 VSS 0.03158f
C9208 VDD.n2715 VSS 0
C9209 VDD.n2716 VSS 0.03187f
C9210 VDD.n2717 VSS 0.02875f
C9211 VDD.n2718 VSS 0.0277f
C9212 VDD.n2719 VSS 0
C9213 VDD.n2720 VSS 0.0277f
C9214 VDD.n2721 VSS 0.03187f
C9215 VDD.n2722 VSS 0.03158f
C9216 VDD.n2723 VSS 1.7511f
C9217 VDD.n2724 VSS 0.03187f
C9218 VDD.n2725 VSS 0.02875f
C9219 VDD.n2726 VSS 0.03158f
C9220 VDD.n2727 VSS 0.03187f
C9221 VDD.n2728 VSS 0.43714f
C9222 VDD.n2729 VSS 0
C9223 VDD.n2730 VSS 0.02875f
C9224 VDD.n2731 VSS 0
C9225 VDD.n2732 VSS 0.0277f
C9226 VDD.n2733 VSS 0.03187f
C9227 VDD.n2734 VSS 0.03158f
C9228 VDD.n2735 VSS 1.45143f
C9229 VDD.n2736 VSS 0.0277f
C9230 VDD.n2737 VSS 0
C9231 VDD.n2738 VSS 0.03158f
C9232 VDD.n2739 VSS 0.03187f
C9233 VDD.n2740 VSS 0
C9234 VDD.n2741 VSS 0.41405f
C9235 VDD.n2742 VSS 0.02875f
C9236 VDD.n2743 VSS 0.02875f
C9237 VDD.n2744 VSS 0.41197f
C9238 VDD.n2745 VSS 0.41167f
C9239 VDD.n2746 VSS 0
C9240 VDD.n2747 VSS 0.03187f
C9241 VDD.n2748 VSS 0.0277f
C9242 VDD.n2749 VSS 0.0277f
C9243 VDD.n2750 VSS 0
C9244 VDD.n2751 VSS 0.03158f
C9245 VDD.n2752 VSS 1.45143f
C9246 VDD.n2753 VSS 0.03158f
C9247 VDD.n2754 VSS 0
C9248 VDD.n2755 VSS 0.0277f
C9249 VDD.n2756 VSS 1.45143f
C9250 VDD.n2757 VSS 0
C9251 VDD.n2758 VSS 0.41167f
C9252 VDD.n2759 VSS 0.02875f
C9253 VDD.n2760 VSS 0.02875f
C9254 VDD.n2761 VSS 0.43714f
C9255 VDD.n2762 VSS 0.43684f
C9256 VDD.n2763 VSS 0.03158f
C9257 VDD.n2764 VSS 0
C9258 VDD.n2765 VSS 0.03187f
C9259 VDD.n2766 VSS 0.02875f
C9260 VDD.n2767 VSS 0.0277f
C9261 VDD.n2768 VSS 0.43684f
C9262 VDD.n2769 VSS 0.03158f
C9263 VDD.n2770 VSS 0
C9264 VDD.n2771 VSS 0.03187f
C9265 VDD.n2772 VSS 0.02875f
C9266 VDD.n2773 VSS 1.36594f
C9267 VDD.n2774 VSS 0.03158f
C9268 VDD.n2775 VSS 0
C9269 VDD.n2776 VSS 0.41197f
C9270 VDD.n2777 VSS 0.02875f
C9271 VDD.n2778 VSS 0.0277f
C9272 VDD.n2779 VSS 0.03187f
C9273 VDD.n2780 VSS 0
C9274 VDD.n2781 VSS 1.7511f
C9275 VDD.n2782 VSS 1.7511f
C9276 VDD.n2783 VSS 0.03158f
C9277 VDD.n2784 VSS 0
C9278 VDD.n2785 VSS 0.41197f
C9279 VDD.n2786 VSS 0.02875f
C9280 VDD.n2787 VSS 0.0277f
C9281 VDD.n2788 VSS 0.03187f
C9282 VDD.n2789 VSS 0
C9283 VDD.n2790 VSS 1.45143f
C9284 VDD.n2791 VSS 1.45143f
C9285 VDD.n2792 VSS 0.03158f
C9286 VDD.n2793 VSS 0
C9287 VDD.n2794 VSS 0.41197f
C9288 VDD.n2795 VSS 0.02875f
C9289 VDD.n2796 VSS 0.0277f
C9290 VDD.n2797 VSS 0.03187f
C9291 VDD.n2798 VSS 0
C9292 VDD.n2799 VSS 1.40123f
C9293 VDD.n2800 VSS 0.03187f
C9294 VDD.n2801 VSS 0.41197f
C9295 VDD.n2802 VSS 0.02875f
C9296 VDD.n2803 VSS 0.03158f
C9297 VDD.n2804 VSS 0.03187f
C9298 VDD.n2805 VSS 0.41197f
C9299 VDD.n2806 VSS 0
C9300 VDD.n2807 VSS 0.02875f
C9301 VDD.n2808 VSS 0.43684f
C9302 VDD.n2809 VSS 0
C9303 VDD.n2810 VSS 0.03187f
C9304 VDD.n2811 VSS 0.0277f
C9305 VDD.n2812 VSS 0.0277f
C9306 VDD.n2813 VSS 0
C9307 VDD.n2814 VSS 0.03158f
C9308 VDD.n2815 VSS 1.5329f
C9309 VDD.n2816 VSS 1.5329f
C9310 VDD.n2817 VSS 0
C9311 VDD.n2818 VSS 0.03187f
C9312 VDD.n2819 VSS 0.0277f
C9313 VDD.n2820 VSS 0.0277f
C9314 VDD.n2821 VSS 0
C9315 VDD.n2822 VSS 0.03158f
C9316 VDD.n2823 VSS 1.40123f
C9317 VDD.n2824 VSS 0.02875f
C9318 VDD.n2825 VSS 0.43684f
C9319 VDD.n2826 VSS 0.43714f
C9320 VDD.n2827 VSS 0
C9321 VDD.n2828 VSS 0.03187f
C9322 VDD.n2829 VSS 0.0277f
C9323 VDD.n2830 VSS 0.0277f
C9324 VDD.n2831 VSS 0
C9325 VDD.n2832 VSS 0.03158f
C9326 VDD.n2833 VSS 1.40123f
C9327 VDD.n2834 VSS 0.02875f
C9328 VDD.n2835 VSS 0.41167f
C9329 VDD.n2836 VSS 0.41197f
C9330 VDD.n2837 VSS 0.03158f
C9331 VDD.n2838 VSS 1.5329f
C9332 VDD.n2839 VSS 1.5329f
C9333 VDD.n2840 VSS 0
C9334 VDD.n2841 VSS 0.03187f
C9335 VDD.n2842 VSS 0.0277f
C9336 VDD.n2843 VSS 0.0277f
C9337 VDD.n2844 VSS 0
C9338 VDD.n2845 VSS 0.03158f
C9339 VDD.n2846 VSS 1.40123f
C9340 VDD.n2847 VSS 0.02875f
C9341 VDD.n2848 VSS 0.41405f
C9342 VDD.n2849 VSS 0.41435f
C9343 VDD.n2850 VSS 0.02875f
C9344 VDD.n2851 VSS 0.0277f
C9345 VDD.n2852 VSS 0.03187f
C9346 VDD.n2853 VSS 0
C9347 VDD.n2854 VSS 1.5329f
C9348 VDD.n2855 VSS 0.03187f
C9349 VDD.n2856 VSS 0.41435f
C9350 VDD.n2857 VSS 0
C9351 VDD.n2858 VSS 0.03187f
C9352 VDD.n2859 VSS 0.0277f
C9353 VDD.n2860 VSS 0.0277f
C9354 VDD.n2861 VSS 0
C9355 VDD.n2862 VSS 0.03158f
C9356 VDD.n2863 VSS 1.5329f
C9357 VDD.n2864 VSS 0.02875f
C9358 VDD.n2865 VSS 0.41167f
C9359 VDD.n2866 VSS 0.41197f
C9360 VDD.n2867 VSS 0.02875f
C9361 VDD.n2868 VSS 0.0277f
C9362 VDD.n2869 VSS 0.03187f
C9363 VDD.n2870 VSS 0
C9364 VDD.n2871 VSS 0.90437f
C9365 VDD.n2872 VSS 0.90422f
C9366 VDD.n2873 VSS 0.01892f
C9367 VDD.n2874 VSS 0.01892f
C9368 VDD.n2875 VSS 0.00637f
C9369 VDD.n2876 VSS 0.01021f
C9370 VDD.n2877 VSS 0.00402f
C9371 VDD.n2878 VSS 0.00987f
C9372 VDD.t476 VSS 0.0079f
C9373 VDD.n2879 VSS 0.00767f
C9374 VDD.n2880 VSS 0.01202f
C9375 VDD.n2881 VSS 0.05436f
C9376 VDD.t379 VSS 0.07801f
C9377 VDD.t423 VSS 0.07995f
C9378 VDD.n2882 VSS 0.00624f
C9379 VDD.t380 VSS 0.0048f
C9380 VDD.n2883 VSS 0.01532f
C9381 VDD.t424 VSS 0.0048f
C9382 VDD.n2884 VSS 0.013f
C9383 VDD.n2885 VSS 0.01001f
C9384 VDD.n2886 VSS 0.0876f
C9385 VDD.t86 VSS 0.08758f
C9386 VDD.n2887 VSS 0.07796f
C9387 VDD.t262 VSS 0.07801f
C9388 VDD.t662 VSS 0.07801f
C9389 VDD.t663 VSS 0.0048f
C9390 VDD.n2888 VSS 0.013f
C9391 VDD.n2889 VSS 0.01006f
C9392 VDD.n2890 VSS 0.01598f
C9393 VDD.n2891 VSS 0.00649f
C9394 VDD.n2892 VSS 0.01892f
C9395 VDD.n2893 VSS 0.36625f
C9396 VDD.n2894 VSS 0.02432f
C9397 VDD.n2895 VSS 0.01241f
C9398 VDD.n2896 VSS 0.00748f
C9399 VDD.n2897 VSS 0.06551f
C9400 VDD.t475 VSS 0.08053f
C9401 VDD.n2898 VSS 0.06674f
C9402 VDD.n2899 VSS 0.00127f
C9403 VDD.n2900 VSS 0.00187f
C9404 VDD.n2901 VSS 0.00334f
C9405 VDD.n2902 VSS 0.00591f
C9406 VDD.n2903 VSS 0.0128f
C9407 VDD.n2904 VSS 0.00667f
C9408 VDD.n2905 VSS 0.2806f
C9409 VDD.n2906 VSS 0.01892f
C9410 VDD.n2907 VSS 0.00637f
C9411 VDD.n2908 VSS 0.01598f
C9412 VDD.n2909 VSS 0.00649f
C9413 VDD.n2910 VSS 0.02432f
C9414 VDD.n2911 VSS 0.2806f
C9415 VDD.n2912 VSS 0.01021f
C9416 VDD.n2913 VSS 0.0128f
C9417 VDD.n2914 VSS 0.02484f
C9418 VDD.n2915 VSS 0.00407f
C9419 VDD.n2916 VSS -0.00164f
C9420 VDD.n2917 VSS 0.05436f
C9421 VDD.n2918 VSS 0.05428f
C9422 VDD.n2919 VSS 0.00366f
C9423 VDD.t530 VSS 0.0048f
C9424 VDD.n2920 VSS 0.02521f
C9425 VDD.n2921 VSS 0.03057f
C9426 VDD.n2922 VSS 0.05174f
C9427 VDD.t249 VSS 0.07897f
C9428 VDD.t152 VSS 0.07897f
C9429 VDD.n2923 VSS 0.05176f
C9430 VDD.n2924 VSS 0.01819f
C9431 VDD.n2925 VSS 0.0167f
C9432 VDD.n2926 VSS 0.0128f
C9433 VDD.n2927 VSS 0.00667f
C9434 VDD.n2928 VSS 0.90511f
C9435 VDD.n2929 VSS 0.90526f
C9436 VDD.n2930 VSS 0
C9437 VDD.n2931 VSS 0.02875f
C9438 VDD.n2932 VSS 0.41167f
C9439 VDD.n2933 VSS 0
C9440 VDD.n2934 VSS 0.03187f
C9441 VDD.n2935 VSS 0.0277f
C9442 VDD.n2936 VSS 0.0277f
C9443 VDD.n2937 VSS 0
C9444 VDD.n2938 VSS 0.03158f
C9445 VDD.n2939 VSS 1.5329f
C9446 VDD.n2940 VSS 0.03158f
C9447 VDD.n2941 VSS 0
C9448 VDD.n2942 VSS 0.0277f
C9449 VDD.n2943 VSS 1.5329f
C9450 VDD.n2944 VSS 0
C9451 VDD.n2945 VSS 0.41167f
C9452 VDD.n2946 VSS 0.02875f
C9453 VDD.n2947 VSS 0.02875f
C9454 VDD.n2948 VSS 0.41182f
C9455 VDD.n2949 VSS 0.41152f
C9456 VDD.n2950 VSS 0
C9457 VDD.n2951 VSS 0.03187f
C9458 VDD.n2952 VSS 0.0277f
C9459 VDD.n2953 VSS 0.0277f
C9460 VDD.n2954 VSS 0
C9461 VDD.n2955 VSS 0.03158f
C9462 VDD.n2956 VSS 1.40123f
C9463 VDD.n2957 VSS 0.03158f
C9464 VDD.n2958 VSS 0
C9465 VDD.n2959 VSS 0.0277f
C9466 VDD.n2960 VSS 1.40123f
C9467 VDD.n2961 VSS 0
C9468 VDD.n2962 VSS 0.41152f
C9469 VDD.n2963 VSS 0.02875f
C9470 VDD.n2964 VSS 0.02875f
C9471 VDD.n2965 VSS 0.41197f
C9472 VDD.n2966 VSS 0.41167f
C9473 VDD.n2967 VSS 0
C9474 VDD.n2968 VSS 0.03187f
C9475 VDD.n2969 VSS 0.0277f
C9476 VDD.n2970 VSS 0.0277f
C9477 VDD.n2971 VSS 0
C9478 VDD.n2972 VSS 0.03158f
C9479 VDD.n2973 VSS 1.45143f
C9480 VDD.n2974 VSS 0.03158f
C9481 VDD.n2975 VSS 0
C9482 VDD.n2976 VSS 0.0277f
C9483 VDD.n2977 VSS 1.45143f
C9484 VDD.n2978 VSS 0
C9485 VDD.n2979 VSS 0.41167f
C9486 VDD.n2980 VSS 0.02875f
C9487 VDD.n2981 VSS 0.02875f
C9488 VDD.n2982 VSS 0.41435f
C9489 VDD.n2983 VSS 0.41405f
C9490 VDD.n2984 VSS 0
C9491 VDD.n2985 VSS 0.03187f
C9492 VDD.n2986 VSS 0.0277f
C9493 VDD.n2987 VSS 0.0277f
C9494 VDD.n2988 VSS 0
C9495 VDD.n2989 VSS 0.03158f
C9496 VDD.n2990 VSS 1.7511f
C9497 VDD.n2991 VSS 0.03158f
C9498 VDD.n2992 VSS 0
C9499 VDD.n2993 VSS 0.0277f
C9500 VDD.n2994 VSS 1.7511f
C9501 VDD.n2995 VSS 0
C9502 VDD.n2996 VSS 0.41405f
C9503 VDD.n2997 VSS 0.02875f
C9504 VDD.n2998 VSS 0.02875f
C9505 VDD.n2999 VSS 0.41197f
C9506 VDD.n3000 VSS 0.41167f
C9507 VDD.n3001 VSS 0
C9508 VDD.n3002 VSS 0.03187f
C9509 VDD.n3003 VSS 0.0277f
C9510 VDD.n3004 VSS 0.0277f
C9511 VDD.n3005 VSS 0
C9512 VDD.n3006 VSS 0.03158f
C9513 VDD.n3007 VSS 1.36594f
C9514 VDD.n3008 VSS 0.03158f
C9515 VDD.n3009 VSS 0
C9516 VDD.n3010 VSS 0.0277f
C9517 VDD.n3011 VSS 1.36594f
C9518 VDD.n3012 VSS 0
C9519 VDD.n3013 VSS 0.41167f
C9520 VDD.n3014 VSS 0.02875f
C9521 VDD.n3015 VSS 0.02875f
C9522 VDD.n3016 VSS 0.43714f
C9523 VDD.n3017 VSS 0.43684f
C9524 VDD.n3018 VSS 0
C9525 VDD.n3019 VSS 0.03187f
C9526 VDD.n3020 VSS 0.0277f
C9527 VDD.n3021 VSS 0.0277f
C9528 VDD.n3022 VSS 0
C9529 VDD.n3023 VSS 0.03158f
C9530 VDD.n3024 VSS 1.61839f
C9531 VDD.n3025 VSS 0.03158f
C9532 VDD.n3026 VSS 0
C9533 VDD.n3027 VSS 0.0277f
C9534 VDD.n3028 VSS 1.61839f
C9535 VDD.n3029 VSS 0
C9536 VDD.n3030 VSS 0.43684f
C9537 VDD.n3031 VSS 0.02875f
C9538 VDD.n3032 VSS 0.02875f
C9539 VDD.n3033 VSS 0.41197f
C9540 VDD.n3034 VSS 0.41167f
C9541 VDD.n3035 VSS 0.03158f
C9542 VDD.n3036 VSS 0
C9543 VDD.n3037 VSS 0.02875f
C9544 VDD.n3038 VSS 0.03158f
C9545 VDD.n3039 VSS 0.03187f
C9546 VDD.n3040 VSS 0.41197f
C9547 VDD.n3041 VSS 0.02875f
C9548 VDD.n3042 VSS 0.03158f
C9549 VDD.n3043 VSS 0.03187f
C9550 VDD.n3044 VSS 0.41197f
C9551 VDD.n3045 VSS 0.02875f
C9552 VDD.n3046 VSS 0.03158f
C9553 VDD.n3047 VSS 0.03187f
C9554 VDD.n3048 VSS 0.41197f
C9555 VDD.n3049 VSS 0.02875f
C9556 VDD.n3050 VSS 0.03158f
C9557 VDD.n3051 VSS 0.03187f
C9558 VDD.n3052 VSS 0.41197f
C9559 VDD.n3053 VSS 0.02875f
C9560 VDD.n3054 VSS 0.03158f
C9561 VDD.n3055 VSS 0.03187f
C9562 VDD.n3056 VSS 0.41197f
C9563 VDD.n3057 VSS 0.02875f
C9564 VDD.n3058 VSS 0.03158f
C9565 VDD.n3059 VSS 0.03187f
C9566 VDD.n3060 VSS 0.41197f
C9567 VDD.n3061 VSS 0.02875f
C9568 VDD.n3062 VSS 0.03158f
C9569 VDD.n3063 VSS 0.03187f
C9570 VDD.n3064 VSS 0.41197f
C9571 VDD.n3065 VSS 0.01892f
C9572 VDD.n3066 VSS 0.00637f
C9573 VDD.n3067 VSS 0.01021f
C9574 VDD.n3068 VSS 0.00364f
C9575 VDD.n3069 VSS 0.00655f
C9576 VDD.t580 VSS 0.09527f
C9577 VDD.n3070 VSS 0.05436f
C9578 VDD.n3071 VSS 0.01221f
C9579 VDD.t719 VSS 0.0048f
C9580 VDD.n3072 VSS 0.013f
C9581 VDD.t444 VSS 0.0048f
C9582 VDD.n3073 VSS 0.01532f
C9583 VDD.t579 VSS 0.0048f
C9584 VDD.n3074 VSS 0.01532f
C9585 VDD.n3075 VSS 0.00975f
C9586 VDD.t721 VSS 0.0048f
C9587 VDD.n3076 VSS 0.013f
C9588 VDD.n3077 VSS 0.05436f
C9589 VDD.t400 VSS 0.0048f
C9590 VDD.n3078 VSS 0.01532f
C9591 VDD.n3079 VSS 0.00975f
C9592 VDD.n3080 VSS 0.05436f
C9593 VDD.t532 VSS 0.0048f
C9594 VDD.n3081 VSS 0.00732f
C9595 VDD.n3082 VSS 0.01017f
C9596 VDD.t418 VSS 0.0048f
C9597 VDD.n3083 VSS 0.01532f
C9598 VDD.t534 VSS 0.0048f
C9599 VDD.n3084 VSS 0.013f
C9600 VDD.t378 VSS 0.0048f
C9601 VDD.n3085 VSS 0.013f
C9602 VDD.t305 VSS 0.07801f
C9603 VDD.n3086 VSS 0.01224f
C9604 VDD.t7 VSS 0.0048f
C9605 VDD.n3087 VSS 0.013f
C9606 VDD.n3088 VSS 0.05436f
C9607 VDD.t391 VSS 0.0048f
C9608 VDD.n3089 VSS 0.01532f
C9609 VDD.n3090 VSS 0.00975f
C9610 VDD.n3091 VSS 0.05436f
C9611 VDD.t196 VSS 0.0048f
C9612 VDD.n3092 VSS 0.01532f
C9613 VDD.t456 VSS 0.0048f
C9614 VDD.n3093 VSS 0.013f
C9615 VDD.t297 VSS 0.07801f
C9616 VDD.t455 VSS 0.07931f
C9617 VDD.n3094 VSS 0.07927f
C9618 VDD.t359 VSS 0.07801f
C9619 VDD.t492 VSS 0.07931f
C9620 VDD.n3095 VSS 0.07923f
C9621 VDD.t493 VSS 0.0048f
C9622 VDD.n3096 VSS 0.01532f
C9623 VDD.t360 VSS 0.0048f
C9624 VDD.n3097 VSS 0.013f
C9625 VDD.n3098 VSS 0.00979f
C9626 VDD.n3099 VSS 0.01221f
C9627 VDD.n3100 VSS 0.05953f
C9628 VDD.n3101 VSS 0.01311f
C9629 VDD.t458 VSS 0.0079f
C9630 VDD.n3102 VSS 0.00767f
C9631 VDD.t394 VSS 0.09527f
C9632 VDD.t299 VSS 0.07801f
C9633 VDD.t449 VSS 0.07801f
C9634 VDD.t450 VSS 0.0048f
C9635 VDD.n3103 VSS 0.00709f
C9636 VDD.n3104 VSS 0.01502f
C9637 VDD.n3105 VSS 0.00312f
C9638 VDD.n3106 VSS 0.06551f
C9639 VDD.t457 VSS 0.08094f
C9640 VDD.n3107 VSS 0.08847f
C9641 VDD.n3108 VSS 0.00273f
C9642 VDD.n3109 VSS 0.00713f
C9643 VDD.t395 VSS 0.00789f
C9644 VDD.n3110 VSS 0.01815f
C9645 VDD.n3111 VSS 0.00602f
C9646 VDD.t454 VSS 0.0048f
C9647 VDD.n3112 VSS 0.013f
C9648 VDD.n3113 VSS 0.00655f
C9649 VDD.n3114 VSS 0.06139f
C9650 VDD.t453 VSS 0.07762f
C9651 VDD.t195 VSS 0.07801f
C9652 VDD.n3115 VSS 0.05436f
C9653 VDD.n3116 VSS 0.01224f
C9654 VDD.n3117 VSS 0.00624f
C9655 VDD.t630 VSS 0.0048f
C9656 VDD.n3118 VSS 0.00745f
C9657 VDD.n3119 VSS 0.00649f
C9658 VDD.n3120 VSS 0.01021f
C9659 VDD.n3121 VSS 0.01892f
C9660 VDD.n3122 VSS 0.01598f
C9661 VDD.n3123 VSS 0.01012f
C9662 VDD.n3124 VSS 0.01372f
C9663 VDD.t629 VSS 0.07801f
C9664 VDD.t51 VSS 0.07801f
C9665 VDD.n3125 VSS 0.07796f
C9666 VDD.t31 VSS 0.0079f
C9667 VDD.n3126 VSS 0.00767f
C9668 VDD.n3127 VSS 0.00187f
C9669 VDD.n3128 VSS 0.00468f
C9670 VDD.t432 VSS 0.0048f
C9671 VDD.n3129 VSS 0.00737f
C9672 VDD.n3130 VSS 0.00279f
C9673 VDD.n3131 VSS 0.00714f
C9674 VDD.n3132 VSS 0.01598f
C9675 VDD.n3133 VSS 0.00649f
C9676 VDD.n3134 VSS 0.01892f
C9677 VDD.n3135 VSS 0.36297f
C9678 VDD.n3136 VSS 0.02432f
C9679 VDD.n3137 VSS 0.0126f
C9680 VDD.t3 VSS 0.0048f
C9681 VDD.n3138 VSS 0.013f
C9682 VDD.t84 VSS 0.08758f
C9683 VDD.t431 VSS 0.07801f
C9684 VDD.t2 VSS 0.07995f
C9685 VDD.n3139 VSS 0.0876f
C9686 VDD.n3140 VSS 0.01001f
C9687 VDD.n3141 VSS 0.00987f
C9688 VDD.n3142 VSS 0.01202f
C9689 VDD.n3143 VSS 0.00127f
C9690 VDD.n3144 VSS 0.06674f
C9691 VDD.t30 VSS 0.08053f
C9692 VDD.n3145 VSS 0.06551f
C9693 VDD.n3146 VSS 0.01393f
C9694 VDD.t52 VSS 0.0048f
C9695 VDD.n3147 VSS 0.013f
C9696 VDD.n3148 VSS 0.01004f
C9697 VDD.n3149 VSS 0.0128f
C9698 VDD.n3150 VSS 0.00667f
C9699 VDD.n3151 VSS 0.00637f
C9700 VDD.n3152 VSS 0.01892f
C9701 VDD.n3153 VSS 0.36386f
C9702 VDD.n3154 VSS 0.02432f
C9703 VDD.n3155 VSS 0.0064f
C9704 VDD.n3156 VSS 0.00496f
C9705 VDD.n3157 VSS 0.01224f
C9706 VDD.n3158 VSS 0.0122f
C9707 VDD.n3159 VSS 0.05436f
C9708 VDD.t390 VSS 0.07801f
C9709 VDD.t6 VSS 0.07931f
C9710 VDD.n3160 VSS 0.0791f
C9711 VDD.t246 VSS 0.07931f
C9712 VDD.n3161 VSS 0.07907f
C9713 VDD.t247 VSS 0.0048f
C9714 VDD.n3162 VSS 0.01532f
C9715 VDD.t306 VSS 0.0048f
C9716 VDD.n3163 VSS 0.013f
C9717 VDD.t304 VSS 0.0048f
C9718 VDD.n3164 VSS 0.01532f
C9719 VDD.n3165 VSS 0.00975f
C9720 VDD.n3166 VSS 0.00979f
C9721 VDD.n3167 VSS 0.01221f
C9722 VDD.n3168 VSS 0.05436f
C9723 VDD.n3169 VSS 0.05436f
C9724 VDD.t303 VSS 0.07801f
C9725 VDD.t377 VSS 0.07931f
C9726 VDD.n3170 VSS 0.07927f
C9727 VDD.t285 VSS 0.0048f
C9728 VDD.n3171 VSS 0.01532f
C9729 VDD.n3172 VSS 0.00975f
C9730 VDD.n3173 VSS 0.00979f
C9731 VDD.t198 VSS 0.0048f
C9732 VDD.n3174 VSS 0.013f
C9733 VDD.t273 VSS 0.0048f
C9734 VDD.n3175 VSS 0.01532f
C9735 VDD.n3176 VSS 0.07923f
C9736 VDD.t272 VSS 0.07931f
C9737 VDD.t197 VSS 0.07801f
C9738 VDD.n3177 VSS 0.05436f
C9739 VDD.n3178 VSS 0.05436f
C9740 VDD.t284 VSS 0.07801f
C9741 VDD.t533 VSS 0.07931f
C9742 VDD.n3179 VSS 0.0791f
C9743 VDD.t12 VSS 0.07801f
C9744 VDD.t675 VSS 0.07931f
C9745 VDD.n3180 VSS 0.07907f
C9746 VDD.t676 VSS 0.0048f
C9747 VDD.n3181 VSS 0.01532f
C9748 VDD.t13 VSS 0.0048f
C9749 VDD.n3182 VSS 0.013f
C9750 VDD.n3183 VSS 0.00979f
C9751 VDD.n3184 VSS 0.01221f
C9752 VDD.t514 VSS 0.08758f
C9753 VDD.n3185 VSS 0.0876f
C9754 VDD.t531 VSS 0.07995f
C9755 VDD.t417 VSS 0.07801f
C9756 VDD.n3186 VSS 0.05436f
C9757 VDD.n3187 VSS 0.01224f
C9758 VDD.n3188 VSS 0.00624f
C9759 VDD.n3189 VSS 0.01472f
C9760 VDD.t401 VSS 0.07801f
C9761 VDD.t124 VSS 0.07801f
C9762 VDD.t717 VSS 0.0079f
C9763 VDD.n3190 VSS 0.01892f
C9764 VDD.n3191 VSS 0.15758f
C9765 VDD.n3192 VSS 0.02432f
C9766 VDD.n3193 VSS 0.00649f
C9767 VDD.n3194 VSS 0.01598f
C9768 VDD.n3195 VSS 0.00776f
C9769 VDD.n3196 VSS 0.00268f
C9770 VDD.n3197 VSS 0.00767f
C9771 VDD.n3198 VSS 0.00273f
C9772 VDD.n3199 VSS 0.08847f
C9773 VDD.t716 VSS 0.08094f
C9774 VDD.n3200 VSS 0.06551f
C9775 VDD.n3201 VSS 0.00978f
C9776 VDD.t125 VSS 0.0048f
C9777 VDD.n3202 VSS 0.013f
C9778 VDD.t402 VSS 0.0048f
C9779 VDD.n3203 VSS 0.01532f
C9780 VDD.n3204 VSS 0.00624f
C9781 VDD.n3205 VSS 0.01224f
C9782 VDD.n3206 VSS 0.0122f
C9783 VDD.n3207 VSS 0.05436f
C9784 VDD.t399 VSS 0.07801f
C9785 VDD.t720 VSS 0.07931f
C9786 VDD.n3208 VSS 0.07927f
C9787 VDD.n3209 VSS 0.00979f
C9788 VDD.t116 VSS 0.0048f
C9789 VDD.n3210 VSS 0.013f
C9790 VDD.t283 VSS 0.0048f
C9791 VDD.n3211 VSS 0.01532f
C9792 VDD.n3212 VSS 0.07923f
C9793 VDD.t282 VSS 0.07931f
C9794 VDD.t115 VSS 0.07801f
C9795 VDD.n3213 VSS 0.05436f
C9796 VDD.t289 VSS 0.0048f
C9797 VDD.n3214 VSS 0.01532f
C9798 VDD.t228 VSS 0.0048f
C9799 VDD.n3215 VSS 0.013f
C9800 VDD.t205 VSS 0.0048f
C9801 VDD.n3216 VSS 0.01532f
C9802 VDD.n3217 VSS 0.05436f
C9803 VDD.n3218 VSS 0.01224f
C9804 VDD.t669 VSS 0.0048f
C9805 VDD.n3219 VSS 0.013f
C9806 VDD.t141 VSS 0.0048f
C9807 VDD.n3220 VSS 0.01532f
C9808 VDD.n3221 VSS 0.05436f
C9809 VDD.n3222 VSS 0.0114f
C9810 VDD.n3223 VSS 0.00649f
C9811 VDD.n3224 VSS 0.01892f
C9812 VDD.n3225 VSS 0.0128f
C9813 VDD.n3226 VSS 0.0277f
C9814 VDD.n3227 VSS 0.41152f
C9815 VDD.n3228 VSS 0.03158f
C9816 VDD.n3229 VSS 0
C9817 VDD.n3230 VSS 0.03187f
C9818 VDD.n3231 VSS 0.02875f
C9819 VDD.n3232 VSS 0
C9820 VDD.n3233 VSS 0
C9821 VDD.n3234 VSS 0.02875f
C9822 VDD.n3235 VSS 0.03158f
C9823 VDD.n3236 VSS 0.0277f
C9824 VDD.n3237 VSS 0.41167f
C9825 VDD.n3238 VSS 0.03158f
C9826 VDD.n3239 VSS 0
C9827 VDD.n3240 VSS 0.03187f
C9828 VDD.n3241 VSS 0.02875f
C9829 VDD.n3242 VSS 0.0277f
C9830 VDD.n3243 VSS 0.41167f
C9831 VDD.n3244 VSS 0.03158f
C9832 VDD.n3245 VSS 0
C9833 VDD.n3246 VSS 0.03187f
C9834 VDD.n3247 VSS 0.02875f
C9835 VDD.n3248 VSS 0.0277f
C9836 VDD.n3249 VSS 0.41167f
C9837 VDD.n3250 VSS 0.03158f
C9838 VDD.n3251 VSS 0
C9839 VDD.n3252 VSS 0.03187f
C9840 VDD.n3253 VSS 0.02875f
C9841 VDD.n3254 VSS 0.0277f
C9842 VDD.n3255 VSS 0.41167f
C9843 VDD.n3256 VSS 0.03158f
C9844 VDD.n3257 VSS 0
C9845 VDD.n3258 VSS 0.03187f
C9846 VDD.n3259 VSS 0.02875f
C9847 VDD.n3260 VSS 0.0277f
C9848 VDD.n3261 VSS 0.41167f
C9849 VDD.n3262 VSS 0.03158f
C9850 VDD.n3263 VSS 0
C9851 VDD.n3264 VSS 0.03187f
C9852 VDD.n3265 VSS 0.02875f
C9853 VDD.n3266 VSS 0.0277f
C9854 VDD.n3267 VSS 0
C9855 VDD.n3268 VSS 0.0277f
C9856 VDD.n3269 VSS 0.03187f
C9857 VDD.n3270 VSS 0.03158f
C9858 VDD.n3271 VSS 1.98389f
C9859 VDD.n3272 VSS 0.41182f
C9860 VDD.n3273 VSS 0.03187f
C9861 VDD.n3274 VSS 0.02875f
C9862 VDD.n3275 VSS 0.03158f
C9863 VDD.n3276 VSS 0.03187f
C9864 VDD.n3277 VSS 0.41197f
C9865 VDD.n3278 VSS 1.36594f
C9866 VDD.n3279 VSS 0
C9867 VDD.n3280 VSS 0.02875f
C9868 VDD.n3281 VSS 0
C9869 VDD.n3282 VSS 0.0277f
C9870 VDD.n3283 VSS 0.03187f
C9871 VDD.n3284 VSS 0.0277f
C9872 VDD.n3285 VSS 0.41167f
C9873 VDD.n3286 VSS 0.03158f
C9874 VDD.n3287 VSS 0
C9875 VDD.n3288 VSS 0.03187f
C9876 VDD.n3289 VSS 0
C9877 VDD.n3290 VSS 0.03158f
C9878 VDD.n3291 VSS 1.98151f
C9879 VDD.n3292 VSS 0.02875f
C9880 VDD.n3293 VSS 0.02875f
C9881 VDD.n3294 VSS 0.0277f
C9882 VDD.n3295 VSS 0.03187f
C9883 VDD.n3296 VSS 0
C9884 VDD.n3297 VSS 1.61839f
C9885 VDD.n3298 VSS 0.03158f
C9886 VDD.n3299 VSS 1.61839f
C9887 VDD.n3300 VSS 0.03187f
C9888 VDD.n3301 VSS 0.02875f
C9889 VDD.n3302 VSS 0.03158f
C9890 VDD.n3303 VSS 0.03187f
C9891 VDD.n3304 VSS 0.41182f
C9892 VDD.n3305 VSS 0.02875f
C9893 VDD.n3306 VSS 0.03158f
C9894 VDD.n3307 VSS 0.03187f
C9895 VDD.n3308 VSS 0.41182f
C9896 VDD.n3309 VSS 0.02875f
C9897 VDD.n3310 VSS 0.03158f
C9898 VDD.n3311 VSS 0.03187f
C9899 VDD.n3312 VSS 0.41182f
C9900 VDD.n3313 VSS 0.02875f
C9901 VDD.n3314 VSS 0.03158f
C9902 VDD.n3315 VSS 0.03187f
C9903 VDD.n3316 VSS 0
C9904 VDD.n3317 VSS 0.02875f
C9905 VDD.n3318 VSS 0.03158f
C9906 VDD.n3319 VSS 0.0277f
C9907 VDD.n3320 VSS 0.41152f
C9908 VDD.n3321 VSS 0.03158f
C9909 VDD.n3322 VSS 0
C9910 VDD.n3323 VSS 0.03187f
C9911 VDD.n3324 VSS 0.02875f
C9912 VDD.n3325 VSS 0.0277f
C9913 VDD.n3326 VSS 0.41152f
C9914 VDD.n3327 VSS 0.03158f
C9915 VDD.n3328 VSS 0
C9916 VDD.n3329 VSS 0.03187f
C9917 VDD.n3330 VSS 0.02875f
C9918 VDD.n3331 VSS 0.0277f
C9919 VDD.n3332 VSS 0.41152f
C9920 VDD.n3333 VSS 0.03158f
C9921 VDD.n3334 VSS 0
C9922 VDD.n3335 VSS 0.03187f
C9923 VDD.n3336 VSS 0.02875f
C9924 VDD.n3337 VSS 1.36594f
C9925 VDD.n3338 VSS 0.03158f
C9926 VDD.n3339 VSS 0
C9927 VDD.n3340 VSS 0.41197f
C9928 VDD.n3341 VSS 0.02875f
C9929 VDD.n3342 VSS 0.0277f
C9930 VDD.n3343 VSS 0.03187f
C9931 VDD.n3344 VSS 0
C9932 VDD.n3345 VSS 1.7511f
C9933 VDD.n3346 VSS 1.7511f
C9934 VDD.n3347 VSS 0.03158f
C9935 VDD.n3348 VSS 0
C9936 VDD.n3349 VSS 0.41197f
C9937 VDD.n3350 VSS 0.02875f
C9938 VDD.n3351 VSS 0.0277f
C9939 VDD.n3352 VSS 0.03187f
C9940 VDD.n3353 VSS 0
C9941 VDD.n3354 VSS 1.45143f
C9942 VDD.n3355 VSS 1.45143f
C9943 VDD.n3356 VSS 0.03158f
C9944 VDD.n3357 VSS 0
C9945 VDD.n3358 VSS 0.41197f
C9946 VDD.n3359 VSS 0.02875f
C9947 VDD.n3360 VSS 0.0277f
C9948 VDD.n3361 VSS 0.03187f
C9949 VDD.n3362 VSS 0
C9950 VDD.n3363 VSS 1.40123f
C9951 VDD.n3364 VSS 0.03187f
C9952 VDD.n3365 VSS 0.41197f
C9953 VDD.n3366 VSS 0.03158f
C9954 VDD.n3367 VSS 1.5329f
C9955 VDD.n3368 VSS 1.5329f
C9956 VDD.n3369 VSS 0
C9957 VDD.n3370 VSS 0.03187f
C9958 VDD.n3371 VSS 0.0277f
C9959 VDD.n3372 VSS 0.0277f
C9960 VDD.n3373 VSS 0
C9961 VDD.n3374 VSS 0.03158f
C9962 VDD.n3375 VSS 1.40123f
C9963 VDD.n3376 VSS 0.02875f
C9964 VDD.n3377 VSS 0.41152f
C9965 VDD.n3378 VSS 0.41182f
C9966 VDD.n3379 VSS 0.02875f
C9967 VDD.n3380 VSS 0.03158f
C9968 VDD.n3381 VSS 0.03187f
C9969 VDD.n3382 VSS 0.41182f
C9970 VDD.n3383 VSS 0.01892f
C9971 VDD.n3384 VSS 0.00637f
C9972 VDD.n3385 VSS 0.01021f
C9973 VDD.t11 VSS 0.0048f
C9974 VDD.n3386 VSS 0.00745f
C9975 VDD.n3387 VSS 0.01024f
C9976 VDD.n3388 VSS 0.01892f
C9977 VDD.n3389 VSS 0.36535f
C9978 VDD.n3390 VSS 0.02432f
C9979 VDD.n3391 VSS 0.00649f
C9980 VDD.n3392 VSS 0.01598f
C9981 VDD.n3393 VSS 0.00636f
C9982 VDD.n3394 VSS 0.00378f
C9983 VDD.n3395 VSS 0.00468f
C9984 VDD.t699 VSS 0.0079f
C9985 VDD.n3396 VSS 0.01202f
C9986 VDD.n3397 VSS 0.05436f
C9987 VDD.t144 VSS 0.07801f
C9988 VDD.t694 VSS 0.07995f
C9989 VDD.n3398 VSS 0.00987f
C9990 VDD.n3399 VSS 0.00624f
C9991 VDD.t145 VSS 0.0048f
C9992 VDD.n3400 VSS 0.01532f
C9993 VDD.t695 VSS 0.0048f
C9994 VDD.n3401 VSS 0.013f
C9995 VDD.n3402 VSS 0.01001f
C9996 VDD.n3403 VSS 0.0876f
C9997 VDD.t515 VSS 0.08758f
C9998 VDD.n3404 VSS 0.07796f
C9999 VDD.t578 VSS 0.07801f
C10000 VDD.t10 VSS 0.07801f
C10001 VDD.n3405 VSS 0.06551f
C10002 VDD.t698 VSS 0.08053f
C10003 VDD.n3406 VSS 0.06674f
C10004 VDD.n3407 VSS 0.00127f
C10005 VDD.n3408 VSS 0.00187f
C10006 VDD.n3409 VSS 0.00767f
C10007 VDD.n3410 VSS 0.01102f
C10008 VDD.n3411 VSS 0.01502f
C10009 VDD.n3412 VSS 0.0128f
C10010 VDD.n3413 VSS 0.00667f
C10011 VDD.n3414 VSS 1.20672f
C10012 VDD.n3415 VSS 1.20687f
C10013 VDD.n3416 VSS 0
C10014 VDD.n3417 VSS 0.02875f
C10015 VDD.n3418 VSS 0.41167f
C10016 VDD.n3419 VSS 0
C10017 VDD.n3420 VSS 0.03187f
C10018 VDD.n3421 VSS 0.0277f
C10019 VDD.n3422 VSS 0.0277f
C10020 VDD.n3423 VSS 0
C10021 VDD.n3424 VSS 0.03158f
C10022 VDD.n3425 VSS 1.5329f
C10023 VDD.n3426 VSS 1.5329f
C10024 VDD.n3427 VSS 0
C10025 VDD.n3428 VSS 0.02875f
C10026 VDD.n3429 VSS 0.41167f
C10027 VDD.n3430 VSS 0
C10028 VDD.n3431 VSS 0.03187f
C10029 VDD.n3432 VSS 0.0277f
C10030 VDD.n3433 VSS 0.0277f
C10031 VDD.n3434 VSS 0
C10032 VDD.n3435 VSS 0.03158f
C10033 VDD.n3436 VSS 1.40123f
C10034 VDD.n3437 VSS 1.40123f
C10035 VDD.n3438 VSS 0
C10036 VDD.n3439 VSS 0.02875f
C10037 VDD.n3440 VSS 0.41167f
C10038 VDD.n3441 VSS 0
C10039 VDD.n3442 VSS 0.03187f
C10040 VDD.n3443 VSS 0.0277f
C10041 VDD.n3444 VSS 0.0277f
C10042 VDD.n3445 VSS 0
C10043 VDD.n3446 VSS 0.03158f
C10044 VDD.n3447 VSS 1.45143f
C10045 VDD.n3448 VSS 1.45143f
C10046 VDD.n3449 VSS 0
C10047 VDD.n3450 VSS 0.02875f
C10048 VDD.n3451 VSS 0.41167f
C10049 VDD.n3452 VSS 0
C10050 VDD.n3453 VSS 0.03187f
C10051 VDD.n3454 VSS 0.0277f
C10052 VDD.n3455 VSS 0.0277f
C10053 VDD.n3456 VSS 0
C10054 VDD.n3457 VSS 0.03158f
C10055 VDD.n3458 VSS 1.7511f
C10056 VDD.n3459 VSS 1.7511f
C10057 VDD.n3460 VSS 0
C10058 VDD.n3461 VSS 0.02875f
C10059 VDD.n3462 VSS 0.41167f
C10060 VDD.n3463 VSS 0
C10061 VDD.n3464 VSS 0.03187f
C10062 VDD.n3465 VSS 0.0277f
C10063 VDD.n3466 VSS 0.0277f
C10064 VDD.n3467 VSS 0
C10065 VDD.n3468 VSS 0.03158f
C10066 VDD.n3469 VSS 1.36594f
C10067 VDD.n3470 VSS 0.03158f
C10068 VDD.n3471 VSS 0
C10069 VDD.n3472 VSS 0.0277f
C10070 VDD.n3473 VSS 1.36594f
C10071 VDD.n3474 VSS 0
C10072 VDD.n3475 VSS 0.41167f
C10073 VDD.n3476 VSS 0.02875f
C10074 VDD.n3477 VSS 0.02875f
C10075 VDD.n3478 VSS 0.41182f
C10076 VDD.n3479 VSS 0.41152f
C10077 VDD.n3480 VSS 0
C10078 VDD.n3481 VSS 0.03187f
C10079 VDD.n3482 VSS 0.0277f
C10080 VDD.n3483 VSS 0.0277f
C10081 VDD.n3484 VSS 0
C10082 VDD.n3485 VSS 0.03158f
C10083 VDD.n3486 VSS 1.61839f
C10084 VDD.n3487 VSS 0.03158f
C10085 VDD.n3488 VSS 0
C10086 VDD.n3489 VSS 0.0277f
C10087 VDD.n3490 VSS 1.61839f
C10088 VDD.n3491 VSS 0
C10089 VDD.n3492 VSS 0.41152f
C10090 VDD.n3493 VSS 0.02875f
C10091 VDD.n3494 VSS 0.02875f
C10092 VDD.n3495 VSS 0.41197f
C10093 VDD.n3496 VSS 0.41167f
C10094 VDD.n3497 VSS 0.03158f
C10095 VDD.n3498 VSS 0
C10096 VDD.n3499 VSS 0.03187f
C10097 VDD.n3500 VSS 0.02875f
C10098 VDD.n3501 VSS 1.98449f
C10099 VDD.n3502 VSS 0.03158f
C10100 VDD.n3503 VSS 0.02964f
C10101 VDD.n3504 VSS 0.02875f
C10102 VDD.n3505 VSS 0.0277f
C10103 VDD.n3506 VSS 0.03187f
C10104 VDD.n3507 VSS 0
C10105 VDD.n3508 VSS 1.61839f
C10106 VDD.n3509 VSS 1.61839f
C10107 VDD.n3510 VSS 0.03158f
C10108 VDD.n3511 VSS 0.02964f
C10109 VDD.n3512 VSS 0.02875f
C10110 VDD.n3513 VSS 0.0277f
C10111 VDD.n3514 VSS 0.03187f
C10112 VDD.n3515 VSS 0
C10113 VDD.n3516 VSS 1.36594f
C10114 VDD.n3517 VSS 1.36594f
C10115 VDD.n3518 VSS 0.03158f
C10116 VDD.n3519 VSS 0.02964f
C10117 VDD.n3520 VSS 0.02875f
C10118 VDD.n3521 VSS 0.0277f
C10119 VDD.n3522 VSS 0.03187f
C10120 VDD.n3523 VSS 0
C10121 VDD.n3524 VSS 1.7511f
C10122 VDD.n3525 VSS 1.7511f
C10123 VDD.n3526 VSS 0.03158f
C10124 VDD.n3527 VSS 0.02964f
C10125 VDD.n3528 VSS 0.02875f
C10126 VDD.n3529 VSS 0.0277f
C10127 VDD.n3530 VSS 0.03187f
C10128 VDD.n3531 VSS 0
C10129 VDD.n3532 VSS 1.45143f
C10130 VDD.n3533 VSS 1.45143f
C10131 VDD.n3534 VSS 0.03158f
C10132 VDD.n3535 VSS 0.02964f
C10133 VDD.n3536 VSS 0.02875f
C10134 VDD.n3537 VSS 0.0277f
C10135 VDD.n3538 VSS 0.03187f
C10136 VDD.n3539 VSS 0
C10137 VDD.n3540 VSS 1.40123f
C10138 VDD.n3541 VSS 1.40123f
C10139 VDD.n3542 VSS 0.03158f
C10140 VDD.n3543 VSS 0.02964f
C10141 VDD.n3544 VSS 0.02875f
C10142 VDD.n3545 VSS 0.0277f
C10143 VDD.n3546 VSS 0.03187f
C10144 VDD.n3547 VSS 0
C10145 VDD.n3548 VSS 1.5329f
C10146 VDD.n3549 VSS 0.03187f
C10147 VDD.n3550 VSS 0.01892f
C10148 VDD.n3551 VSS 0.00637f
C10149 VDD.n3552 VSS 0.01021f
C10150 VDD.t397 VSS 0.0048f
C10151 VDD.n3553 VSS 0.01532f
C10152 VDD.n3554 VSS 0.0122f
C10153 VDD.t355 VSS 0.07801f
C10154 VDD.n3555 VSS 0.05436f
C10155 VDD.t436 VSS 0.0048f
C10156 VDD.n3556 VSS 0.013f
C10157 VDD.t140 VSS 0.07801f
C10158 VDD.t435 VSS 0.07931f
C10159 VDD.n3557 VSS 0.07927f
C10160 VDD.t371 VSS 0.07801f
C10161 VDD.t441 VSS 0.07931f
C10162 VDD.n3558 VSS 0.07923f
C10163 VDD.t442 VSS 0.0048f
C10164 VDD.n3559 VSS 0.01532f
C10165 VDD.t372 VSS 0.0048f
C10166 VDD.n3560 VSS 0.013f
C10167 VDD.n3561 VSS 0.05436f
C10168 VDD.t572 VSS 0.07801f
C10169 VDD.t713 VSS 0.07932f
C10170 VDD.t714 VSS 0.0048f
C10171 VDD.n3562 VSS 0.06992f
C10172 VDD.t573 VSS 0.0048f
C10173 VDD.n3563 VSS 0.01532f
C10174 VDD.n3564 VSS 0.00975f
C10175 VDD.n3565 VSS 0.00979f
C10176 VDD.n3566 VSS 0.01221f
C10177 VDD.n3567 VSS 0.00602f
C10178 VDD.n3568 VSS 0.00273f
C10179 VDD.t142 VSS 0.07801f
C10180 VDD.t620 VSS 0.07801f
C10181 VDD.n3569 VSS 0.00778f
C10182 VDD.t621 VSS 0.0048f
C10183 VDD.n3570 VSS 0.013f
C10184 VDD.n3571 VSS 0.00713f
C10185 VDD.t438 VSS 0.0079f
C10186 VDD.n3572 VSS 0.00767f
C10187 VDD.n3573 VSS 0.01372f
C10188 VDD.n3574 VSS 0.01393f
C10189 VDD.n3575 VSS 0.06551f
C10190 VDD.t437 VSS 0.08094f
C10191 VDD.n3576 VSS 0.08847f
C10192 VDD.t388 VSS 0.09527f
C10193 VDD.t389 VSS 0.00789f
C10194 VDD.n3577 VSS 0.01815f
C10195 VDD.n3578 VSS 0.05953f
C10196 VDD.t439 VSS 0.07762f
C10197 VDD.n3579 VSS 0.06139f
C10198 VDD.n3580 VSS 0.00655f
C10199 VDD.t440 VSS 0.0048f
C10200 VDD.n3581 VSS 0.013f
C10201 VDD.t356 VSS 0.0048f
C10202 VDD.n3582 VSS 0.01369f
C10203 VDD.n3583 VSS 0.0064f
C10204 VDD.n3584 VSS 0.01892f
C10205 VDD.n3585 VSS 0.36565f
C10206 VDD.n3586 VSS 0.02432f
C10207 VDD.n3587 VSS 0.00649f
C10208 VDD.n3588 VSS 0.01598f
C10209 VDD.n3589 VSS 0.00714f
C10210 VDD.n3590 VSS 0.00377f
C10211 VDD.n3591 VSS 0.01224f
C10212 VDD.n3592 VSS 0.05436f
C10213 VDD.t516 VSS 0.17168f
C10214 VDD.t164 VSS 0.0048f
C10215 VDD.n3593 VSS 0.013f
C10216 VDD.n3594 VSS 0.01404f
C10217 VDD.t715 VSS 0.0079f
C10218 VDD.t517 VSS 0.00789f
C10219 VDD.n3595 VSS 0.00605f
C10220 VDD.n3596 VSS 0.01803f
C10221 VDD.n3597 VSS -0.00341f
C10222 VDD.n3598 VSS 0.12581f
C10223 VDD.n3599 VSS -0.0017f
C10224 VDD.n3600 VSS 0.00767f
C10225 VDD.n3601 VSS 0.01372f
C10226 VDD.n3602 VSS 0.01393f
C10227 VDD.n3603 VSS 0.06997f
C10228 VDD.t163 VSS 0.07801f
C10229 VDD.t396 VSS 0.07801f
C10230 VDD.n3604 VSS 0.05436f
C10231 VDD.n3605 VSS 0.01224f
C10232 VDD.n3606 VSS 0.0036f
C10233 VDD.n3607 VSS 0.00714f
C10234 VDD.n3608 VSS 0.0128f
C10235 VDD.n3609 VSS 0.00667f
C10236 VDD.n3610 VSS 1.20508f
C10237 VDD.n3611 VSS 1.20523f
C10238 VDD.n3612 VSS 0
C10239 VDD.n3613 VSS 0.03187f
C10240 VDD.n3614 VSS 0.0277f
C10241 VDD.n3615 VSS 0.0277f
C10242 VDD.n3616 VSS 0.02964f
C10243 VDD.n3617 VSS 0.03158f
C10244 VDD.n3618 VSS 1.5329f
C10245 VDD.n3619 VSS 0.02875f
C10246 VDD.n3620 VSS 0.41167f
C10247 VDD.n3621 VSS 0.41197f
C10248 VDD.n3622 VSS 0.02875f
C10249 VDD.n3623 VSS 0.0277f
C10250 VDD.n3624 VSS 0.03187f
C10251 VDD.n3625 VSS 0
C10252 VDD.n3626 VSS 1.20568f
C10253 VDD.n3627 VSS 0.01598f
C10254 VDD.n3628 VSS 0.00637f
C10255 VDD.n3629 VSS 0.00667f
C10256 VDD.n3630 VSS 1.20553f
C10257 VDD.n3631 VSS 0.01892f
C10258 VDD.n3632 VSS 0.01021f
C10259 VDD.n3633 VSS 0.36535f
C10260 VDD.n3634 VSS 0.02432f
C10261 VDD.n3635 VSS 0.00843f
C10262 VDD.t143 VSS 0.0048f
C10263 VDD.n3636 VSS 0.00737f
C10264 VDD.n3637 VSS 0.00624f
C10265 VDD.n3638 VSS 0.01224f
C10266 VDD.n3639 VSS 0.0122f
C10267 VDD.n3640 VSS 0.00975f
C10268 VDD.n3641 VSS 0.00979f
C10269 VDD.n3642 VSS 0.01221f
C10270 VDD.n3643 VSS 0.05436f
C10271 VDD.t668 VSS 0.07801f
C10272 VDD.t204 VSS 0.07931f
C10273 VDD.n3644 VSS 0.07907f
C10274 VDD.n3645 VSS 0.0791f
C10275 VDD.t227 VSS 0.07931f
C10276 VDD.t288 VSS 0.07801f
C10277 VDD.n3646 VSS 0.05436f
C10278 VDD.n3647 VSS 0.0122f
C10279 VDD.n3648 VSS 0.01224f
C10280 VDD.n3649 VSS 0.00624f
C10281 VDD.n3650 VSS 0.00624f
C10282 VDD.n3651 VSS 0.01224f
C10283 VDD.n3652 VSS 0.05436f
C10284 VDD.t443 VSS 0.07801f
C10285 VDD.t718 VSS 0.07762f
C10286 VDD.n3653 VSS 0.06139f
C10287 VDD.n3654 VSS 0.05953f
C10288 VDD.t581 VSS 0.00789f
C10289 VDD.n3655 VSS 0.01815f
C10290 VDD.n3656 VSS 0.00602f
C10291 VDD.n3657 VSS 0.00844f
C10292 VDD.n3658 VSS 0.0128f
C10293 VDD.n3659 VSS 0.00667f
C10294 VDD.n3660 VSS 1.20657f
C10295 VDD.n3661 VSS 1.20672f
C10296 VDD.n3662 VSS 0
C10297 VDD.n3663 VSS 0.02875f
C10298 VDD.n3664 VSS 0.41212f
C10299 VDD.n3665 VSS 0
C10300 VDD.n3666 VSS 0.03187f
C10301 VDD.n3667 VSS 0.0277f
C10302 VDD.n3668 VSS 0.0277f
C10303 VDD.n3669 VSS 0
C10304 VDD.n3670 VSS 0.03158f
C10305 VDD.n3671 VSS 1.5329f
C10306 VDD.n3672 VSS 1.5329f
C10307 VDD.n3673 VSS 0
C10308 VDD.n3674 VSS 0.02875f
C10309 VDD.n3675 VSS 0.41212f
C10310 VDD.n3676 VSS 0
C10311 VDD.n3677 VSS 0.03187f
C10312 VDD.n3678 VSS 0.0277f
C10313 VDD.n3679 VSS 0.0277f
C10314 VDD.n3680 VSS 0
C10315 VDD.n3681 VSS 0.03158f
C10316 VDD.n3682 VSS 1.40123f
C10317 VDD.n3683 VSS 1.40123f
C10318 VDD.n3684 VSS 0
C10319 VDD.n3685 VSS 0.02875f
C10320 VDD.n3686 VSS 0.41212f
C10321 VDD.n3687 VSS 0
C10322 VDD.n3688 VSS 0.03187f
C10323 VDD.n3689 VSS 0.0277f
C10324 VDD.n3690 VSS 0.0277f
C10325 VDD.n3691 VSS 0
C10326 VDD.n3692 VSS 0.03158f
C10327 VDD.n3693 VSS 1.45143f
C10328 VDD.n3694 VSS 1.45143f
C10329 VDD.n3695 VSS 0
C10330 VDD.n3696 VSS 0.02875f
C10331 VDD.n3697 VSS 0.41212f
C10332 VDD.n3698 VSS 0
C10333 VDD.n3699 VSS 0.03187f
C10334 VDD.n3700 VSS 0.0277f
C10335 VDD.n3701 VSS 0.0277f
C10336 VDD.n3702 VSS 0
C10337 VDD.n3703 VSS 0.03158f
C10338 VDD.n3704 VSS 1.7511f
C10339 VDD.n3705 VSS 1.7511f
C10340 VDD.n3706 VSS 0
C10341 VDD.n3707 VSS 0.02875f
C10342 VDD.n3708 VSS 0.41212f
C10343 VDD.n3709 VSS 0
C10344 VDD.n3710 VSS 0.03187f
C10345 VDD.n3711 VSS 0.0277f
C10346 VDD.n3712 VSS 0.0277f
C10347 VDD.n3713 VSS 0
C10348 VDD.n3714 VSS 0.03158f
C10349 VDD.n3715 VSS 1.36594f
C10350 VDD.n3716 VSS 1.36594f
C10351 VDD.n3717 VSS 0
C10352 VDD.n3718 VSS 0.02875f
C10353 VDD.n3719 VSS 0.41212f
C10354 VDD.n3720 VSS 0
C10355 VDD.n3721 VSS 0.03187f
C10356 VDD.n3722 VSS 0.0277f
C10357 VDD.n3723 VSS 0.0277f
C10358 VDD.n3724 VSS 0
C10359 VDD.n3725 VSS 0.03158f
C10360 VDD.n3726 VSS 1.61839f
C10361 VDD.n3727 VSS 1.61839f
C10362 VDD.n3728 VSS 0
C10363 VDD.n3729 VSS 0.03187f
C10364 VDD.n3730 VSS 0.0277f
C10365 VDD.n3731 VSS 0.0277f
C10366 VDD.n3732 VSS 0
C10367 VDD.n3733 VSS 0.03158f
C10368 VDD.n3734 VSS 1.98091f
C10369 VDD.n3735 VSS 0.02875f
C10370 VDD.n3736 VSS 0.41212f
C10371 VDD.n3737 VSS 0.41242f
C10372 VDD.n3738 VSS 0.02875f
C10373 VDD.n3739 VSS 0
C10374 VDD.n3740 VSS 0
C10375 VDD.n3741 VSS 1.98419f
C10376 VDD.n3742 VSS 0.03158f
C10377 VDD.n3743 VSS 0.03187f
C10378 VDD.n3744 VSS 0.02875f
C10379 VDD.n3745 VSS 0.0277f
C10380 VDD.n3746 VSS 0.03187f
C10381 VDD.n3747 VSS 0
C10382 VDD.n3748 VSS 1.61839f
C10383 VDD.n3749 VSS 1.61839f
C10384 VDD.n3750 VSS 0.03158f
C10385 VDD.n3751 VSS 0.03187f
C10386 VDD.n3752 VSS 0.02875f
C10387 VDD.n3753 VSS 0.0277f
C10388 VDD.n3754 VSS 0.03187f
C10389 VDD.n3755 VSS 0
C10390 VDD.n3756 VSS 1.36594f
C10391 VDD.n3757 VSS 1.36594f
C10392 VDD.n3758 VSS 0.03158f
C10393 VDD.n3759 VSS 0.03187f
C10394 VDD.n3760 VSS 0.02875f
C10395 VDD.n3761 VSS 0.0277f
C10396 VDD.n3762 VSS 0.03187f
C10397 VDD.n3763 VSS 0
C10398 VDD.n3764 VSS 1.7511f
C10399 VDD.n3765 VSS 1.7511f
C10400 VDD.n3766 VSS 0.03158f
C10401 VDD.n3767 VSS 0.03187f
C10402 VDD.n3768 VSS 0.02875f
C10403 VDD.n3769 VSS 0.0277f
C10404 VDD.n3770 VSS 0.03187f
C10405 VDD.n3771 VSS 0
C10406 VDD.n3772 VSS 1.45143f
C10407 VDD.n3773 VSS 1.45143f
C10408 VDD.n3774 VSS 0.03158f
C10409 VDD.n3775 VSS 0.03187f
C10410 VDD.n3776 VSS 0.02875f
C10411 VDD.n3777 VSS 0.0277f
C10412 VDD.n3778 VSS 0.03187f
C10413 VDD.n3779 VSS 0
C10414 VDD.n3780 VSS 1.40123f
C10415 VDD.n3781 VSS 1.40123f
C10416 VDD.n3782 VSS 0.03158f
C10417 VDD.n3783 VSS 0.03187f
C10418 VDD.n3784 VSS 0.02875f
C10419 VDD.n3785 VSS 0.0277f
C10420 VDD.n3786 VSS 0.03187f
C10421 VDD.n3787 VSS 0
C10422 VDD.n3788 VSS 1.5329f
C10423 VDD.n3789 VSS 1.5329f
C10424 VDD.n3790 VSS 0.03158f
C10425 VDD.n3791 VSS 0.03187f
C10426 VDD.n3792 VSS 0.02875f
C10427 VDD.n3793 VSS 0.0277f
C10428 VDD.n3794 VSS 0.03187f
C10429 VDD.n3795 VSS 0
C10430 VDD.n3796 VSS 1.20478f
C10431 VDD.n3797 VSS 0.01262f
C10432 VDD.n3798 VSS 0.00667f
C10433 VDD.n3799 VSS 1.20463f
C10434 VDD.n3800 VSS 0.01892f
C10435 VDD.n3801 VSS 0.01021f
C10436 VDD.n3802 VSS 0.36684f
C10437 VDD.n3803 VSS 0.02432f
C10438 VDD.n3804 VSS 0.01117f
C10439 VDD.n3805 VSS 0.00572f
C10440 VDD.n3806 VSS 0.01202f
C10441 VDD.n3807 VSS 0.00127f
C10442 VDD.n3808 VSS 0.06674f
C10443 VDD.t683 VSS 0.08053f
C10444 VDD.n3809 VSS 0.06551f
C10445 VDD.n3810 VSS 0.01393f
C10446 VDD.t559 VSS 0.0048f
C10447 VDD.n3811 VSS 0.013f
C10448 VDD.t577 VSS 0.0048f
C10449 VDD.n3812 VSS 0.01532f
C10450 VDD.n3813 VSS 0.00624f
C10451 VDD.n3814 VSS 0.01224f
C10452 VDD.n3815 VSS 0.05436f
C10453 VDD.n3816 VSS 0.05436f
C10454 VDD.n3817 VSS 0.01224f
C10455 VDD.n3818 VSS 0.00624f
C10456 VDD.t271 VSS 0.0048f
C10457 VDD.n3819 VSS 0.00879f
C10458 VDD.n3820 VSS 0.01002f
C10459 VDD.n3821 VSS 0.01014f
C10460 VDD.n3822 VSS 0.01598f
C10461 VDD.n3823 VSS 0.00637f
C10462 VDD.n3824 VSS 0.00667f
C10463 VDD.n3825 VSS 1.20627f
C10464 VDD.n3826 VSS 0.01892f
C10465 VDD.n3827 VSS 0.01021f
C10466 VDD.n3828 VSS 0.36416f
C10467 VDD.n3829 VSS 0.02432f
C10468 VDD.n3830 VSS 0.01024f
C10469 VDD.t374 VSS 0.0048f
C10470 VDD.n3831 VSS 0.01173f
C10471 VDD.n3832 VSS 0.00655f
C10472 VDD.n3833 VSS 0.00602f
C10473 VDD.t293 VSS 0.00789f
C10474 VDD.n3834 VSS 0.01815f
C10475 VDD.n3835 VSS 0.05953f
C10476 VDD.t292 VSS 0.09527f
C10477 VDD.n3836 VSS 0.08847f
C10478 VDD.n3837 VSS 0.00273f
C10479 VDD.n3838 VSS 0.00767f
C10480 VDD.n3839 VSS 0.01372f
C10481 VDD.n3840 VSS 0.01393f
C10482 VDD.n3841 VSS 0.06551f
C10483 VDD.t53 VSS 0.07801f
C10484 VDD.t301 VSS 0.07801f
C10485 VDD.n3842 VSS 0.05436f
C10486 VDD.n3843 VSS 0.01224f
C10487 VDD.n3844 VSS 0.00568f
C10488 VDD.n3845 VSS 0.00714f
C10489 VDD.n3846 VSS 0.0128f
C10490 VDD.n3847 VSS 0.00667f
C10491 VDD.n3848 VSS 0.28269f
C10492 VDD.n3849 VSS 0.01892f
C10493 VDD.n3850 VSS 0.28269f
C10494 VDD.n3851 VSS 0.02432f
C10495 VDD.n3852 VSS 0.01468f
C10496 VDD.n3853 VSS 0.01422f
C10497 VDD.n3854 VSS -0.00162f
C10498 VDD.n3855 VSS 0.05436f
C10499 VDD.t641 VSS 0.07801f
C10500 VDD.t41 VSS 0.07801f
C10501 VDD.t28 VSS 0.07801f
C10502 VDD.n3856 VSS 0.05428f
C10503 VDD.n3857 VSS 0.05436f
C10504 VDD.n3858 VSS -0.00166f
C10505 VDD.n3859 VSS 0.01302f
C10506 VDD.n3860 VSS 0.01361f
C10507 VDD.n3861 VSS 0.0128f
C10508 VDD.n3862 VSS 0.00667f
C10509 VDD.n3863 VSS 0.90839f
C10510 VDD.n3864 VSS 0.90854f
C10511 VDD.n3865 VSS 0
C10512 VDD.n3866 VSS 0.03187f
C10513 VDD.n3867 VSS 0.0277f
C10514 VDD.n3868 VSS 0.0277f
C10515 VDD.n3869 VSS 0
C10516 VDD.n3870 VSS 0.03158f
C10517 VDD.n3871 VSS 1.5329f
C10518 VDD.n3872 VSS 0.02875f
C10519 VDD.n3873 VSS 0.41167f
C10520 VDD.n3874 VSS 0.41197f
C10521 VDD.n3875 VSS 0.02875f
C10522 VDD.n3876 VSS 0.0277f
C10523 VDD.n3877 VSS 0.03187f
C10524 VDD.n3878 VSS 0
C10525 VDD.n3879 VSS 0.90869f
C10526 VDD.n3880 VSS 0.90854f
C10527 VDD.n3881 VSS 0.00667f
C10528 VDD.n3882 VSS 0.00637f
C10529 VDD.n3883 VSS 0.01892f
C10530 VDD.n3884 VSS 0.28239f
C10531 VDD.n3885 VSS 0.02432f
C10532 VDD.n3886 VSS 0.0103f
C10533 VDD.n3887 VSS -0.00162f
C10534 VDD.n3888 VSS 0.00985f
C10535 VDD.n3889 VSS 0.0095f
C10536 VDD.n3890 VSS 0.05428f
C10537 VDD.t512 VSS 0.07792f
C10538 VDD.t4 VSS 0.07792f
C10539 VDD.n3891 VSS 0.05428f
C10540 VDD.n3892 VSS 0.05436f
C10541 VDD.n3893 VSS -0.00166f
C10542 VDD.n3894 VSS 0.02208f
C10543 VDD.n3895 VSS 0.02265f
C10544 VDD.n3896 VSS 0.0128f
C10545 VDD.n3897 VSS 0.00667f
C10546 VDD.n3898 VSS 0.90407f
C10547 VDD.n3899 VSS 0.01892f
C10548 VDD.n3900 VSS 0.00649f
C10549 VDD.n3901 VSS 0.02432f
C10550 VDD.n3902 VSS 0.28135f
C10551 VDD.n3903 VSS 0.28135f
C10552 VDD.n3904 VSS 0.00667f
C10553 VDD.n3905 VSS 0.00637f
C10554 VDD.n3906 VSS 0.01892f
C10555 VDD.n3907 VSS 0.36446f
C10556 VDD.n3908 VSS 0.02432f
C10557 VDD.n3909 VSS 0.00958f
C10558 VDD.t300 VSS 0.0048f
C10559 VDD.n3910 VSS 0.01532f
C10560 VDD.n3911 VSS 0.00624f
C10561 VDD.n3912 VSS 0.01224f
C10562 VDD.n3913 VSS 0.0122f
C10563 VDD.n3914 VSS 0.00975f
C10564 VDD.n3915 VSS 0.00979f
C10565 VDD.n3916 VSS 0.01221f
C10566 VDD.n3917 VSS 0.05436f
C10567 VDD.t405 VSS 0.07801f
C10568 VDD.t638 VSS 0.07931f
C10569 VDD.n3918 VSS 0.07907f
C10570 VDD.n3919 VSS 0.0791f
C10571 VDD.t473 VSS 0.07931f
C10572 VDD.t627 VSS 0.07801f
C10573 VDD.n3920 VSS 0.05436f
C10574 VDD.n3921 VSS 0.0122f
C10575 VDD.n3922 VSS 0.01224f
C10576 VDD.n3923 VSS 0.00624f
C10577 VDD.n3924 VSS 0.00624f
C10578 VDD.n3925 VSS 0.01224f
C10579 VDD.n3926 VSS 0.05436f
C10580 VDD.t74 VSS 0.07801f
C10581 VDD.t315 VSS 0.07762f
C10582 VDD.n3927 VSS 0.06139f
C10583 VDD.n3928 VSS 0.00378f
C10584 VDD.n3929 VSS 0.00765f
C10585 VDD.n3930 VSS 0.01598f
C10586 VDD.n3931 VSS 0.00637f
C10587 VDD.n3932 VSS 0.00667f
C10588 VDD.n3933 VSS 0.28046f
C10589 VDD.n3934 VSS 0.01892f
C10590 VDD.n3935 VSS 0.01021f
C10591 VDD.n3936 VSS 0.36714f
C10592 VDD.n3937 VSS 0.02432f
C10593 VDD.n3938 VSS 0.00851f
C10594 VDD.n3939 VSS 0.00591f
C10595 VDD.n3940 VSS 0.00273f
C10596 VDD.n3941 VSS 0.08847f
C10597 VDD.t319 VSS 0.08094f
C10598 VDD.n3942 VSS 0.06551f
C10599 VDD.n3943 VSS 0.01393f
C10600 VDD.t434 VSS 0.0048f
C10601 VDD.n3944 VSS 0.013f
C10602 VDD.t65 VSS 0.0048f
C10603 VDD.n3945 VSS 0.01532f
C10604 VDD.n3946 VSS 0.00624f
C10605 VDD.n3947 VSS 0.01224f
C10606 VDD.n3948 VSS 0.05436f
C10607 VDD.n3949 VSS 0.05436f
C10608 VDD.n3950 VSS 0.01224f
C10609 VDD.n3951 VSS 0.00624f
C10610 VDD.t27 VSS 0.0048f
C10611 VDD.n3952 VSS 0.01094f
C10612 VDD.n3953 VSS 0.01217f
C10613 VDD.n3954 VSS 0.0128f
C10614 VDD.n3955 VSS 0.00667f
C10615 VDD.n3956 VSS 0.27971f
C10616 VDD.n3957 VSS 0.01892f
C10617 VDD.n3958 VSS 0.27971f
C10618 VDD.n3959 VSS 0.02432f
C10619 VDD.n3960 VSS 0.01602f
C10620 VDD.n3961 VSS 0.03047f
C10621 VDD.n3962 VSS 0.05178f
C10622 VDD.t153 VSS 0.07897f
C10623 VDD.t40 VSS 0.07897f
C10624 VDD.n3963 VSS 0.05174f
C10625 VDD.n3964 VSS 0.02656f
C10626 VDD.n3965 VSS 0.01227f
C10627 VDD.n3966 VSS 0.0128f
C10628 VDD.n3967 VSS 0.00667f
C10629 VDD.n3968 VSS 0.90586f
C10630 VDD.n3969 VSS 0.90601f
C10631 VDD.n3970 VSS 0
C10632 VDD.n3971 VSS 0.02875f
C10633 VDD.n3972 VSS 0
C10634 VDD.n3973 VSS 0.028f
C10635 VDD.t541 VSS 0.07801f
C10636 VDD.n3974 VSS 0.05428f
C10637 VDD.t542 VSS 0.00488f
C10638 VDD.n3975 VSS 0.0173f
C10639 VDD.n3976 VSS 0.02802f
C10640 VDD.n3977 VSS -0.00166f
C10641 VDD.n3978 VSS 0.05436f
C10642 VDD.t678 VSS 0.07792f
C10643 VDD.t556 VSS 0.07792f
C10644 VDD.n3979 VSS -0.00164f
C10645 VDD.n3980 VSS 0.05436f
C10646 VDD.t223 VSS 0.07801f
C10647 VDD.n3981 VSS 0.05428f
C10648 VDD.n3982 VSS 0.00954f
C10649 VDD.t224 VSS 0.0048f
C10650 VDD.n3983 VSS 0.11305f
C10651 VDD.n3984 VSS 0.01452f
C10652 VDD.n3985 VSS 0.37995f
C10653 VDD.n3986 VSS 1.04259f
C10654 VDD.n3987 VSS 1.04229f
C10655 VDD.n3988 VSS 0
C10656 VDD.n3989 VSS 0.03187f
C10657 VDD.n3990 VSS 0.0277f
C10658 VDD.n3991 VSS 0.0277f
C10659 VDD.n3992 VSS 0
C10660 VDD.n3993 VSS 0.03158f
C10661 VDD.n3994 VSS 1.5329f
C10662 VDD.n3995 VSS 1.5329f
C10663 VDD.n3996 VSS 0
C10664 VDD.n3997 VSS 0.03187f
C10665 VDD.n3998 VSS 0.0277f
C10666 VDD.n3999 VSS 0.0277f
C10667 VDD.n4000 VSS 0
C10668 VDD.n4001 VSS 0.03158f
C10669 VDD.n4002 VSS 1.40123f
C10670 VDD.n4003 VSS 0.02875f
C10671 VDD.n4004 VSS 1.04184f
C10672 VDD.n4005 VSS 1.04214f
C10673 VDD.n4006 VSS 0.43761f
C10674 VDD.n4007 VSS 0.43631f
C10675 VDD.n4008 VSS 2.21609f
C10676 VDD.n4009 VSS 2.21624f
C10677 VDD.n4010 VSS 0
C10678 VDD.n4011 VSS 0.03187f
C10679 VDD.n4012 VSS 0.0277f
C10680 VDD.n4013 VSS 2.84345f
C10681 VDD.n4014 VSS 0
C10682 VDD.n4015 VSS 0.03158f
C10683 VDD.n4016 VSS 1.5329f
C10684 VDD.n4017 VSS 0.02875f
C10685 VDD.n4018 VSS 0.41167f
C10686 VDD.n4019 VSS 0.41197f
C10687 VDD.n4020 VSS 0
C10688 VDD.n4021 VSS 0.03187f
C10689 VDD.n4022 VSS 0.0277f
C10690 VDD.n4023 VSS 2.84405f
C10691 VDD.n4024 VSS 0
C10692 VDD.n4025 VSS 0.03158f
C10693 VDD.n4026 VSS 1.5329f
C10694 VDD.n4027 VSS 0.02875f
C10695 VDD.n4028 VSS 0.41152f
C10696 VDD.n4029 VSS 0.41182f
C10697 VDD.n4030 VSS 0
C10698 VDD.n4031 VSS 0.03187f
C10699 VDD.n4032 VSS 0.0277f
C10700 VDD.n4033 VSS 2.84643f
C10701 VDD.n4034 VSS 0
C10702 VDD.n4035 VSS 0.03158f
C10703 VDD.n4036 VSS 1.5329f
C10704 VDD.n4037 VSS 0.02875f
C10705 VDD.n4038 VSS 0.41167f
C10706 VDD.n4039 VSS 0.41197f
C10707 VDD.n4040 VSS 0
C10708 VDD.n4041 VSS 0.03187f
C10709 VDD.n4042 VSS 0.0277f
C10710 VDD.n4043 VSS 2.84703f
C10711 VDD.n4044 VSS 0
C10712 VDD.n4045 VSS 0.03158f
C10713 VDD.n4046 VSS 1.5329f
C10714 VDD.n4047 VSS 0.02875f
C10715 VDD.n4048 VSS 0.41212f
C10716 VDD.n4049 VSS 0.41242f
C10717 VDD.n4050 VSS 0.03187f
C10718 VDD.n4051 VSS 0.0277f
C10719 VDD.n4052 VSS 0
C10720 VDD.n4053 VSS 2.84375f
C10721 VDD.n4054 VSS 0
C10722 VDD.n4055 VSS 0.03158f
C10723 VDD.n4056 VSS 1.5329f
C10724 VDD.n4057 VSS 0.02875f
C10725 VDD.n4058 VSS 0.41167f
C10726 VDD.n4059 VSS 0.41197f
C10727 VDD.n4060 VSS 0
C10728 VDD.n4061 VSS 0.03187f
C10729 VDD.n4062 VSS 0.0277f
C10730 VDD.n4063 VSS 2.84435f
C10731 VDD.n4064 VSS 0
C10732 VDD.n4065 VSS 0.03158f
C10733 VDD.n4066 VSS 1.5329f
C10734 VDD.n4067 VSS 0.02875f
C10735 VDD.n4068 VSS 0.43684f
C10736 VDD.n4069 VSS 0.43714f
C10737 VDD.n4070 VSS 0.03187f
C10738 VDD.n4071 VSS 0.0277f
C10739 VDD.n4072 VSS 0
C10740 VDD.n4073 VSS 2.8506f
C10741 VDD.n4074 VSS 0
C10742 VDD.n4075 VSS 0.03158f
C10743 VDD.n4076 VSS 1.5329f
C10744 VDD.n4077 VSS 0.02875f
C10745 VDD.n4078 VSS 0.41167f
C10746 VDD.n4079 VSS 0.41197f
C10747 VDD.n4080 VSS 0
C10748 VDD.n4081 VSS 0.03187f
C10749 VDD.n4082 VSS 0.0277f
C10750 VDD.n4083 VSS 2.8512f
C10751 VDD.n4084 VSS 0
C10752 VDD.n4085 VSS 0.03158f
C10753 VDD.n4086 VSS 1.5329f
C10754 VDD.n4087 VSS 0.02875f
C10755 VDD.n4088 VSS 0.41405f
C10756 VDD.n4089 VSS 0.41435f
C10757 VDD.n4090 VSS 0
C10758 VDD.n4091 VSS 0.03187f
C10759 VDD.n4092 VSS 0.0277f
C10760 VDD.n4093 VSS 2.84077f
C10761 VDD.n4094 VSS 0
C10762 VDD.n4095 VSS 0.03158f
C10763 VDD.n4096 VSS 1.5329f
C10764 VDD.n4097 VSS 0.02875f
C10765 VDD.n4098 VSS 0.41167f
C10766 VDD.n4099 VSS 0.41197f
C10767 VDD.n4100 VSS 0
C10768 VDD.n4101 VSS 0.03187f
C10769 VDD.n4102 VSS 0.0277f
C10770 VDD.n4103 VSS 2.84137f
C10771 VDD.n4104 VSS 0
C10772 VDD.n4105 VSS 0.03158f
C10773 VDD.n4106 VSS 1.5329f
C10774 VDD.n4107 VSS 0.02875f
C10775 VDD.n4108 VSS 0.41152f
C10776 VDD.n4109 VSS 0.41182f
C10777 VDD.n4110 VSS 0
C10778 VDD.n4111 VSS 0.03187f
C10779 VDD.n4112 VSS 0.0277f
C10780 VDD.n4113 VSS 2.84375f
C10781 VDD.n4114 VSS 0
C10782 VDD.n4115 VSS 0.03158f
C10783 VDD.n4116 VSS 1.5329f
C10784 VDD.n4117 VSS 0.02875f
C10785 VDD.n4118 VSS 0.41167f
C10786 VDD.n4119 VSS 0.41197f
C10787 VDD.n4120 VSS 0.50874f
C10788 VDD.n4121 VSS 0
C10789 VDD.n4122 VSS 0.02875f
C10790 VDD.n4123 VSS 0.03187f
C10791 VDD.n4124 VSS 0.0277f
C10792 VDD.n4125 VSS 2.84435f
C10793 VDD.n4126 VSS 0
C10794 VDD.n4127 VSS 0.03158f
C10795 VDD.n4128 VSS 1.5329f
C10796 VDD.n4129 VSS 0.03158f
C10797 VDD.n4130 VSS 0
C10798 VDD.n4131 VSS 0.0277f
C10799 VDD.n4132 VSS 1.5329f
C10800 VDD.n4133 VSS 0.50862f
C10801 VDD.n4134 VSS 0.02876f
C10802 VDD.n4135 VSS 0.02875f
C10803 VDD.n4136 VSS 0.41197f
C10804 VDD.n4137 VSS 0.41167f
C10805 VDD.n4138 VSS 0
C10806 VDD.n4139 VSS 0.03187f
C10807 VDD.n4140 VSS 0.0277f
C10808 VDD.n4141 VSS 0.0277f
C10809 VDD.n4142 VSS 0
C10810 VDD.n4143 VSS 0.03158f
C10811 VDD.n4144 VSS 1.40123f
C10812 VDD.n4145 VSS 1.40123f
C10813 VDD.n4146 VSS 0
C10814 VDD.n4147 VSS 0.03187f
C10815 VDD.n4148 VSS 0.0277f
C10816 VDD.n4149 VSS 0.0277f
C10817 VDD.n4150 VSS 0
C10818 VDD.n4151 VSS 0.03158f
C10819 VDD.n4152 VSS 1.45143f
C10820 VDD.n4153 VSS 0.02875f
C10821 VDD.n4154 VSS 0.41167f
C10822 VDD.n4155 VSS 0.41197f
C10823 VDD.n4156 VSS 0.02875f
C10824 VDD.n4157 VSS 0.0277f
C10825 VDD.n4158 VSS 0.03187f
C10826 VDD.n4159 VSS 0.50862f
C10827 VDD.n4160 VSS 1.07103f
C10828 VDD.n4161 VSS 1.07088f
C10829 VDD.n4162 VSS 0.00667f
C10830 VDD.n4163 VSS 0.00637f
C10831 VDD.n4164 VSS 0.01892f
C10832 VDD.n4165 VSS 0.31129f
C10833 VDD.n4166 VSS 0.02432f
C10834 VDD.n4167 VSS 0.02315f
C10835 VDD.n4168 VSS 0.01528f
C10836 VDD.t170 VSS 4.36944f
C10837 VDD.t213 VSS 4.28544f
C10838 VDD.t210 VSS 2.46923f
C10839 VDD.n4169 VSS 3.26177f
C10840 VDD.t253 VSS 3.98954f
C10841 VDD.n4170 VSS 3.25265f
C10842 VDD.n4171 VSS 0.13932f
C10843 VDD.n4172 VSS 2.23873f
C10844 VDD.t307 VSS 4.36943f
C10845 VDD.t14 VSS 4.28544f
C10846 VDD.t16 VSS 2.46923f
C10847 VDD.n4173 VSS 3.26175f
C10848 VDD.t309 VSS 3.98954f
C10849 VDD.n4174 VSS 3.25262f
C10850 VDD.n4175 VSS 0.13937f
C10851 VDD.n4176 VSS 2.24095f
C10852 VDD.n4177 VSS 0.19166f
C10853 VDD.n4178 VSS 0.02216f
C10854 VDD.n4179 VSS 0.05326f
C10855 VDD.t651 VSS 0.07897f
C10856 VDD.t708 VSS 0.07897f
C10857 VDD.n4180 VSS 0.05321f
C10858 VDD.n4181 VSS 0.06396f
C10859 programmable_folded_cascode_0.programmable_pfet_1.transmission_gate$16_1.out.t1 VSS 0.01024f
C10860 programmable_folded_cascode_0.programmable_pfet_1.transmission_gate$16_1.out.t2 VSS 0.00993f
C10861 programmable_folded_cascode_0.programmable_pfet_1.transmission_gate$16_1.out.t0 VSS 0.04036f
C10862 programmable_folded_cascode_0.programmable_pfet_1.transmission_gate$16_1.out.t6 VSS 2.00286f
C10863 programmable_folded_cascode_0.programmable_pfet_1.transmission_gate$16_1.out.t4 VSS 2.0554f
C10864 programmable_folded_cascode_0.programmable_pfet_1.transmission_gate$16_1.out.t11 VSS 2.0554f
C10865 programmable_folded_cascode_0.programmable_pfet_1.transmission_gate$16_1.out.t12 VSS 2.05525f
C10866 programmable_folded_cascode_0.programmable_pfet_1.transmission_gate$16_1.out.t9 VSS 2.05525f
C10867 programmable_folded_cascode_0.programmable_pfet_1.transmission_gate$16_1.out.t16 VSS 2.05525f
C10868 programmable_folded_cascode_0.programmable_pfet_1.transmission_gate$16_1.out.t17 VSS 2.05525f
C10869 programmable_folded_cascode_0.programmable_pfet_1.transmission_gate$16_1.out.t13 VSS 2.05525f
C10870 programmable_folded_cascode_0.programmable_pfet_1.transmission_gate$16_1.out.t10 VSS 2.05525f
C10871 programmable_folded_cascode_0.programmable_pfet_1.transmission_gate$16_1.out.t15 VSS 1.58362f
C10872 programmable_folded_cascode_0.programmable_pfet_1.transmission_gate$16_1.out.n0 VSS 0.61404f
C10873 programmable_folded_cascode_0.programmable_pfet_1.transmission_gate$16_1.out.t20 VSS 2.00286f
C10874 programmable_folded_cascode_0.programmable_pfet_1.transmission_gate$16_1.out.t14 VSS 2.0554f
C10875 programmable_folded_cascode_0.programmable_pfet_1.transmission_gate$16_1.out.t21 VSS 2.0554f
C10876 programmable_folded_cascode_0.programmable_pfet_1.transmission_gate$16_1.out.t22 VSS 2.05525f
C10877 programmable_folded_cascode_0.programmable_pfet_1.transmission_gate$16_1.out.t18 VSS 2.05525f
C10878 programmable_folded_cascode_0.programmable_pfet_1.transmission_gate$16_1.out.t7 VSS 2.05525f
C10879 programmable_folded_cascode_0.programmable_pfet_1.transmission_gate$16_1.out.t8 VSS 2.05525f
C10880 programmable_folded_cascode_0.programmable_pfet_1.transmission_gate$16_1.out.t3 VSS 2.05525f
C10881 programmable_folded_cascode_0.programmable_pfet_1.transmission_gate$16_1.out.t19 VSS 2.05525f
C10882 programmable_folded_cascode_0.programmable_pfet_1.transmission_gate$16_1.out.t5 VSS 1.56791f
C10883 programmable_folded_cascode_0.programmable_pfet_1.transmission_gate$16_1.out.n1 VSS 0.58906f
C10884 programmable_folded_cascode_0.programmable_pfet_1.transmission_gate$16_1.out.n2 VSS 0.06193f
.ends
